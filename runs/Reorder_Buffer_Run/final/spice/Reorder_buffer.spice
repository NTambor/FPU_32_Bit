* NGSPICE file created from Reorder_buffer.ext - technology: sky130A

* Black-box entry subcircuit for sky130_fd_sc_hd__fill_1 abstract view
.subckt sky130_fd_sc_hd__fill_1 VGND VNB VPB VPWR
.ends

* Black-box entry subcircuit for sky130_fd_sc_hd__a211o_1 abstract view
.subckt sky130_fd_sc_hd__a211o_1 A1 A2 B1 C1 VGND VNB VPB VPWR X
.ends

* Black-box entry subcircuit for sky130_fd_sc_hd__decap_3 abstract view
.subckt sky130_fd_sc_hd__decap_3 VGND VNB VPB VPWR
.ends

* Black-box entry subcircuit for sky130_ef_sc_hd__decap_12 abstract view
.subckt sky130_ef_sc_hd__decap_12 VPWR VGND VPB VNB
.ends

* Black-box entry subcircuit for sky130_fd_sc_hd__decap_4 abstract view
.subckt sky130_fd_sc_hd__decap_4 VGND VNB VPB VPWR
.ends

* Black-box entry subcircuit for sky130_fd_sc_hd__a22o_1 abstract view
.subckt sky130_fd_sc_hd__a22o_1 A1 A2 B1 B2 VGND VNB VPB VPWR X
.ends

* Black-box entry subcircuit for sky130_fd_sc_hd__o21a_1 abstract view
.subckt sky130_fd_sc_hd__o21a_1 A1 A2 B1 VGND VNB VPB VPWR X
.ends

* Black-box entry subcircuit for sky130_fd_sc_hd__dfxtp_1 abstract view
.subckt sky130_fd_sc_hd__dfxtp_1 CLK D VGND VNB VPB VPWR Q
.ends

* Black-box entry subcircuit for sky130_fd_sc_hd__dlygate4sd3_1 abstract view
.subckt sky130_fd_sc_hd__dlygate4sd3_1 A VGND VNB VPB VPWR X
.ends

* Black-box entry subcircuit for sky130_fd_sc_hd__tapvpwrvgnd_1 abstract view
.subckt sky130_fd_sc_hd__tapvpwrvgnd_1 VGND VPWR
.ends

* Black-box entry subcircuit for sky130_fd_sc_hd__decap_8 abstract view
.subckt sky130_fd_sc_hd__decap_8 VGND VNB VPB VPWR
.ends

* Black-box entry subcircuit for sky130_fd_sc_hd__decap_6 abstract view
.subckt sky130_fd_sc_hd__decap_6 VGND VNB VPB VPWR
.ends

* Black-box entry subcircuit for sky130_fd_sc_hd__fill_2 abstract view
.subckt sky130_fd_sc_hd__fill_2 VGND VNB VPB VPWR
.ends

* Black-box entry subcircuit for sky130_fd_sc_hd__a221o_1 abstract view
.subckt sky130_fd_sc_hd__a221o_1 A1 A2 B1 B2 C1 VGND VNB VPB VPWR X
.ends

* Black-box entry subcircuit for sky130_fd_sc_hd__mux2_1 abstract view
.subckt sky130_fd_sc_hd__mux2_1 A0 A1 S VGND VNB VPB VPWR X
.ends

* Black-box entry subcircuit for sky130_fd_sc_hd__a2bb2o_1 abstract view
.subckt sky130_fd_sc_hd__a2bb2o_1 A1_N A2_N B1 B2 VGND VNB VPB VPWR X
.ends

* Black-box entry subcircuit for sky130_fd_sc_hd__and3_1 abstract view
.subckt sky130_fd_sc_hd__and3_1 A B C VGND VNB VPB VPWR X
.ends

* Black-box entry subcircuit for sky130_fd_sc_hd__and2_1 abstract view
.subckt sky130_fd_sc_hd__and2_1 A B VGND VNB VPB VPWR X
.ends

* Black-box entry subcircuit for sky130_fd_sc_hd__nand2_1 abstract view
.subckt sky130_fd_sc_hd__nand2_1 A B VGND VNB VPB VPWR Y
.ends

* Black-box entry subcircuit for sky130_fd_sc_hd__dlymetal6s2s_1 abstract view
.subckt sky130_fd_sc_hd__dlymetal6s2s_1 A VGND VNB VPB VPWR X
.ends

* Black-box entry subcircuit for sky130_fd_sc_hd__buf_1 abstract view
.subckt sky130_fd_sc_hd__buf_1 A VGND VNB VPB VPWR X
.ends

* Black-box entry subcircuit for sky130_fd_sc_hd__buf_2 abstract view
.subckt sky130_fd_sc_hd__buf_2 A VGND VNB VPB VPWR X
.ends

* Black-box entry subcircuit for sky130_fd_sc_hd__clkbuf_2 abstract view
.subckt sky130_fd_sc_hd__clkbuf_2 A VGND VNB VPB VPWR X
.ends

* Black-box entry subcircuit for sky130_fd_sc_hd__and3_2 abstract view
.subckt sky130_fd_sc_hd__and3_2 A B C VGND VNB VPB VPWR X
.ends

* Black-box entry subcircuit for sky130_fd_sc_hd__o22a_1 abstract view
.subckt sky130_fd_sc_hd__o22a_1 A1 A2 B1 B2 VGND VNB VPB VPWR X
.ends

* Black-box entry subcircuit for sky130_fd_sc_hd__buf_4 abstract view
.subckt sky130_fd_sc_hd__buf_4 A VGND VNB VPB VPWR X
.ends

* Black-box entry subcircuit for sky130_fd_sc_hd__nor2_1 abstract view
.subckt sky130_fd_sc_hd__nor2_1 A B VGND VNB VPB VPWR Y
.ends

* Black-box entry subcircuit for sky130_fd_sc_hd__or2_4 abstract view
.subckt sky130_fd_sc_hd__or2_4 A B VGND VNB VPB VPWR X
.ends

* Black-box entry subcircuit for sky130_fd_sc_hd__nand3b_1 abstract view
.subckt sky130_fd_sc_hd__nand3b_1 A_N B C VGND VNB VPB VPWR Y
.ends

* Black-box entry subcircuit for sky130_fd_sc_hd__diode_2 abstract view
.subckt sky130_fd_sc_hd__diode_2 DIODE VGND VNB VPB VPWR
.ends

* Black-box entry subcircuit for sky130_fd_sc_hd__o211a_1 abstract view
.subckt sky130_fd_sc_hd__o211a_1 A1 A2 B1 C1 VGND VNB VPB VPWR X
.ends

* Black-box entry subcircuit for sky130_fd_sc_hd__clkbuf_4 abstract view
.subckt sky130_fd_sc_hd__clkbuf_4 A VGND VNB VPB VPWR X
.ends

* Black-box entry subcircuit for sky130_fd_sc_hd__clkbuf_16 abstract view
.subckt sky130_fd_sc_hd__clkbuf_16 A VGND VNB VPB VPWR X
.ends

* Black-box entry subcircuit for sky130_fd_sc_hd__and3b_2 abstract view
.subckt sky130_fd_sc_hd__and3b_2 A_N B C VGND VNB VPB VPWR X
.ends

* Black-box entry subcircuit for sky130_fd_sc_hd__or2_1 abstract view
.subckt sky130_fd_sc_hd__or2_1 A B VGND VNB VPB VPWR X
.ends

* Black-box entry subcircuit for sky130_fd_sc_hd__clkbuf_8 abstract view
.subckt sky130_fd_sc_hd__clkbuf_8 A VGND VNB VPB VPWR X
.ends

* Black-box entry subcircuit for sky130_fd_sc_hd__nor4_2 abstract view
.subckt sky130_fd_sc_hd__nor4_2 A B C D VGND VNB VPB VPWR Y
.ends

* Black-box entry subcircuit for sky130_fd_sc_hd__nor2_2 abstract view
.subckt sky130_fd_sc_hd__nor2_2 A B VGND VNB VPB VPWR Y
.ends

* Black-box entry subcircuit for sky130_fd_sc_hd__o21ai_4 abstract view
.subckt sky130_fd_sc_hd__o21ai_4 A1 A2 B1 VGND VNB VPB VPWR Y
.ends

* Black-box entry subcircuit for sky130_fd_sc_hd__and2_2 abstract view
.subckt sky130_fd_sc_hd__and2_2 A B VGND VNB VPB VPWR X
.ends

* Black-box entry subcircuit for sky130_fd_sc_hd__xnor2_1 abstract view
.subckt sky130_fd_sc_hd__xnor2_1 A B VGND VNB VPB VPWR Y
.ends

* Black-box entry subcircuit for sky130_fd_sc_hd__or3_4 abstract view
.subckt sky130_fd_sc_hd__or3_4 A B C VGND VNB VPB VPWR X
.ends

* Black-box entry subcircuit for sky130_fd_sc_hd__a311o_1 abstract view
.subckt sky130_fd_sc_hd__a311o_1 A1 A2 A3 B1 C1 VGND VNB VPB VPWR X
.ends

* Black-box entry subcircuit for sky130_fd_sc_hd__or3_2 abstract view
.subckt sky130_fd_sc_hd__or3_2 A B C VGND VNB VPB VPWR X
.ends

* Black-box entry subcircuit for sky130_fd_sc_hd__nand2b_2 abstract view
.subckt sky130_fd_sc_hd__nand2b_2 A_N B VGND VNB VPB VPWR Y
.ends

* Black-box entry subcircuit for sky130_fd_sc_hd__and4b_1 abstract view
.subckt sky130_fd_sc_hd__and4b_1 A_N B C D VGND VNB VPB VPWR X
.ends

* Black-box entry subcircuit for sky130_fd_sc_hd__or3b_1 abstract view
.subckt sky130_fd_sc_hd__or3b_1 A B C_N VGND VNB VPB VPWR X
.ends

* Black-box entry subcircuit for sky130_fd_sc_hd__and2b_2 abstract view
.subckt sky130_fd_sc_hd__and2b_2 A_N B VGND VNB VPB VPWR X
.ends

* Black-box entry subcircuit for sky130_fd_sc_hd__inv_2 abstract view
.subckt sky130_fd_sc_hd__inv_2 A VGND VNB VPB VPWR Y
.ends

* Black-box entry subcircuit for sky130_fd_sc_hd__clkinv_4 abstract view
.subckt sky130_fd_sc_hd__clkinv_4 A VGND VNB VPB VPWR Y
.ends

* Black-box entry subcircuit for sky130_fd_sc_hd__and4b_4 abstract view
.subckt sky130_fd_sc_hd__and4b_4 A_N B C D VGND VNB VPB VPWR X
.ends

* Black-box entry subcircuit for sky130_fd_sc_hd__clkinvlp_4 abstract view
.subckt sky130_fd_sc_hd__clkinvlp_4 A VGND VNB VPB VPWR Y
.ends

* Black-box entry subcircuit for sky130_fd_sc_hd__a31o_1 abstract view
.subckt sky130_fd_sc_hd__a31o_1 A1 A2 A3 B1 VGND VNB VPB VPWR X
.ends

* Black-box entry subcircuit for sky130_fd_sc_hd__and2b_1 abstract view
.subckt sky130_fd_sc_hd__and2b_1 A_N B VGND VNB VPB VPWR X
.ends

* Black-box entry subcircuit for sky130_fd_sc_hd__o31a_1 abstract view
.subckt sky130_fd_sc_hd__o31a_1 A1 A2 A3 B1 VGND VNB VPB VPWR X
.ends

* Black-box entry subcircuit for sky130_fd_sc_hd__a21oi_1 abstract view
.subckt sky130_fd_sc_hd__a21oi_1 A1 A2 B1 VGND VNB VPB VPWR Y
.ends

* Black-box entry subcircuit for sky130_fd_sc_hd__clkinv_8 abstract view
.subckt sky130_fd_sc_hd__clkinv_8 A VGND VNB VPB VPWR Y
.ends

* Black-box entry subcircuit for sky130_fd_sc_hd__and2_4 abstract view
.subckt sky130_fd_sc_hd__and2_4 A B VGND VNB VPB VPWR X
.ends

* Black-box entry subcircuit for sky130_fd_sc_hd__dfxtp_2 abstract view
.subckt sky130_fd_sc_hd__dfxtp_2 CLK D VGND VNB VPB VPWR Q
.ends

* Black-box entry subcircuit for sky130_fd_sc_hd__bufinv_16 abstract view
.subckt sky130_fd_sc_hd__bufinv_16 A VGND VNB VPB VPWR Y
.ends

* Black-box entry subcircuit for sky130_fd_sc_hd__inv_6 abstract view
.subckt sky130_fd_sc_hd__inv_6 A VGND VNB VPB VPWR Y
.ends

* Black-box entry subcircuit for sky130_fd_sc_hd__or3_1 abstract view
.subckt sky130_fd_sc_hd__or3_1 A B C VGND VNB VPB VPWR X
.ends

* Black-box entry subcircuit for sky130_fd_sc_hd__o32a_1 abstract view
.subckt sky130_fd_sc_hd__o32a_1 A1 A2 A3 B1 B2 VGND VNB VPB VPWR X
.ends

* Black-box entry subcircuit for sky130_fd_sc_hd__nand4b_1 abstract view
.subckt sky130_fd_sc_hd__nand4b_1 A_N B C D VGND VNB VPB VPWR Y
.ends

* Black-box entry subcircuit for sky130_fd_sc_hd__inv_8 abstract view
.subckt sky130_fd_sc_hd__inv_8 A VGND VNB VPB VPWR Y
.ends

* Black-box entry subcircuit for sky130_fd_sc_hd__and4b_2 abstract view
.subckt sky130_fd_sc_hd__and4b_2 A_N B C D VGND VNB VPB VPWR X
.ends

* Black-box entry subcircuit for sky130_fd_sc_hd__o221a_4 abstract view
.subckt sky130_fd_sc_hd__o221a_4 A1 A2 B1 B2 C1 VGND VNB VPB VPWR X
.ends

* Black-box entry subcircuit for sky130_fd_sc_hd__nand2b_1 abstract view
.subckt sky130_fd_sc_hd__nand2b_1 A_N B VGND VNB VPB VPWR Y
.ends

* Black-box entry subcircuit for sky130_fd_sc_hd__or4bb_1 abstract view
.subckt sky130_fd_sc_hd__or4bb_1 A B C_N D_N VGND VNB VPB VPWR X
.ends

* Black-box entry subcircuit for sky130_fd_sc_hd__o21ai_1 abstract view
.subckt sky130_fd_sc_hd__o21ai_1 A1 A2 B1 VGND VNB VPB VPWR Y
.ends

* Black-box entry subcircuit for sky130_fd_sc_hd__clkinv_2 abstract view
.subckt sky130_fd_sc_hd__clkinv_2 A VGND VNB VPB VPWR Y
.ends

* Black-box entry subcircuit for sky130_fd_sc_hd__nor2_4 abstract view
.subckt sky130_fd_sc_hd__nor2_4 A B VGND VNB VPB VPWR Y
.ends

* Black-box entry subcircuit for sky130_fd_sc_hd__clkbuf_1 abstract view
.subckt sky130_fd_sc_hd__clkbuf_1 A VGND VNB VPB VPWR X
.ends

* Black-box entry subcircuit for sky130_fd_sc_hd__a21o_1 abstract view
.subckt sky130_fd_sc_hd__a21o_1 A1 A2 B1 VGND VNB VPB VPWR X
.ends

* Black-box entry subcircuit for sky130_fd_sc_hd__o311a_1 abstract view
.subckt sky130_fd_sc_hd__o311a_1 A1 A2 A3 B1 C1 VGND VNB VPB VPWR X
.ends

* Black-box entry subcircuit for sky130_fd_sc_hd__a32o_4 abstract view
.subckt sky130_fd_sc_hd__a32o_4 A1 A2 A3 B1 B2 VGND VNB VPB VPWR X
.ends

* Black-box entry subcircuit for sky130_fd_sc_hd__o211ai_1 abstract view
.subckt sky130_fd_sc_hd__o211ai_1 A1 A2 B1 C1 VGND VNB VPB VPWR Y
.ends

* Black-box entry subcircuit for sky130_fd_sc_hd__and4bb_1 abstract view
.subckt sky130_fd_sc_hd__and4bb_1 A_N B_N C D VGND VNB VPB VPWR X
.ends

* Black-box entry subcircuit for sky130_fd_sc_hd__and3b_4 abstract view
.subckt sky130_fd_sc_hd__and3b_4 A_N B C VGND VNB VPB VPWR X
.ends

* Black-box entry subcircuit for sky130_fd_sc_hd__and3_4 abstract view
.subckt sky130_fd_sc_hd__and3_4 A B C VGND VNB VPB VPWR X
.ends

* Black-box entry subcircuit for sky130_fd_sc_hd__and4_4 abstract view
.subckt sky130_fd_sc_hd__and4_4 A B C D VGND VNB VPB VPWR X
.ends

* Black-box entry subcircuit for sky130_fd_sc_hd__and3b_1 abstract view
.subckt sky130_fd_sc_hd__and3b_1 A_N B C VGND VNB VPB VPWR X
.ends

* Black-box entry subcircuit for sky130_fd_sc_hd__nand2_2 abstract view
.subckt sky130_fd_sc_hd__nand2_2 A B VGND VNB VPB VPWR Y
.ends

* Black-box entry subcircuit for sky130_fd_sc_hd__and4_1 abstract view
.subckt sky130_fd_sc_hd__and4_1 A B C D VGND VNB VPB VPWR X
.ends

* Black-box entry subcircuit for sky130_fd_sc_hd__a311oi_2 abstract view
.subckt sky130_fd_sc_hd__a311oi_2 A1 A2 A3 B1 C1 VGND VNB VPB VPWR Y
.ends

* Black-box entry subcircuit for sky130_fd_sc_hd__nor3b_1 abstract view
.subckt sky130_fd_sc_hd__nor3b_1 A B C_N VGND VNB VPB VPWR Y
.ends

* Black-box entry subcircuit for sky130_fd_sc_hd__a21boi_1 abstract view
.subckt sky130_fd_sc_hd__a21boi_1 A1 A2 B1_N VGND VNB VPB VPWR Y
.ends

* Black-box entry subcircuit for sky130_fd_sc_hd__mux4_1 abstract view
.subckt sky130_fd_sc_hd__mux4_1 A0 A1 A2 A3 S0 S1 VGND VNB VPB VPWR X
.ends

* Black-box entry subcircuit for sky130_fd_sc_hd__or2_2 abstract view
.subckt sky130_fd_sc_hd__or2_2 A B VGND VNB VPB VPWR X
.ends

* Black-box entry subcircuit for sky130_fd_sc_hd__o21a_2 abstract view
.subckt sky130_fd_sc_hd__o21a_2 A1 A2 B1 VGND VNB VPB VPWR X
.ends

* Black-box entry subcircuit for sky130_fd_sc_hd__or4b_2 abstract view
.subckt sky130_fd_sc_hd__or4b_2 A B C D_N VGND VNB VPB VPWR X
.ends

* Black-box entry subcircuit for sky130_fd_sc_hd__a21oi_2 abstract view
.subckt sky130_fd_sc_hd__a21oi_2 A1 A2 B1 VGND VNB VPB VPWR Y
.ends

* Black-box entry subcircuit for sky130_fd_sc_hd__or3b_2 abstract view
.subckt sky130_fd_sc_hd__or3b_2 A B C_N VGND VNB VPB VPWR X
.ends

* Black-box entry subcircuit for sky130_fd_sc_hd__or4b_1 abstract view
.subckt sky130_fd_sc_hd__or4b_1 A B C D_N VGND VNB VPB VPWR X
.ends

* Black-box entry subcircuit for sky130_fd_sc_hd__xor2_1 abstract view
.subckt sky130_fd_sc_hd__xor2_1 A B VGND VNB VPB VPWR X
.ends

* Black-box entry subcircuit for sky130_fd_sc_hd__nand3_1 abstract view
.subckt sky130_fd_sc_hd__nand3_1 A B C VGND VNB VPB VPWR Y
.ends

* Black-box entry subcircuit for sky130_fd_sc_hd__o2bb2a_1 abstract view
.subckt sky130_fd_sc_hd__o2bb2a_1 A1_N A2_N B1 B2 VGND VNB VPB VPWR X
.ends

* Black-box entry subcircuit for sky130_fd_sc_hd__a31o_2 abstract view
.subckt sky130_fd_sc_hd__a31o_2 A1 A2 A3 B1 VGND VNB VPB VPWR X
.ends

.subckt Reorder_buffer VGND VPWR clk control[0] control[1] data_location[0] data_location[1]
+ data_location[2] data_location[3] done enable_write[0] enable_write[1] enable_write[2]
+ out[0] out[10] out[11] out[12] out[13] out[14] out[15] out[16] out[17] out[18] out[19]
+ out[1] out[20] out[21] out[22] out[23] out[24] out[25] out[26] out[27] out[28] out[29]
+ out[2] out[30] out[31] out[3] out[4] out[5] out[6] out[7] out[8] out[9] reset success
+ value0[0] value0[10] value0[11] value0[12] value0[13] value0[14] value0[15] value0[16]
+ value0[17] value0[18] value0[19] value0[1] value0[20] value0[21] value0[22] value0[23]
+ value0[24] value0[25] value0[26] value0[27] value0[28] value0[29] value0[2] value0[30]
+ value0[31] value0[3] value0[4] value0[5] value0[6] value0[7] value0[8] value0[9]
+ value1[0] value1[10] value1[11] value1[12] value1[13] value1[14] value1[15] value1[16]
+ value1[17] value1[18] value1[19] value1[1] value1[20] value1[21] value1[22] value1[23]
+ value1[24] value1[25] value1[26] value1[27] value1[28] value1[29] value1[2] value1[30]
+ value1[31] value1[3] value1[4] value1[5] value1[6] value1[7] value1[8] value1[9]
+ value2[0] value2[10] value2[11] value2[12] value2[13] value2[14] value2[15] value2[16]
+ value2[17] value2[18] value2[19] value2[1] value2[20] value2[21] value2[22] value2[23]
+ value2[24] value2[25] value2[26] value2[27] value2[28] value2[29] value2[2] value2[30]
+ value2[31] value2[3] value2[4] value2[5] value2[6] value2[7] value2[8] value2[9]
+ value[0] value[1] value[2] value[3] write_location0[0] write_location0[1] write_location0[2]
+ write_location0[3] write_location1[0] write_location1[1] write_location1[2] write_location1[3]
+ write_location2[0] write_location2[1] write_location2[2] write_location2[3]
XFILLER_79_391 VGND VGND VPWR VPWR sky130_fd_sc_hd__fill_1
X_3155_ net728 net186 _1279_ net190 VGND VGND VPWR VPWR _1280_ sky130_fd_sc_hd__a211o_1
XFILLER_39_277 VGND VGND VPWR VPWR sky130_fd_sc_hd__decap_3
XFILLER_82_545 VPWR VGND VPWR VGND sky130_ef_sc_hd__decap_12
X_3086_ net718 net186 _1233_ net190 VGND VGND VPWR VPWR _1234_ sky130_fd_sc_hd__a211o_1
XFILLER_35_483 VGND VGND VPWR VPWR sky130_fd_sc_hd__decap_4
XFILLER_22_122 VPWR VGND VPWR VGND sky130_ef_sc_hd__decap_12
XFILLER_52_18 VGND VGND VPWR VPWR sky130_fd_sc_hd__decap_4
X_3988_ net351 _1901_ _1905_ net355 VGND VGND VPWR VPWR _1908_ sky130_fd_sc_hd__a22o_1
XFILLER_50_475 VGND VGND VPWR VPWR sky130_fd_sc_hd__fill_1
X_2939_ net1135 net201 _1126_ VGND VGND VPWR VPWR _0096_ sky130_fd_sc_hd__o21a_1
X_4609_ clknet_leaf_8_clk _0140_ VGND VGND VPWR VPWR array\[14\]\[6\] sky130_fd_sc_hd__dfxtp_1
Xhold362 array\[15\]\[30\] VGND VGND VPWR VPWR net1128 sky130_fd_sc_hd__dlygate4sd3_1
XFILLER_89_111 VGND VGND VPWR VPWR sky130_fd_sc_hd__fill_1
Xhold340 array\[11\]\[18\] VGND VGND VPWR VPWR net1106 sky130_fd_sc_hd__dlygate4sd3_1
Xhold351 array\[2\]\[3\] VGND VGND VPWR VPWR net1117 sky130_fd_sc_hd__dlygate4sd3_1
Xhold373 array\[15\]\[1\] VGND VGND VPWR VPWR net1139 sky130_fd_sc_hd__dlygate4sd3_1
Xhold395 array\[0\]\[10\] VGND VGND VPWR VPWR net1161 sky130_fd_sc_hd__dlygate4sd3_1
Xhold384 array\[2\]\[22\] VGND VGND VPWR VPWR net1150 sky130_fd_sc_hd__dlygate4sd3_1
XFILLER_45_225 VGND VGND VPWR VPWR sky130_fd_sc_hd__fill_1
XFILLER_93_69 VPWR VGND VPWR VGND sky130_ef_sc_hd__decap_12
XTAP_TAPCELL_ROW_56_765 VGND VPWR sky130_fd_sc_hd__tapvpwrvgnd_1
XTAP_TAPCELL_ROW_28_489 VGND VPWR sky130_fd_sc_hd__tapvpwrvgnd_1
XFILLER_9_104 VGND VGND VPWR VPWR sky130_fd_sc_hd__decap_8
XTAP_TAPCELL_ROW_11_312 VGND VPWR sky130_fd_sc_hd__tapvpwrvgnd_1
XFILLER_9_137 VGND VGND VPWR VPWR sky130_fd_sc_hd__decap_6
XFILLER_5_376 VGND VGND VPWR VPWR sky130_fd_sc_hd__fill_1
XFILLER_68_306 VGND VGND VPWR VPWR sky130_fd_sc_hd__fill_2
XFILLER_3_45 VGND VGND VPWR VPWR sky130_fd_sc_hd__fill_1
XFILLER_76_361 VGND VGND VPWR VPWR sky130_fd_sc_hd__decap_3
XFILLER_67_92 VGND VGND VPWR VPWR sky130_fd_sc_hd__fill_1
XFILLER_36_247 VGND VGND VPWR VPWR sky130_fd_sc_hd__decap_4
X_3911_ net416 _1832_ _1836_ net353 net214 VGND VGND VPWR VPWR _1838_ sky130_fd_sc_hd__a221o_1
X_4891_ clknet_leaf_55_clk _0422_ VGND VGND VPWR VPWR array\[6\]\[2\] sky130_fd_sc_hd__dfxtp_1
X_3842_ net355 _1769_ _1773_ net415 net214 VGND VGND VPWR VPWR _1775_ sky130_fd_sc_hd__a221o_1
XFILLER_32_497 VGND VGND VPWR VPWR sky130_fd_sc_hd__fill_2
X_3773_ net355 _1705_ _1709_ net351 VGND VGND VPWR VPWR _1712_ sky130_fd_sc_hd__a22o_1
X_2724_ net1063 _0980_ net293 VGND VGND VPWR VPWR _0027_ sky130_fd_sc_hd__mux2_1
X_2655_ _0630_ _0856_ _0860_ _0931_ VGND VGND VPWR VPWR _0933_ sky130_fd_sc_hd__a2bb2o_1
X_2586_ net700 net401 net508 VGND VGND VPWR VPWR _0887_ sky130_fd_sc_hd__and3_1
X_4325_ net1250 net223 net337 net722 _2164_ VGND VGND VPWR VPWR _0448_ sky130_fd_sc_hd__a221o_1
XFILLER_47_18 VGND VGND VPWR VPWR sky130_fd_sc_hd__decap_6
X_4256_ net572 net428 net331 net642 net221 VGND VGND VPWR VPWR _2121_ sky130_fd_sc_hd__a221o_1
XFILLER_74_309 VGND VGND VPWR VPWR sky130_fd_sc_hd__decap_6
X_4187_ net755 net234 VGND VGND VPWR VPWR _2074_ sky130_fd_sc_hd__and2_1
X_3207_ net837 _1317_ net157 VGND VGND VPWR VPWR _0173_ sky130_fd_sc_hd__mux2_1
X_3138_ net1272 net162 _1268_ VGND VGND VPWR VPWR _0153_ sky130_fd_sc_hd__o21a_1
XFILLER_70_526 VGND VGND VPWR VPWR sky130_fd_sc_hd__decap_6
X_3069_ net267 _1218_ VGND VGND VPWR VPWR _1219_ sky130_fd_sc_hd__nand2_1
XFILLER_63_28 VGND VGND VPWR VPWR sky130_fd_sc_hd__fill_2
XTAP_TAPCELL_ROW_81_1012 VGND VPWR sky130_fd_sc_hd__tapvpwrvgnd_1
XFILLER_42_239 VGND VGND VPWR VPWR sky130_fd_sc_hd__fill_2
XTAP_TAPCELL_ROW_53_735 VGND VPWR sky130_fd_sc_hd__tapvpwrvgnd_1
XTAP_TAPCELL_ROW_25_459 VGND VPWR sky130_fd_sc_hd__tapvpwrvgnd_1
XFILLER_23_486 VGND VGND VPWR VPWR sky130_fd_sc_hd__decap_4
XFILLER_6_118 VPWR VGND VPWR VGND sky130_ef_sc_hd__decap_12
Xhold170 net137 VGND VGND VPWR VPWR net936 sky130_fd_sc_hd__dlygate4sd3_1
Xhold181 array\[2\]\[17\] VGND VGND VPWR VPWR net947 sky130_fd_sc_hd__dlygate4sd3_1
Xhold192 array\[3\]\[25\] VGND VGND VPWR VPWR net958 sky130_fd_sc_hd__dlygate4sd3_1
Xfanout650 net60 VGND VGND VPWR VPWR net650 sky130_fd_sc_hd__dlymetal6s2s_1
Xfanout694 net41 VGND VGND VPWR VPWR net694 sky130_fd_sc_hd__buf_1
Xfanout683 net46 VGND VGND VPWR VPWR net683 sky130_fd_sc_hd__buf_2
Xfanout661 net57 VGND VGND VPWR VPWR net661 sky130_fd_sc_hd__buf_2
Xfanout672 net52 VGND VGND VPWR VPWR net672 sky130_fd_sc_hd__clkbuf_2
XTAP_TAPCELL_ROW_69_890 VGND VPWR sky130_fd_sc_hd__tapvpwrvgnd_1
XFILLER_58_372 VGND VGND VPWR VPWR sky130_fd_sc_hd__decap_8
XFILLER_37_84 VGND VGND VPWR VPWR sky130_fd_sc_hd__fill_1
XFILLER_73_386 VGND VGND VPWR VPWR sky130_fd_sc_hd__fill_1
XFILLER_14_442 VGND VGND VPWR VPWR sky130_fd_sc_hd__fill_2
XFILLER_14_475 VGND VGND VPWR VPWR sky130_fd_sc_hd__fill_1
X_2440_ _0586_ _0627_ _0780_ VGND VGND VPWR VPWR _0782_ sky130_fd_sc_hd__and3_2
XFILLER_52_6 VPWR VGND VPWR VGND sky130_ef_sc_hd__decap_12
X_2371_ net1296 net208 _0735_ VGND VGND VPWR VPWR _0499_ sky130_fd_sc_hd__o21a_1
X_4110_ array\[13\]\[30\] net555 net540 array\[15\]\[30\] _2018_ VGND VGND VPWR VPWR
+ _2019_ sky130_fd_sc_hd__a221o_1
XFILLER_56_309 VGND VGND VPWR VPWR sky130_fd_sc_hd__decap_4
X_4041_ array\[10\]\[24\] net470 net453 array\[8\]\[24\] VGND VGND VPWR VPWR _1956_
+ sky130_fd_sc_hd__a22o_1
XFILLER_32_250 VGND VGND VPWR VPWR sky130_fd_sc_hd__fill_2
XTAP_TAPCELL_ROW_50_705 VGND VPWR sky130_fd_sc_hd__tapvpwrvgnd_1
X_4874_ clknet_leaf_23_clk _0405_ VGND VGND VPWR VPWR array\[7\]\[17\] sky130_fd_sc_hd__dfxtp_1
XTAP_TAPCELL_ROW_22_429 VGND VPWR sky130_fd_sc_hd__tapvpwrvgnd_1
X_3825_ array\[9\]\[5\] net556 net540 array\[11\]\[5\] _1758_ VGND VGND VPWR VPWR
+ _1759_ sky130_fd_sc_hd__a221o_1
XFILLER_20_434 VGND VGND VPWR VPWR sky130_fd_sc_hd__decap_8
X_3756_ net719 net349 net421 VGND VGND VPWR VPWR _1698_ sky130_fd_sc_hd__and3_1
X_2707_ net683 net611 net394 VGND VGND VPWR VPWR _0969_ sky130_fd_sc_hd__mux2_1
X_3687_ net707 net350 net422 VGND VGND VPWR VPWR _1653_ sky130_fd_sc_hd__and3_1
X_2638_ net583 net512 net398 net659 VGND VGND VPWR VPWR _0921_ sky130_fd_sc_hd__a22o_1
X_2569_ net571 net510 net396 net641 net301 VGND VGND VPWR VPWR _0876_ sky130_fd_sc_hd__a221o_1
X_4308_ net734 net335 VGND VGND VPWR VPWR _2154_ sky130_fd_sc_hd__and2_1
X_4239_ net1143 net226 _2107_ _2108_ VGND VGND VPWR VPWR _0418_ sky130_fd_sc_hd__o22a_1
XFILLER_28_545 VPWR VGND VPWR VGND sky130_ef_sc_hd__decap_12
XFILLER_55_331 VGND VGND VPWR VPWR sky130_fd_sc_hd__decap_4
XTAP_TAPCELL_ROW_66_860 VGND VPWR sky130_fd_sc_hd__tapvpwrvgnd_1
XTAP_TAPCELL_ROW_38_584 VGND VPWR sky130_fd_sc_hd__tapvpwrvgnd_1
XFILLER_90_15 VPWR VGND VPWR VGND sky130_ef_sc_hd__decap_12
XFILLER_11_445 VGND VGND VPWR VPWR sky130_fd_sc_hd__decap_3
XFILLER_23_53 VGND VGND VPWR VPWR sky130_fd_sc_hd__decap_3
XFILLER_7_449 VPWR VGND VPWR VGND sky130_ef_sc_hd__decap_12
XFILLER_2_165 VGND VGND VPWR VPWR sky130_fd_sc_hd__fill_1
Xfanout491 _1221_ VGND VGND VPWR VPWR net491 sky130_fd_sc_hd__buf_4
XFILLER_48_83 VGND VGND VPWR VPWR sky130_fd_sc_hd__fill_1
Xfanout480 _1435_ VGND VGND VPWR VPWR net480 sky130_fd_sc_hd__buf_2
XFILLER_0_57 VGND VGND VPWR VPWR sky130_fd_sc_hd__fill_2
XFILLER_46_397 VGND VGND VPWR VPWR sky130_fd_sc_hd__decap_3
XFILLER_9_55 VGND VGND VPWR VPWR sky130_fd_sc_hd__fill_1
X_3610_ net560 head\[0\] VGND VGND VPWR VPWR _1594_ sky130_fd_sc_hd__nor2_1
X_4590_ clknet_leaf_51_clk _0121_ VGND VGND VPWR VPWR array\[15\]\[19\] sky130_fd_sc_hd__dfxtp_1
X_3541_ net611 net474 net361 net683 net253 VGND VGND VPWR VPWR _1547_ sky130_fd_sc_hd__a221o_1
X_3472_ net939 net262 _1498_ VGND VGND VPWR VPWR _0257_ sky130_fd_sc_hd__o21a_1
XFILLER_88_209 VGND VGND VPWR VPWR sky130_fd_sc_hd__fill_2
X_2423_ net583 net659 net519 VGND VGND VPWR VPWR _0770_ sky130_fd_sc_hd__mux2_1
X_2354_ net569 net639 net518 VGND VGND VPWR VPWR _0724_ sky130_fd_sc_hd__mux2_1
XFILLER_84_437 VGND VGND VPWR VPWR sky130_fd_sc_hd__decap_3
X_2285_ net684 net612 net523 VGND VGND VPWR VPWR _0675_ sky130_fd_sc_hd__mux2_1
XFILLER_56_106 VGND VGND VPWR VPWR sky130_fd_sc_hd__fill_1
X_4024_ net355 _1935_ _1939_ net435 net213 VGND VGND VPWR VPWR _1941_ sky130_fd_sc_hd__a221o_1
XFILLER_37_397 VGND VGND VPWR VPWR sky130_fd_sc_hd__fill_1
XTAP_TAPCELL_ROW_63_830 VGND VPWR sky130_fd_sc_hd__tapvpwrvgnd_1
XTAP_TAPCELL_ROW_35_554 VGND VPWR sky130_fd_sc_hd__tapvpwrvgnd_1
X_4857_ clknet_leaf_56_clk _0388_ VGND VGND VPWR VPWR array\[7\]\[0\] sky130_fd_sc_hd__dfxtp_1
XFILLER_60_18 VGND VGND VPWR VPWR sky130_fd_sc_hd__decap_8
X_3808_ net353 _1737_ _1741_ net437 VGND VGND VPWR VPWR _1744_ sky130_fd_sc_hd__a22o_1
XFILLER_60_29 VPWR VGND VPWR VGND sky130_ef_sc_hd__decap_12
X_4788_ clknet_leaf_4_clk _0319_ VGND VGND VPWR VPWR array\[9\]\[6\] sky130_fd_sc_hd__dfxtp_1
XFILLER_4_419 VGND VGND VPWR VPWR sky130_fd_sc_hd__fill_1
X_3739_ net593 net426 net347 net667 net244 VGND VGND VPWR VPWR _1687_ sky130_fd_sc_hd__a221o_1
XFILLER_69_27 VPWR VGND VPWR VGND sky130_ef_sc_hd__decap_12
XFILLER_87_231 VGND VGND VPWR VPWR sky130_fd_sc_hd__fill_1
XFILLER_85_15 VPWR VGND VPWR VGND sky130_ef_sc_hd__decap_12
XTAP_TAPCELL_ROW_7_279 VGND VPWR sky130_fd_sc_hd__tapvpwrvgnd_1
XFILLER_87_297 VGND VGND VPWR VPWR sky130_fd_sc_hd__decap_4
XFILLER_87_275 VGND VGND VPWR VPWR sky130_fd_sc_hd__decap_4
XFILLER_47_106 VGND VGND VPWR VPWR sky130_fd_sc_hd__decap_6
XFILLER_28_342 VGND VGND VPWR VPWR sky130_fd_sc_hd__fill_2
XFILLER_90_418 VGND VGND VPWR VPWR sky130_fd_sc_hd__fill_2
XTAP_TAPCELL_ROW_87_1073 VGND VPWR sky130_fd_sc_hd__tapvpwrvgnd_1
XFILLER_55_183 VGND VGND VPWR VPWR sky130_fd_sc_hd__decap_6
XFILLER_34_41 VGND VGND VPWR VPWR sky130_fd_sc_hd__decap_8
XFILLER_34_85 VGND VGND VPWR VPWR sky130_fd_sc_hd__fill_2
XFILLER_3_441 VGND VGND VPWR VPWR sky130_fd_sc_hd__decap_6
XFILLER_3_485 VPWR VGND VPWR VGND sky130_ef_sc_hd__decap_12
XFILLER_38_117 VGND VGND VPWR VPWR sky130_fd_sc_hd__fill_1
XFILLER_66_448 VGND VGND VPWR VPWR sky130_fd_sc_hd__decap_3
XFILLER_93_289 VGND VGND VPWR VPWR sky130_fd_sc_hd__fill_2
XTAP_TAPCELL_ROW_77_977 VGND VPWR sky130_fd_sc_hd__tapvpwrvgnd_1
X_2972_ net697 net625 net493 VGND VGND VPWR VPWR _1154_ sky130_fd_sc_hd__mux2_1
XTAP_TAPCELL_ROW_60_800 VGND VPWR sky130_fd_sc_hd__tapvpwrvgnd_1
XTAP_TAPCELL_ROW_32_524 VGND VPWR sky130_fd_sc_hd__tapvpwrvgnd_1
X_4711_ clknet_leaf_18_clk _0242_ VGND VGND VPWR VPWR array\[11\]\[12\] sky130_fd_sc_hd__dfxtp_1
X_4642_ clknet_leaf_60_clk _0173_ VGND VGND VPWR VPWR array\[13\]\[7\] sky130_fd_sc_hd__dfxtp_1
X_4573_ clknet_leaf_34_clk _0104_ VGND VGND VPWR VPWR array\[15\]\[2\] sky130_fd_sc_hd__dfxtp_1
X_3524_ net607 net245 _1535_ net254 VGND VGND VPWR VPWR _1536_ sky130_fd_sc_hd__a211o_1
XFILLER_89_529 VPWR VGND VPWR VGND sky130_ef_sc_hd__decap_12
X_3455_ net595 net477 net363 net669 VGND VGND VPWR VPWR _1487_ sky130_fd_sc_hd__a22o_1
X_2406_ net735 net315 _0758_ net406 net312 VGND VGND VPWR VPWR _0759_ sky130_fd_sc_hd__a221o_1
XFILLER_69_242 VGND VGND VPWR VPWR sky130_fd_sc_hd__decap_4
X_3386_ net654 _1438_ VGND VGND VPWR VPWR _1440_ sky130_fd_sc_hd__or2_4
X_2337_ net103 net104 _0637_ VGND VGND VPWR VPWR _0711_ sky130_fd_sc_hd__nand3b_1
XTAP_TAPCELL_ROW_4_249 VGND VPWR sky130_fd_sc_hd__tapvpwrvgnd_1
X_2268_ net607 net319 _0663_ net410 net327 VGND VGND VPWR VPWR _0664_ sky130_fd_sc_hd__a221o_1
XFILLER_84_289 VPWR VGND VPWR VGND sky130_ef_sc_hd__decap_12
X_4007_ array\[6\]\[21\] net458 net441 array\[4\]\[21\] VGND VGND VPWR VPWR _1925_
+ sky130_fd_sc_hd__a22o_1
XFILLER_55_18 VPWR VGND VPWR VGND sky130_ef_sc_hd__decap_12
XFILLER_65_481 VGND VGND VPWR VPWR sky130_fd_sc_hd__fill_2
X_2199_ net560 head\[0\] VGND VGND VPWR VPWR _0608_ sky130_fd_sc_hd__and2_1
XFILLER_37_183 VGND VGND VPWR VPWR sky130_fd_sc_hd__decap_3
XFILLER_13_529 VPWR VGND VPWR VGND sky130_ef_sc_hd__decap_12
XFILLER_71_39 VPWR VGND VPWR VGND sky130_ef_sc_hd__decap_12
XFILLER_21_540 VGND VGND VPWR VPWR sky130_fd_sc_hd__fill_2
X_4909_ clknet_leaf_6_clk _0440_ VGND VGND VPWR VPWR array\[6\]\[20\] sky130_fd_sc_hd__dfxtp_1
XFILLER_0_433 VGND VGND VPWR VPWR sky130_fd_sc_hd__decap_4
Xhold30 array\[13\]\[20\] VGND VGND VPWR VPWR net796 sky130_fd_sc_hd__dlygate4sd3_1
XFILLER_0_477 VPWR VGND VPWR VGND sky130_ef_sc_hd__decap_12
Xhold41 array\[2\]\[1\] VGND VGND VPWR VPWR net807 sky130_fd_sc_hd__dlygate4sd3_1
Xhold74 net129 VGND VGND VPWR VPWR net840 sky130_fd_sc_hd__dlygate4sd3_1
Xhold52 array\[15\]\[9\] VGND VGND VPWR VPWR net818 sky130_fd_sc_hd__dlygate4sd3_1
Xhold63 array\[8\]\[28\] VGND VGND VPWR VPWR net829 sky130_fd_sc_hd__dlygate4sd3_1
Xhold96 array\[10\]\[8\] VGND VGND VPWR VPWR net862 sky130_fd_sc_hd__dlygate4sd3_1
Xhold85 array\[15\]\[28\] VGND VGND VPWR VPWR net851 sky130_fd_sc_hd__dlygate4sd3_1
XFILLER_90_237 VGND VGND VPWR VPWR sky130_fd_sc_hd__fill_2
XTAP_TAPCELL_ROW_74_947 VGND VPWR sky130_fd_sc_hd__tapvpwrvgnd_1
XFILLER_28_194 VGND VGND VPWR VPWR sky130_fd_sc_hd__fill_2
XFILLER_45_73 VGND VGND VPWR VPWR sky130_fd_sc_hd__fill_1
XFILLER_8_533 VPWR VGND VPWR VGND sky130_ef_sc_hd__decap_12
XFILLER_6_45 VPWR VGND VPWR VGND sky130_ef_sc_hd__decap_12
XANTENNA_5 _0782_ VGND VGND VPWR VPWR sky130_fd_sc_hd__diode_2
X_3240_ net798 _1339_ net159 VGND VGND VPWR VPWR _0184_ sky130_fd_sc_hd__mux2_1
XFILLER_3_293 VPWR VGND VPWR VGND sky130_ef_sc_hd__decap_12
XFILLER_94_510 VPWR VGND VPWR VGND sky130_ef_sc_hd__decap_12
X_3171_ net957 net163 _1290_ VGND VGND VPWR VPWR _0164_ sky130_fd_sc_hd__o21a_1
XFILLER_39_404 VGND VGND VPWR VPWR sky130_fd_sc_hd__decap_3
XFILLER_13_3 VPWR VGND VPWR VGND sky130_ef_sc_hd__decap_12
XTAP_TAPCELL_ROW_1_219 VGND VPWR sky130_fd_sc_hd__tapvpwrvgnd_1
XFILLER_54_418 VGND VGND VPWR VPWR sky130_fd_sc_hd__fill_2
XFILLER_81_237 VGND VGND VPWR VPWR sky130_fd_sc_hd__decap_3
XFILLER_62_462 VPWR VGND VPWR VGND sky130_ef_sc_hd__decap_12
XTAP_TAPCELL_ROW_17_373 VGND VPWR sky130_fd_sc_hd__tapvpwrvgnd_1
XFILLER_34_197 VGND VGND VPWR VPWR sky130_fd_sc_hd__decap_3
X_2955_ tail\[1\] net104 _0626_ VGND VGND VPWR VPWR _1137_ sky130_fd_sc_hd__mux2_1
X_2886_ net759 net628 net498 VGND VGND VPWR VPWR _1091_ sky130_fd_sc_hd__mux2_1
X_4625_ clknet_leaf_60_clk _0156_ VGND VGND VPWR VPWR array\[14\]\[22\] sky130_fd_sc_hd__dfxtp_1
X_4556_ clknet_leaf_23_clk _0087_ VGND VGND VPWR VPWR array\[0\]\[17\] sky130_fd_sc_hd__dfxtp_1
Xhold511 array\[0\]\[19\] VGND VGND VPWR VPWR net1277 sky130_fd_sc_hd__dlygate4sd3_1
Xhold500 array\[1\]\[29\] VGND VGND VPWR VPWR net1266 sky130_fd_sc_hd__dlygate4sd3_1
Xhold522 array\[8\]\[5\] VGND VGND VPWR VPWR net1288 sky130_fd_sc_hd__dlygate4sd3_1
Xhold544 array\[3\]\[7\] VGND VGND VPWR VPWR net1310 sky130_fd_sc_hd__dlygate4sd3_1
Xhold533 array\[11\]\[21\] VGND VGND VPWR VPWR net1299 sky130_fd_sc_hd__dlygate4sd3_1
X_3507_ net1146 net251 _1523_ _1524_ VGND VGND VPWR VPWR _0266_ sky130_fd_sc_hd__o22a_1
X_4487_ clknet_leaf_17_clk _0018_ VGND VGND VPWR VPWR array\[5\]\[12\] sky130_fd_sc_hd__dfxtp_1
Xhold555 ready_check\[0\] VGND VGND VPWR VPWR net1321 sky130_fd_sc_hd__dlygate4sd3_1
XFILLER_89_359 VGND VGND VPWR VPWR sky130_fd_sc_hd__decap_8
X_3438_ net747 net258 _1475_ net266 VGND VGND VPWR VPWR _1476_ sky130_fd_sc_hd__a211o_1
X_3369_ net721 net174 VGND VGND VPWR VPWR _1427_ sky130_fd_sc_hd__and2_1
XFILLER_38_481 VGND VGND VPWR VPWR sky130_fd_sc_hd__decap_8
XTAP_TAPCELL_ROW_84_1043 VGND VPWR sky130_fd_sc_hd__tapvpwrvgnd_1
XFILLER_82_27 VGND VGND VPWR VPWR sky130_fd_sc_hd__fill_1
XTAP_TAPCELL_ROW_71_917 VGND VPWR sky130_fd_sc_hd__tapvpwrvgnd_1
XFILLER_15_54 VGND VGND VPWR VPWR sky130_fd_sc_hd__fill_2
XFILLER_13_337 VGND VGND VPWR VPWR sky130_fd_sc_hd__decap_4
XFILLER_13_326 VGND VGND VPWR VPWR sky130_fd_sc_hd__fill_1
XFILLER_5_503 VGND VGND VPWR VPWR sky130_fd_sc_hd__fill_1
XFILLER_31_42 VGND VGND VPWR VPWR sky130_fd_sc_hd__decap_8
XFILLER_0_230 VGND VGND VPWR VPWR sky130_fd_sc_hd__decap_4
XFILLER_88_392 VPWR VGND VPWR VGND sky130_ef_sc_hd__decap_12
XFILLER_36_418 VGND VGND VPWR VPWR sky130_fd_sc_hd__fill_2
XFILLER_48_289 VGND VGND VPWR VPWR sky130_fd_sc_hd__decap_3
XTAP_TAPCELL_ROW_59_796 VGND VPWR sky130_fd_sc_hd__tapvpwrvgnd_1
XFILLER_56_94 VGND VGND VPWR VPWR sky130_fd_sc_hd__fill_2
XFILLER_71_281 VGND VGND VPWR VPWR sky130_fd_sc_hd__fill_2
XFILLER_72_82 VGND VGND VPWR VPWR sky130_fd_sc_hd__fill_2
XTAP_TAPCELL_ROW_14_343 VGND VPWR sky130_fd_sc_hd__tapvpwrvgnd_1
XFILLER_31_156 VGND VGND VPWR VPWR sky130_fd_sc_hd__decap_3
X_2740_ net659 net583 net394 VGND VGND VPWR VPWR _0991_ sky130_fd_sc_hd__mux2_1
X_2671_ net639 net569 net393 VGND VGND VPWR VPWR _0945_ sky130_fd_sc_hd__mux2_1
X_4410_ clknet_leaf_41_clk _0521_ VGND VGND VPWR VPWR array\[2\]\[31\] sky130_fd_sc_hd__dfxtp_1
X_4341_ head\[3\] net217 _0616_ net562 VGND VGND VPWR VPWR _0380_ sky130_fd_sc_hd__o211a_1
Xfanout309 _0787_ VGND VGND VPWR VPWR net309 sky130_fd_sc_hd__clkbuf_4
X_4272_ net759 net429 net333 net628 VGND VGND VPWR VPWR _2131_ sky130_fd_sc_hd__a22o_1
XFILLER_86_329 VGND VGND VPWR VPWR sky130_fd_sc_hd__fill_1
X_3223_ net689 net373 VGND VGND VPWR VPWR _1328_ sky130_fd_sc_hd__and2_1
X_3154_ net590 net491 net376 net664 VGND VGND VPWR VPWR _1279_ sky130_fd_sc_hd__a22o_1
XFILLER_39_289 VGND VGND VPWR VPWR sky130_fd_sc_hd__fill_1
X_3085_ net578 net491 net376 net648 VGND VGND VPWR VPWR _1233_ sky130_fd_sc_hd__a22o_1
XFILLER_82_557 VGND VGND VPWR VPWR sky130_fd_sc_hd__fill_1
XFILLER_54_248 VGND VGND VPWR VPWR sky130_fd_sc_hd__decap_4
XFILLER_22_134 VGND VGND VPWR VPWR sky130_fd_sc_hd__decap_6
XFILLER_50_421 VGND VGND VPWR VPWR sky130_fd_sc_hd__decap_6
XFILLER_62_281 VGND VGND VPWR VPWR sky130_fd_sc_hd__fill_2
X_3987_ array\[1\]\[19\] net550 net528 array\[3\]\[19\] _1906_ VGND VGND VPWR VPWR
+ _1907_ sky130_fd_sc_hd__a221o_1
X_2938_ net725 net273 _1125_ net386 net270 VGND VGND VPWR VPWR _1126_ sky130_fd_sc_hd__a221o_1
X_2869_ net711 net271 _1079_ net384 net268 VGND VGND VPWR VPWR _1080_ sky130_fd_sc_hd__a221o_1
X_4608_ clknet_leaf_28_clk _0139_ VGND VGND VPWR VPWR array\[14\]\[5\] sky130_fd_sc_hd__dfxtp_1
X_4539_ clknet_leaf_56_clk _0070_ VGND VGND VPWR VPWR array\[0\]\[0\] sky130_fd_sc_hd__dfxtp_1
Xhold330 array\[0\]\[25\] VGND VGND VPWR VPWR net1096 sky130_fd_sc_hd__dlygate4sd3_1
Xhold341 array\[6\]\[6\] VGND VGND VPWR VPWR net1107 sky130_fd_sc_hd__dlygate4sd3_1
Xhold352 array\[4\]\[15\] VGND VGND VPWR VPWR net1118 sky130_fd_sc_hd__dlygate4sd3_1
Xhold385 array\[14\]\[1\] VGND VGND VPWR VPWR net1151 sky130_fd_sc_hd__dlygate4sd3_1
Xhold396 array\[11\]\[7\] VGND VGND VPWR VPWR net1162 sky130_fd_sc_hd__dlygate4sd3_1
Xhold374 array\[7\]\[10\] VGND VGND VPWR VPWR net1140 sky130_fd_sc_hd__dlygate4sd3_1
Xhold363 array\[12\]\[2\] VGND VGND VPWR VPWR net1129 sky130_fd_sc_hd__dlygate4sd3_1
XFILLER_89_167 VGND VGND VPWR VPWR sky130_fd_sc_hd__fill_1
XFILLER_77_38 VGND VGND VPWR VPWR sky130_fd_sc_hd__fill_2
XFILLER_93_15 VPWR VGND VPWR VGND sky130_ef_sc_hd__decap_12
XFILLER_85_351 VPWR VGND VPWR VGND sky130_ef_sc_hd__decap_12
XFILLER_73_502 VGND VGND VPWR VPWR sky130_fd_sc_hd__fill_2
XTAP_TAPCELL_ROW_56_766 VGND VPWR sky130_fd_sc_hd__tapvpwrvgnd_1
Xclkbuf_3_6__f_clk clknet_0_clk VGND VGND VPWR VPWR clknet_3_6__leaf_clk sky130_fd_sc_hd__clkbuf_16
XFILLER_26_97 VGND VGND VPWR VPWR sky130_fd_sc_hd__decap_4
XFILLER_26_484 VGND VGND VPWR VPWR sky130_fd_sc_hd__decap_4
XTAP_TAPCELL_ROW_11_313 VGND VPWR sky130_fd_sc_hd__tapvpwrvgnd_1
XFILLER_41_498 VGND VGND VPWR VPWR sky130_fd_sc_hd__fill_1
XFILLER_42_85 VGND VGND VPWR VPWR sky130_fd_sc_hd__fill_1
XFILLER_5_322 VGND VGND VPWR VPWR sky130_fd_sc_hd__decap_6
XFILLER_1_561 VGND VGND VPWR VPWR sky130_fd_sc_hd__fill_1
XFILLER_3_57 VGND VGND VPWR VPWR sky130_fd_sc_hd__fill_2
XFILLER_76_384 VGND VGND VPWR VPWR sky130_fd_sc_hd__decap_4
XFILLER_83_81 VPWR VGND VPWR VGND sky130_ef_sc_hd__decap_12
X_3910_ net437 _1830_ _1834_ net356 VGND VGND VPWR VPWR _1837_ sky130_fd_sc_hd__a22o_1
X_4890_ clknet_leaf_3_clk _0421_ VGND VGND VPWR VPWR array\[6\]\[1\] sky130_fd_sc_hd__dfxtp_1
X_3841_ net353 _1767_ _1771_ net437 VGND VGND VPWR VPWR _1774_ sky130_fd_sc_hd__a22o_1
X_3772_ array\[1\]\[0\] net543 net526 array\[3\]\[0\] _1710_ VGND VGND VPWR VPWR _1711_
+ sky130_fd_sc_hd__a221o_1
X_2723_ net735 net289 _0979_ net387 VGND VGND VPWR VPWR _0980_ sky130_fd_sc_hd__a22o_1
XFILLER_8_160 VGND VGND VPWR VPWR sky130_fd_sc_hd__decap_3
X_2654_ net757 _0860_ VGND VGND VPWR VPWR _0932_ sky130_fd_sc_hd__nand2_1
X_2585_ net1008 net299 _0886_ VGND VGND VPWR VPWR _0562_ sky130_fd_sc_hd__o21a_1
X_4324_ net582 net429 net333 net658 VGND VGND VPWR VPWR _2164_ sky130_fd_sc_hd__a22o_1
X_4255_ net712 net335 VGND VGND VPWR VPWR _2120_ sky130_fd_sc_hd__and2_1
XFILLER_86_159 VGND VGND VPWR VPWR sky130_fd_sc_hd__decap_8
X_4186_ net910 net225 _2073_ VGND VGND VPWR VPWR _0400_ sky130_fd_sc_hd__o21a_1
X_3206_ net762 net485 net181 net703 _1316_ VGND VGND VPWR VPWR _1317_ sky130_fd_sc_hd__a221o_1
X_3137_ net741 net186 _1267_ net190 VGND VGND VPWR VPWR _1268_ sky130_fd_sc_hd__a211o_1
XFILLER_94_181 VGND VGND VPWR VPWR sky130_fd_sc_hd__decap_4
XFILLER_27_248 VGND VGND VPWR VPWR sky130_fd_sc_hd__decap_4
XFILLER_27_259 VGND VGND VPWR VPWR sky130_fd_sc_hd__fill_1
XFILLER_55_557 VGND VGND VPWR VPWR sky130_fd_sc_hd__decap_3
XFILLER_82_365 VGND VGND VPWR VPWR sky130_fd_sc_hd__fill_2
X_3068_ _1138_ _1139_ _1137_ VGND VGND VPWR VPWR _1218_ sky130_fd_sc_hd__and3b_2
XTAP_TAPCELL_ROW_81_1013 VGND VPWR sky130_fd_sc_hd__tapvpwrvgnd_1
XFILLER_23_421 VGND VGND VPWR VPWR sky130_fd_sc_hd__fill_1
XFILLER_35_281 VGND VGND VPWR VPWR sky130_fd_sc_hd__decap_3
XTAP_TAPCELL_ROW_53_736 VGND VPWR sky130_fd_sc_hd__tapvpwrvgnd_1
XFILLER_50_295 VGND VGND VPWR VPWR sky130_fd_sc_hd__fill_1
XTAP_TAPCELL_ROW_92_1120 VGND VPWR sky130_fd_sc_hd__tapvpwrvgnd_1
XFILLER_88_15 VPWR VGND VPWR VGND sky130_ef_sc_hd__decap_12
Xhold171 array\[14\]\[31\] VGND VGND VPWR VPWR net937 sky130_fd_sc_hd__dlygate4sd3_1
Xhold160 array\[2\]\[10\] VGND VGND VPWR VPWR net926 sky130_fd_sc_hd__dlygate4sd3_1
Xhold182 array\[3\]\[10\] VGND VGND VPWR VPWR net948 sky130_fd_sc_hd__dlygate4sd3_1
Xhold193 array\[6\]\[31\] VGND VGND VPWR VPWR net959 sky130_fd_sc_hd__dlygate4sd3_1
Xfanout651 net6 VGND VGND VPWR VPWR net651 sky130_fd_sc_hd__clkbuf_4
Xfanout640 net65 VGND VGND VPWR VPWR net640 sky130_fd_sc_hd__dlymetal6s2s_1
Xfanout684 net46 VGND VGND VPWR VPWR net684 sky130_fd_sc_hd__buf_1
Xfanout662 net57 VGND VGND VPWR VPWR net662 sky130_fd_sc_hd__buf_1
Xfanout673 net51 VGND VGND VPWR VPWR net673 sky130_fd_sc_hd__clkbuf_2
XFILLER_92_129 VGND VGND VPWR VPWR sky130_fd_sc_hd__fill_2
Xfanout695 net40 VGND VGND VPWR VPWR net695 sky130_fd_sc_hd__buf_2
XTAP_TAPCELL_ROW_69_891 VGND VPWR sky130_fd_sc_hd__tapvpwrvgnd_1
XFILLER_33_218 VGND VGND VPWR VPWR sky130_fd_sc_hd__fill_1
XFILLER_14_421 VGND VGND VPWR VPWR sky130_fd_sc_hd__decap_4
X_2370_ net699 net316 _0734_ net408 net313 VGND VGND VPWR VPWR _0735_ sky130_fd_sc_hd__a221o_1
XFILLER_1_380 VPWR VGND VPWR VGND sky130_ef_sc_hd__decap_12
X_4040_ array\[1\]\[24\] net556 net538 array\[3\]\[24\] _1954_ VGND VGND VPWR VPWR
+ _1955_ sky130_fd_sc_hd__a221o_1
XFILLER_64_398 VGND VGND VPWR VPWR sky130_fd_sc_hd__fill_1
XTAP_TAPCELL_ROW_50_706 VGND VPWR sky130_fd_sc_hd__tapvpwrvgnd_1
X_4873_ clknet_leaf_23_clk _0404_ VGND VGND VPWR VPWR array\[7\]\[16\] sky130_fd_sc_hd__dfxtp_1
XFILLER_60_560 VGND VGND VPWR VPWR sky130_fd_sc_hd__fill_2
X_3824_ array\[10\]\[5\] net470 net453 array\[8\]\[5\] VGND VGND VPWR VPWR _1758_
+ sky130_fd_sc_hd__a22o_1
X_3755_ net878 net238 _1696_ _1697_ VGND VGND VPWR VPWR _0341_ sky130_fd_sc_hd__o22a_1
XFILLER_20_468 VGND VGND VPWR VPWR sky130_fd_sc_hd__fill_1
X_3686_ net1192 net238 _1651_ _1652_ VGND VGND VPWR VPWR _0317_ sky130_fd_sc_hd__o22a_1
X_2706_ net799 _0968_ net296 VGND VGND VPWR VPWR _0021_ sky130_fd_sc_hd__mux2_1
X_2637_ net1055 net298 _0919_ _0920_ VGND VGND VPWR VPWR _0580_ sky130_fd_sc_hd__o22a_1
XPHY_EDGE_ROW_12_Right_12 VGND VGND VPWR VPWR sky130_fd_sc_hd__decap_3
X_2568_ net711 net399 net507 VGND VGND VPWR VPWR _0875_ sky130_fd_sc_hd__and3_1
XFILLER_58_29 VGND VGND VPWR VPWR sky130_fd_sc_hd__fill_2
X_2499_ net682 net610 net515 VGND VGND VPWR VPWR _0824_ sky130_fd_sc_hd__mux2_1
X_4307_ net1111 net218 _2152_ _2153_ VGND VGND VPWR VPWR _0441_ sky130_fd_sc_hd__o22a_1
X_4238_ net575 net433 net342 net645 net231 VGND VGND VPWR VPWR _2108_ sky130_fd_sc_hd__a221o_1
XFILLER_28_557 VGND VGND VPWR VPWR sky130_fd_sc_hd__fill_1
X_4169_ net1193 net225 _2061_ _2062_ VGND VGND VPWR VPWR _0394_ sky130_fd_sc_hd__o22a_1
XTAP_TAPCELL_ROW_66_861 VGND VPWR sky130_fd_sc_hd__tapvpwrvgnd_1
XPHY_EDGE_ROW_21_Right_21 VGND VGND VPWR VPWR sky130_fd_sc_hd__decap_3
XFILLER_55_376 VGND VGND VPWR VPWR sky130_fd_sc_hd__decap_6
XTAP_TAPCELL_ROW_38_585 VGND VPWR sky130_fd_sc_hd__tapvpwrvgnd_1
XFILLER_90_27 VGND VGND VPWR VPWR sky130_fd_sc_hd__fill_1
XPHY_EDGE_ROW_30_Right_30 VGND VGND VPWR VPWR sky130_fd_sc_hd__decap_3
XFILLER_93_405 VPWR VGND VPWR VGND sky130_ef_sc_hd__decap_12
XFILLER_65_107 VGND VGND VPWR VPWR sky130_fd_sc_hd__decap_4
XFILLER_19_524 VGND VGND VPWR VPWR sky130_fd_sc_hd__fill_1
Xfanout481 _1368_ VGND VGND VPWR VPWR net481 sky130_fd_sc_hd__clkbuf_4
XFILLER_48_62 VPWR VGND VPWR VGND sky130_ef_sc_hd__decap_12
Xfanout492 _1221_ VGND VGND VPWR VPWR net492 sky130_fd_sc_hd__clkbuf_4
Xfanout470 net472 VGND VGND VPWR VPWR net470 sky130_fd_sc_hd__clkbuf_4
XFILLER_19_546 VGND VGND VPWR VPWR sky130_fd_sc_hd__decap_8
XFILLER_58_170 VGND VGND VPWR VPWR sky130_fd_sc_hd__decap_3
XFILLER_14_251 VGND VGND VPWR VPWR sky130_fd_sc_hd__fill_1
XFILLER_42_560 VGND VGND VPWR VPWR sky130_fd_sc_hd__fill_2
XFILLER_80_93 VGND VGND VPWR VPWR sky130_fd_sc_hd__fill_2
X_3540_ net747 net247 VGND VGND VPWR VPWR _1546_ sky130_fd_sc_hd__and2_1
X_3471_ net723 net258 _1497_ net266 VGND VGND VPWR VPWR _1498_ sky130_fd_sc_hd__a211o_1
X_2422_ net885 net209 _0769_ VGND VGND VPWR VPWR _0516_ sky130_fd_sc_hd__o21a_1
XFILLER_43_3 VGND VGND VPWR VPWR sky130_fd_sc_hd__fill_1
X_2353_ net1117 net207 _0723_ VGND VGND VPWR VPWR _0493_ sky130_fd_sc_hd__o21a_1
X_4023_ net351 _1933_ _1937_ net415 VGND VGND VPWR VPWR _1940_ sky130_fd_sc_hd__a22o_1
X_2284_ net1042 net323 _0674_ VGND VGND VPWR VPWR _0473_ sky130_fd_sc_hd__o21a_1
XTAP_TAPCELL_ROW_63_831 VGND VPWR sky130_fd_sc_hd__tapvpwrvgnd_1
XTAP_TAPCELL_ROW_35_555 VGND VPWR sky130_fd_sc_hd__tapvpwrvgnd_1
X_4856_ clknet_leaf_62_clk _0387_ VGND VGND VPWR VPWR full sky130_fd_sc_hd__dfxtp_1
XFILLER_20_221 VGND VGND VPWR VPWR sky130_fd_sc_hd__decap_8
X_3807_ array\[13\]\[3\] net546 net534 array\[15\]\[3\] _1742_ VGND VGND VPWR VPWR
+ _1743_ sky130_fd_sc_hd__a221o_1
X_4787_ clknet_leaf_32_clk _0318_ VGND VGND VPWR VPWR array\[9\]\[5\] sky130_fd_sc_hd__dfxtp_1
X_3738_ net731 net350 net422 VGND VGND VPWR VPWR _1686_ sky130_fd_sc_hd__and3_1
XFILLER_69_39 VGND VGND VPWR VPWR sky130_fd_sc_hd__decap_8
X_3669_ net654 _1638_ VGND VGND VPWR VPWR _1640_ sky130_fd_sc_hd__or2_1
XFILLER_85_27 VPWR VGND VPWR VGND sky130_ef_sc_hd__decap_12
XFILLER_28_365 VGND VGND VPWR VPWR sky130_fd_sc_hd__decap_6
XTAP_TAPCELL_ROW_87_1074 VGND VPWR sky130_fd_sc_hd__tapvpwrvgnd_1
XFILLER_24_560 VGND VGND VPWR VPWR sky130_fd_sc_hd__fill_2
XFILLER_51_390 VGND VGND VPWR VPWR sky130_fd_sc_hd__fill_2
XFILLER_7_214 VGND VGND VPWR VPWR sky130_fd_sc_hd__fill_2
XFILLER_3_497 VGND VGND VPWR VPWR sky130_fd_sc_hd__decap_6
XFILLER_66_416 VGND VGND VPWR VPWR sky130_fd_sc_hd__decap_4
Xclkbuf_leaf_58_clk clknet_3_0__leaf_clk VGND VGND VPWR VPWR clknet_leaf_58_clk sky130_fd_sc_hd__clkbuf_8
XFILLER_19_332 VGND VGND VPWR VPWR sky130_fd_sc_hd__decap_4
XFILLER_81_419 VGND VGND VPWR VPWR sky130_fd_sc_hd__fill_2
XTAP_TAPCELL_ROW_77_978 VGND VPWR sky130_fd_sc_hd__tapvpwrvgnd_1
XFILLER_74_493 VGND VGND VPWR VPWR sky130_fd_sc_hd__decap_4
XFILLER_46_195 VGND VGND VPWR VPWR sky130_fd_sc_hd__fill_1
X_2971_ _0625_ _1141_ _1145_ net379 VGND VGND VPWR VPWR _1153_ sky130_fd_sc_hd__nor4_2
XFILLER_22_519 VGND VGND VPWR VPWR sky130_fd_sc_hd__decap_4
XTAP_TAPCELL_ROW_60_801 VGND VPWR sky130_fd_sc_hd__tapvpwrvgnd_1
XFILLER_91_81 VPWR VGND VPWR VGND sky130_ef_sc_hd__decap_12
X_4710_ clknet_leaf_18_clk _0241_ VGND VGND VPWR VPWR array\[11\]\[11\] sky130_fd_sc_hd__dfxtp_1
XTAP_TAPCELL_ROW_32_525 VGND VPWR sky130_fd_sc_hd__tapvpwrvgnd_1
X_4641_ clknet_leaf_8_clk _0172_ VGND VGND VPWR VPWR array\[13\]\[6\] sky130_fd_sc_hd__dfxtp_1
X_4572_ clknet_leaf_59_clk _0103_ VGND VGND VPWR VPWR array\[15\]\[1\] sky130_fd_sc_hd__dfxtp_1
X_3523_ net623 net476 net359 net695 VGND VGND VPWR VPWR _1535_ sky130_fd_sc_hd__a22o_1
X_3454_ net1299 net259 _1485_ _1486_ VGND VGND VPWR VPWR _0251_ sky130_fd_sc_hd__o22a_1
X_2405_ net597 net671 net517 VGND VGND VPWR VPWR _0758_ sky130_fd_sc_hd__mux2_1
X_3385_ net654 _1438_ VGND VGND VPWR VPWR _1439_ sky130_fd_sc_hd__nor2_2
XFILLER_69_254 VGND VGND VPWR VPWR sky130_fd_sc_hd__fill_1
X_2336_ _0589_ _0709_ net517 VGND VGND VPWR VPWR _0710_ sky130_fd_sc_hd__o21ai_4
Xclkbuf_leaf_49_clk clknet_3_2__leaf_clk VGND VGND VPWR VPWR clknet_leaf_49_clk sky130_fd_sc_hd__clkbuf_8
X_2267_ net695 net623 net521 VGND VGND VPWR VPWR _0663_ sky130_fd_sc_hd__mux2_1
XFILLER_57_449 VGND VGND VPWR VPWR sky130_fd_sc_hd__fill_1
XFILLER_84_279 VGND VGND VPWR VPWR sky130_fd_sc_hd__fill_2
X_4006_ array\[13\]\[21\] net545 net527 array\[15\]\[21\] _1923_ VGND VGND VPWR VPWR
+ _1924_ sky130_fd_sc_hd__a221o_1
X_2198_ net560 _0603_ net169 net545 VGND VGND VPWR VPWR _0454_ sky130_fd_sc_hd__a22o_1
XTAP_TAPCELL_ROW_48_680 VGND VPWR sky130_fd_sc_hd__tapvpwrvgnd_1
XFILLER_52_165 VGND VGND VPWR VPWR sky130_fd_sc_hd__fill_2
X_4908_ clknet_leaf_56_clk _0439_ VGND VGND VPWR VPWR array\[6\]\[19\] sky130_fd_sc_hd__dfxtp_1
X_4839_ clknet_leaf_44_clk _0370_ VGND VGND VPWR VPWR net137 sky130_fd_sc_hd__dfxtp_1
XFILLER_0_412 VGND VGND VPWR VPWR sky130_fd_sc_hd__decap_8
XFILLER_29_20 VPWR VGND VPWR VGND sky130_ef_sc_hd__decap_12
Xhold31 net124 VGND VGND VPWR VPWR net797 sky130_fd_sc_hd__dlygate4sd3_1
Xhold20 array\[13\]\[3\] VGND VGND VPWR VPWR net786 sky130_fd_sc_hd__dlygate4sd3_1
XFILLER_0_489 VPWR VGND VPWR VGND sky130_ef_sc_hd__decap_12
Xhold64 array\[15\]\[26\] VGND VGND VPWR VPWR net830 sky130_fd_sc_hd__dlygate4sd3_1
Xhold42 array\[5\]\[24\] VGND VGND VPWR VPWR net808 sky130_fd_sc_hd__dlygate4sd3_1
Xhold53 array\[14\]\[9\] VGND VGND VPWR VPWR net819 sky130_fd_sc_hd__dlygate4sd3_1
Xhold75 array\[2\]\[11\] VGND VGND VPWR VPWR net841 sky130_fd_sc_hd__dlygate4sd3_1
Xhold97 array\[5\]\[11\] VGND VGND VPWR VPWR net863 sky130_fd_sc_hd__dlygate4sd3_1
XFILLER_75_279 VGND VGND VPWR VPWR sky130_fd_sc_hd__fill_1
Xhold86 array\[13\]\[0\] VGND VGND VPWR VPWR net852 sky130_fd_sc_hd__dlygate4sd3_1
XTAP_TAPCELL_ROW_74_948 VGND VPWR sky130_fd_sc_hd__tapvpwrvgnd_1
XFILLER_16_324 VPWR VGND VPWR VGND sky130_ef_sc_hd__decap_12
XFILLER_56_460 VGND VGND VPWR VPWR sky130_fd_sc_hd__fill_1
XFILLER_8_501 VPWR VGND VPWR VGND sky130_ef_sc_hd__decap_12
XFILLER_8_545 VPWR VGND VPWR VGND sky130_ef_sc_hd__decap_12
XFILLER_6_57 VGND VGND VPWR VPWR sky130_fd_sc_hd__decap_6
XANTENNA_6 _0782_ VGND VGND VPWR VPWR sky130_fd_sc_hd__diode_2
XFILLER_3_261 VPWR VGND VPWR VGND sky130_ef_sc_hd__decap_12
XFILLER_79_541 VPWR VGND VPWR VGND sky130_ef_sc_hd__decap_12
X_3170_ net716 net187 _1289_ net191 VGND VGND VPWR VPWR _1290_ sky130_fd_sc_hd__a211o_1
XFILLER_39_416 VGND VGND VPWR VPWR sky130_fd_sc_hd__decap_4
XFILLER_94_533 VPWR VGND VPWR VGND sky130_ef_sc_hd__decap_12
XFILLER_94_522 VGND VGND VPWR VPWR sky130_fd_sc_hd__decap_8
XFILLER_66_224 VPWR VGND VPWR VGND sky130_ef_sc_hd__decap_12
XFILLER_19_151 VGND VGND VPWR VPWR sky130_fd_sc_hd__fill_1
XTAP_TAPCELL_ROW_45_650 VGND VPWR sky130_fd_sc_hd__tapvpwrvgnd_1
XFILLER_62_474 VGND VGND VPWR VPWR sky130_fd_sc_hd__fill_2
XFILLER_62_485 VGND VGND VPWR VPWR sky130_fd_sc_hd__decap_6
XTAP_TAPCELL_ROW_17_374 VGND VPWR sky130_fd_sc_hd__tapvpwrvgnd_1
XFILLER_22_327 VGND VGND VPWR VPWR sky130_fd_sc_hd__fill_1
X_2954_ net1046 net200 _1136_ VGND VGND VPWR VPWR _0101_ sky130_fd_sc_hd__o21a_1
X_2885_ net884 net201 _1090_ VGND VGND VPWR VPWR _0078_ sky130_fd_sc_hd__o21a_1
XPHY_EDGE_ROW_6_Right_6 VGND VGND VPWR VPWR sky130_fd_sc_hd__decap_3
X_4624_ clknet_leaf_0_clk _0155_ VGND VGND VPWR VPWR array\[14\]\[21\] sky130_fd_sc_hd__dfxtp_1
X_4555_ clknet_leaf_22_clk _0086_ VGND VGND VPWR VPWR array\[0\]\[16\] sky130_fd_sc_hd__dfxtp_1
Xhold501 array\[1\]\[4\] VGND VGND VPWR VPWR net1267 sky130_fd_sc_hd__dlygate4sd3_1
Xhold534 array\[11\]\[26\] VGND VGND VPWR VPWR net1300 sky130_fd_sc_hd__dlygate4sd3_1
Xhold545 array\[4\]\[10\] VGND VGND VPWR VPWR net1311 sky130_fd_sc_hd__dlygate4sd3_1
Xhold512 array\[2\]\[21\] VGND VGND VPWR VPWR net1278 sky130_fd_sc_hd__dlygate4sd3_1
Xhold523 array\[12\]\[21\] VGND VGND VPWR VPWR net1289 sky130_fd_sc_hd__dlygate4sd3_1
X_3506_ net569 net474 net362 net639 net253 VGND VGND VPWR VPWR _1524_ sky130_fd_sc_hd__a221o_1
X_4486_ clknet_leaf_17_clk _0017_ VGND VGND VPWR VPWR array\[5\]\[11\] sky130_fd_sc_hd__dfxtp_1
X_3437_ net611 net480 net366 net683 VGND VGND VPWR VPWR _1475_ sky130_fd_sc_hd__a22o_1
X_3368_ net883 net155 _1425_ _1426_ VGND VGND VPWR VPWR _0225_ sky130_fd_sc_hd__o22a_1
XFILLER_85_500 VGND VGND VPWR VPWR sky130_fd_sc_hd__decap_4
XFILLER_66_18 VGND VGND VPWR VPWR sky130_fd_sc_hd__decap_8
X_2319_ net723 net322 _0697_ net413 net330 VGND VGND VPWR VPWR _0698_ sky130_fd_sc_hd__a221o_1
XFILLER_66_29 VPWR VGND VPWR VGND sky130_ef_sc_hd__decap_12
X_3299_ net710 net174 VGND VGND VPWR VPWR _1381_ sky130_fd_sc_hd__and2_1
XTAP_TAPCELL_ROW_84_1044 VGND VPWR sky130_fd_sc_hd__tapvpwrvgnd_1
XTAP_TAPCELL_ROW_71_918 VGND VPWR sky130_fd_sc_hd__tapvpwrvgnd_1
XFILLER_15_44 VGND VGND VPWR VPWR sky130_fd_sc_hd__fill_2
XFILLER_21_371 VGND VGND VPWR VPWR sky130_fd_sc_hd__fill_2
XFILLER_21_382 VGND VGND VPWR VPWR sky130_fd_sc_hd__decap_4
XFILLER_5_559 VGND VGND VPWR VPWR sky130_fd_sc_hd__fill_1
XFILLER_0_253 VGND VGND VPWR VPWR sky130_fd_sc_hd__fill_2
Xinput110 write_location1[3] VGND VGND VPWR VPWR net110 sky130_fd_sc_hd__buf_1
XFILLER_88_382 VGND VGND VPWR VPWR sky130_fd_sc_hd__fill_2
XFILLER_0_286 VGND VGND VPWR VPWR sky130_fd_sc_hd__decap_4
XFILLER_48_235 VGND VGND VPWR VPWR sky130_fd_sc_hd__fill_2
XTAP_TAPCELL_ROW_59_797 VGND VPWR sky130_fd_sc_hd__tapvpwrvgnd_1
XTAP_TAPCELL_ROW_42_620 VGND VPWR sky130_fd_sc_hd__tapvpwrvgnd_1
XTAP_TAPCELL_ROW_14_344 VGND VPWR sky130_fd_sc_hd__tapvpwrvgnd_1
XPHY_EDGE_ROW_59_Right_59 VGND VGND VPWR VPWR sky130_fd_sc_hd__decap_3
X_2670_ net785 _0944_ net294 VGND VGND VPWR VPWR _0009_ sky130_fd_sc_hd__mux2_1
X_4340_ net1316 net217 _0611_ _0587_ VGND VGND VPWR VPWR _0379_ sky130_fd_sc_hd__o211a_1
X_4271_ net1029 net220 _2129_ _2130_ VGND VGND VPWR VPWR _0428_ sky130_fd_sc_hd__o22a_1
X_3222_ net895 _1327_ net159 VGND VGND VPWR VPWR _0178_ sky130_fd_sc_hd__mux2_1
XPHY_EDGE_ROW_68_Right_68 VGND VGND VPWR VPWR sky130_fd_sc_hd__decap_3
X_3153_ net988 net163 _1278_ VGND VGND VPWR VPWR _0158_ sky130_fd_sc_hd__o21a_1
XFILLER_94_396 VPWR VGND VPWR VGND sky130_ef_sc_hd__decap_12
X_3084_ net1151 net161 _1232_ VGND VGND VPWR VPWR _0135_ sky130_fd_sc_hd__o21a_1
XPHY_EDGE_ROW_77_Right_77 VGND VGND VPWR VPWR sky130_fd_sc_hd__decap_3
X_3986_ array\[2\]\[19\] net456 net439 array\[0\]\[19\] VGND VGND VPWR VPWR _1906_
+ sky130_fd_sc_hd__a22o_1
XFILLER_50_444 VGND VGND VPWR VPWR sky130_fd_sc_hd__decap_8
X_2937_ net587 net661 net499 VGND VGND VPWR VPWR _1125_ sky130_fd_sc_hd__mux2_1
XFILLER_50_488 VGND VGND VPWR VPWR sky130_fd_sc_hd__decap_8
X_2868_ net571 net641 net500 VGND VGND VPWR VPWR _1079_ sky130_fd_sc_hd__mux2_1
X_4607_ clknet_leaf_43_clk _0138_ VGND VGND VPWR VPWR array\[14\]\[4\] sky130_fd_sc_hd__dfxtp_1
Xhold320 array\[8\]\[4\] VGND VGND VPWR VPWR net1086 sky130_fd_sc_hd__dlygate4sd3_1
X_2799_ net619 net504 net276 net691 net286 VGND VGND VPWR VPWR _1033_ sky130_fd_sc_hd__a221o_1
XFILLER_89_113 VPWR VGND VPWR VGND sky130_ef_sc_hd__decap_12
Xhold331 array\[0\]\[30\] VGND VGND VPWR VPWR net1097 sky130_fd_sc_hd__dlygate4sd3_1
X_4538_ clknet_leaf_49_clk _0069_ VGND VGND VPWR VPWR array\[8\]\[31\] sky130_fd_sc_hd__dfxtp_1
Xhold353 array\[8\]\[10\] VGND VGND VPWR VPWR net1119 sky130_fd_sc_hd__dlygate4sd3_1
Xhold342 array\[11\]\[3\] VGND VGND VPWR VPWR net1108 sky130_fd_sc_hd__dlygate4sd3_1
Xhold386 array\[0\]\[5\] VGND VGND VPWR VPWR net1152 sky130_fd_sc_hd__dlygate4sd3_1
X_4469_ clknet_leaf_16_clk _0580_ VGND VGND VPWR VPWR array\[4\]\[26\] sky130_fd_sc_hd__dfxtp_1
Xhold375 array\[14\]\[4\] VGND VGND VPWR VPWR net1141 sky130_fd_sc_hd__dlygate4sd3_1
Xhold364 array\[7\]\[15\] VGND VGND VPWR VPWR net1130 sky130_fd_sc_hd__dlygate4sd3_1
XPHY_EDGE_ROW_86_Right_86 VGND VGND VPWR VPWR sky130_fd_sc_hd__decap_3
Xhold397 array\[3\]\[3\] VGND VGND VPWR VPWR net1163 sky130_fd_sc_hd__dlygate4sd3_1
XFILLER_93_27 VPWR VGND VPWR VGND sky130_ef_sc_hd__decap_12
XFILLER_85_363 VGND VGND VPWR VPWR sky130_fd_sc_hd__decap_8
XFILLER_26_43 VGND VGND VPWR VPWR sky130_fd_sc_hd__decap_6
XTAP_TAPCELL_ROW_56_767 VGND VPWR sky130_fd_sc_hd__tapvpwrvgnd_1
XFILLER_13_113 VGND VGND VPWR VPWR sky130_fd_sc_hd__fill_1
XFILLER_26_76 VGND VGND VPWR VPWR sky130_fd_sc_hd__fill_1
XFILLER_41_444 VGND VGND VPWR VPWR sky130_fd_sc_hd__decap_4
XTAP_TAPCELL_ROW_11_314 VGND VPWR sky130_fd_sc_hd__tapvpwrvgnd_1
XFILLER_21_190 VGND VGND VPWR VPWR sky130_fd_sc_hd__decap_3
XFILLER_5_345 VGND VGND VPWR VPWR sky130_fd_sc_hd__fill_1
XPHY_EDGE_ROW_39_Left_134 VGND VGND VPWR VPWR sky130_fd_sc_hd__decap_3
XFILLER_76_341 VGND VGND VPWR VPWR sky130_fd_sc_hd__decap_3
XPHY_EDGE_ROW_48_Left_143 VGND VGND VPWR VPWR sky130_fd_sc_hd__decap_3
XFILLER_91_388 VGND VGND VPWR VPWR sky130_fd_sc_hd__decap_4
XFILLER_83_93 VPWR VGND VPWR VGND sky130_ef_sc_hd__decap_12
X_3840_ array\[13\]\[6\] net546 net534 array\[15\]\[6\] _1772_ VGND VGND VPWR VPWR
+ _1773_ sky130_fd_sc_hd__a221o_1
X_3771_ array\[2\]\[0\] net456 net439 array\[0\]\[0\] VGND VGND VPWR VPWR _1710_ sky130_fd_sc_hd__a22o_1
X_2722_ net671 net597 net391 VGND VGND VPWR VPWR _0979_ sky130_fd_sc_hd__mux2_1
XFILLER_73_3 VGND VGND VPWR VPWR sky130_fd_sc_hd__fill_1
XPHY_EDGE_ROW_57_Left_152 VGND VGND VPWR VPWR sky130_fd_sc_hd__decap_3
X_2653_ _0589_ net757 VGND VGND VPWR VPWR _0931_ sky130_fd_sc_hd__and2_2
X_2584_ net701 _0868_ _0885_ net303 VGND VGND VPWR VPWR _0886_ sky130_fd_sc_hd__a211o_1
X_4323_ net1090 net220 _2162_ _2163_ VGND VGND VPWR VPWR _0447_ sky130_fd_sc_hd__o22a_1
X_4254_ net1251 net220 _2118_ _2119_ VGND VGND VPWR VPWR _0422_ sky130_fd_sc_hd__o22a_1
X_4185_ net764 net234 net229 _2072_ VGND VGND VPWR VPWR _2073_ sky130_fd_sc_hd__a211o_1
X_3205_ net633 net371 VGND VGND VPWR VPWR _1316_ sky130_fd_sc_hd__and2_1
XPHY_EDGE_ROW_66_Left_161 VGND VGND VPWR VPWR sky130_fd_sc_hd__decap_3
X_3136_ net603 net491 net376 net677 VGND VGND VPWR VPWR _1267_ sky130_fd_sc_hd__a22o_1
X_3067_ net849 _1217_ net166 VGND VGND VPWR VPWR _0133_ sky130_fd_sc_hd__mux2_1
XFILLER_42_219 VPWR VGND VPWR VGND sky130_ef_sc_hd__decap_12
XFILLER_82_399 VGND VGND VPWR VPWR sky130_fd_sc_hd__decap_3
XTAP_TAPCELL_ROW_81_1014 VGND VPWR sky130_fd_sc_hd__tapvpwrvgnd_1
XTAP_TAPCELL_ROW_53_737 VGND VPWR sky130_fd_sc_hd__tapvpwrvgnd_1
XFILLER_23_499 VGND VGND VPWR VPWR sky130_fd_sc_hd__decap_4
X_3969_ array\[14\]\[18\] net460 net443 array\[12\]\[18\] VGND VGND VPWR VPWR _1890_
+ sky130_fd_sc_hd__a22o_1
XPHY_EDGE_ROW_75_Left_170 VGND VGND VPWR VPWR sky130_fd_sc_hd__decap_3
XFILLER_12_67 VPWR VGND VPWR VGND sky130_ef_sc_hd__decap_12
XFILLER_88_27 VGND VGND VPWR VPWR sky130_fd_sc_hd__fill_1
XTAP_TAPCELL_ROW_92_1121 VGND VPWR sky130_fd_sc_hd__tapvpwrvgnd_1
Xhold150 array\[3\]\[26\] VGND VGND VPWR VPWR net916 sky130_fd_sc_hd__dlygate4sd3_1
XFILLER_2_348 VPWR VGND VPWR VGND sky130_ef_sc_hd__decap_12
Xhold161 array\[10\]\[23\] VGND VGND VPWR VPWR net927 sky130_fd_sc_hd__dlygate4sd3_1
Xhold194 array\[0\]\[16\] VGND VGND VPWR VPWR net960 sky130_fd_sc_hd__dlygate4sd3_1
Xhold172 net133 VGND VGND VPWR VPWR net938 sky130_fd_sc_hd__dlygate4sd3_1
Xhold183 array\[8\]\[23\] VGND VGND VPWR VPWR net949 sky130_fd_sc_hd__dlygate4sd3_1
XFILLER_77_138 VGND VGND VPWR VPWR sky130_fd_sc_hd__fill_1
XFILLER_77_105 VGND VGND VPWR VPWR sky130_fd_sc_hd__decap_6
Xfanout630 net7 VGND VGND VPWR VPWR net630 sky130_fd_sc_hd__dlymetal6s2s_1
Xfanout641 net64 VGND VGND VPWR VPWR net641 sky130_fd_sc_hd__buf_2
Xfanout652 net6 VGND VGND VPWR VPWR net652 sky130_fd_sc_hd__buf_2
Xfanout663 net56 VGND VGND VPWR VPWR net663 sky130_fd_sc_hd__buf_2
Xfanout685 net45 VGND VGND VPWR VPWR net685 sky130_fd_sc_hd__buf_2
Xfanout674 net51 VGND VGND VPWR VPWR net674 sky130_fd_sc_hd__clkbuf_2
Xfanout696 net40 VGND VGND VPWR VPWR net696 sky130_fd_sc_hd__dlymetal6s2s_1
XFILLER_73_333 VGND VGND VPWR VPWR sky130_fd_sc_hd__fill_1
XTAP_TAPCELL_ROW_69_892 VGND VPWR sky130_fd_sc_hd__tapvpwrvgnd_1
XFILLER_18_238 VGND VGND VPWR VPWR sky130_fd_sc_hd__fill_1
XFILLER_14_477 VPWR VGND VPWR VGND sky130_ef_sc_hd__decap_12
XFILLER_38_6 VGND VGND VPWR VPWR sky130_fd_sc_hd__decap_4
XFILLER_37_525 VGND VGND VPWR VPWR sky130_fd_sc_hd__fill_1
XFILLER_94_81 VGND VGND VPWR VPWR sky130_fd_sc_hd__decap_3
XFILLER_76_182 VGND VGND VPWR VPWR sky130_fd_sc_hd__decap_4
XTAP_TAPCELL_ROW_50_707 VGND VPWR sky130_fd_sc_hd__tapvpwrvgnd_1
X_4872_ clknet_leaf_35_clk _0403_ VGND VGND VPWR VPWR array\[7\]\[15\] sky130_fd_sc_hd__dfxtp_1
X_3823_ array\[13\]\[5\] net557 net541 array\[15\]\[5\] _1756_ VGND VGND VPWR VPWR
+ _1757_ sky130_fd_sc_hd__a221o_1
X_3754_ net581 net425 net346 net657 net243 VGND VGND VPWR VPWR _1697_ sky130_fd_sc_hd__a221o_1
X_3685_ net569 net425 net346 net639 net243 VGND VGND VPWR VPWR _1652_ sky130_fd_sc_hd__a221o_1
X_2705_ net749 net292 _0967_ net390 VGND VGND VPWR VPWR _0968_ sky130_fd_sc_hd__a22o_1
X_2636_ net587 net510 net396 net661 net301 VGND VGND VPWR VPWR _0920_ sky130_fd_sc_hd__a221o_1
X_2567_ net1218 net302 _0868_ net717 _0874_ VGND VGND VPWR VPWR _0556_ sky130_fd_sc_hd__a221o_1
X_2498_ net987 net205 _0823_ VGND VGND VPWR VPWR _0538_ sky130_fd_sc_hd__o21a_1
X_4306_ net598 net427 net331 net672 net221 VGND VGND VPWR VPWR _2153_ sky130_fd_sc_hd__a221o_1
X_4237_ net715 net235 VGND VGND VPWR VPWR _2107_ sky130_fd_sc_hd__and2_1
XFILLER_74_29 VGND VGND VPWR VPWR sky130_fd_sc_hd__fill_2
X_4168_ net566 net432 net341 net636 net230 VGND VGND VPWR VPWR _2062_ sky130_fd_sc_hd__a221o_1
XFILLER_82_141 VGND VGND VPWR VPWR sky130_fd_sc_hd__decap_4
X_3119_ net754 net188 _1255_ net192 VGND VGND VPWR VPWR _1256_ sky130_fd_sc_hd__a211o_1
XTAP_TAPCELL_ROW_66_862 VGND VPWR sky130_fd_sc_hd__tapvpwrvgnd_1
X_4099_ array\[14\]\[29\] net464 net447 array\[12\]\[29\] VGND VGND VPWR VPWR _2009_
+ sky130_fd_sc_hd__a22o_1
XFILLER_55_355 VGND VGND VPWR VPWR sky130_fd_sc_hd__fill_1
XTAP_TAPCELL_ROW_38_586 VGND VPWR sky130_fd_sc_hd__tapvpwrvgnd_1
XFILLER_43_528 VGND VGND VPWR VPWR sky130_fd_sc_hd__fill_2
XFILLER_23_263 VGND VGND VPWR VPWR sky130_fd_sc_hd__fill_1
XFILLER_51_561 VGND VGND VPWR VPWR sky130_fd_sc_hd__fill_1
XFILLER_23_66 VGND VGND VPWR VPWR sky130_fd_sc_hd__fill_2
XFILLER_3_3 VPWR VGND VPWR VGND sky130_ef_sc_hd__decap_12
XFILLER_48_41 VGND VGND VPWR VPWR sky130_fd_sc_hd__fill_1
XFILLER_93_417 VPWR VGND VPWR VGND sky130_ef_sc_hd__decap_12
Xfanout471 net472 VGND VGND VPWR VPWR net471 sky130_fd_sc_hd__buf_2
Xfanout460 net463 VGND VGND VPWR VPWR net460 sky130_fd_sc_hd__clkbuf_2
XFILLER_65_119 VGND VGND VPWR VPWR sky130_fd_sc_hd__decap_4
Xfanout493 _1149_ VGND VGND VPWR VPWR net493 sky130_fd_sc_hd__clkbuf_8
XFILLER_48_74 VGND VGND VPWR VPWR sky130_fd_sc_hd__decap_3
XFILLER_48_85 VPWR VGND VPWR VGND sky130_ef_sc_hd__decap_12
Xfanout482 _1368_ VGND VGND VPWR VPWR net482 sky130_fd_sc_hd__buf_2
XFILLER_0_15 VPWR VGND VPWR VGND sky130_ef_sc_hd__decap_12
XFILLER_46_333 VGND VGND VPWR VPWR sky130_fd_sc_hd__decap_3
XFILLER_73_141 VGND VGND VPWR VPWR sky130_fd_sc_hd__fill_2
XFILLER_9_35 VPWR VGND VPWR VGND sky130_ef_sc_hd__decap_12
XFILLER_9_57 VGND VGND VPWR VPWR sky130_fd_sc_hd__fill_1
X_3470_ net583 net480 net366 net659 VGND VGND VPWR VPWR _1497_ sky130_fd_sc_hd__a22o_1
XFILLER_89_81 VPWR VGND VPWR VGND sky130_ef_sc_hd__decap_12
X_2421_ net725 net317 _0768_ net409 net314 VGND VGND VPWR VPWR _0769_ sky130_fd_sc_hd__a221o_1
XFILLER_69_414 VGND VGND VPWR VPWR sky130_fd_sc_hd__decap_3
X_2352_ net711 net315 _0722_ net407 net312 VGND VGND VPWR VPWR _0723_ sky130_fd_sc_hd__a221o_1
X_2283_ net749 net319 _0673_ net413 net327 VGND VGND VPWR VPWR _0674_ sky130_fd_sc_hd__a221o_1
X_4022_ array\[1\]\[22\] net543 net526 array\[3\]\[22\] _1938_ VGND VGND VPWR VPWR
+ _1939_ sky130_fd_sc_hd__a221o_1
XFILLER_77_480 VGND VGND VPWR VPWR sky130_fd_sc_hd__fill_1
XFILLER_49_193 VGND VGND VPWR VPWR sky130_fd_sc_hd__decap_6
XTAP_TAPCELL_ROW_35_556 VGND VPWR sky130_fd_sc_hd__tapvpwrvgnd_1
XTAP_TAPCELL_ROW_63_832 VGND VPWR sky130_fd_sc_hd__tapvpwrvgnd_1
XFILLER_33_561 VGND VGND VPWR VPWR sky130_fd_sc_hd__fill_1
X_4855_ clknet_leaf_0_clk _0386_ VGND VGND VPWR VPWR net119 sky130_fd_sc_hd__dfxtp_1
X_3806_ array\[14\]\[3\] net459 net442 array\[12\]\[3\] VGND VGND VPWR VPWR _1742_
+ sky130_fd_sc_hd__a22o_1
X_4786_ clknet_leaf_41_clk _0317_ VGND VGND VPWR VPWR array\[9\]\[4\] sky130_fd_sc_hd__dfxtp_1
X_3737_ net1124 net237 _1684_ _1685_ VGND VGND VPWR VPWR _0335_ sky130_fd_sc_hd__o22a_1
X_3668_ net654 _1638_ VGND VGND VPWR VPWR _1639_ sky130_fd_sc_hd__nor2_2
X_3599_ tail\[3\] _1581_ VGND VGND VPWR VPWR _1586_ sky130_fd_sc_hd__xnor2_1
X_2619_ net599 net510 net396 net673 net301 VGND VGND VPWR VPWR _0909_ sky130_fd_sc_hd__a221o_1
XFILLER_85_39 VPWR VGND VPWR VGND sky130_ef_sc_hd__decap_12
XFILLER_68_491 VGND VGND VPWR VPWR sky130_fd_sc_hd__decap_4
XTAP_TAPCELL_ROW_87_1075 VGND VPWR sky130_fd_sc_hd__tapvpwrvgnd_1
XFILLER_55_196 VGND VGND VPWR VPWR sky130_fd_sc_hd__decap_6
XFILLER_11_277 VGND VGND VPWR VPWR sky130_fd_sc_hd__decap_3
XFILLER_50_75 VGND VGND VPWR VPWR sky130_fd_sc_hd__fill_1
Xfanout290 net292 VGND VGND VPWR VPWR net290 sky130_fd_sc_hd__clkbuf_4
XTAP_TAPCELL_ROW_77_979 VGND VPWR sky130_fd_sc_hd__tapvpwrvgnd_1
XFILLER_19_344 VGND VGND VPWR VPWR sky130_fd_sc_hd__decap_4
XFILLER_46_152 VGND VGND VPWR VPWR sky130_fd_sc_hd__decap_3
XFILLER_61_111 VGND VGND VPWR VPWR sky130_fd_sc_hd__fill_1
X_2970_ net651 _1147_ net379 VGND VGND VPWR VPWR _1152_ sky130_fd_sc_hd__or3_4
XFILLER_15_561 VGND VGND VPWR VPWR sky130_fd_sc_hd__fill_1
XFILLER_22_509 VGND VGND VPWR VPWR sky130_fd_sc_hd__decap_3
XTAP_TAPCELL_ROW_60_802 VGND VPWR sky130_fd_sc_hd__tapvpwrvgnd_1
XFILLER_91_93 VPWR VGND VPWR VGND sky130_ef_sc_hd__decap_12
XFILLER_30_531 VGND VGND VPWR VPWR sky130_fd_sc_hd__fill_1
XTAP_TAPCELL_ROW_32_526 VGND VPWR sky130_fd_sc_hd__tapvpwrvgnd_1
X_4640_ clknet_leaf_30_clk _0171_ VGND VGND VPWR VPWR array\[13\]\[5\] sky130_fd_sc_hd__dfxtp_1
X_4571_ clknet_leaf_59_clk _0102_ VGND VGND VPWR VPWR array\[15\]\[0\] sky130_fd_sc_hd__dfxtp_1
X_3522_ net867 net249 _1533_ _1534_ VGND VGND VPWR VPWR _0271_ sky130_fd_sc_hd__o22a_1
X_3453_ net598 net477 net363 net672 net263 VGND VGND VPWR VPWR _1486_ sky130_fd_sc_hd__a221o_1
X_2404_ net984 net210 _0757_ VGND VGND VPWR VPWR _0510_ sky130_fd_sc_hd__o21a_1
X_3384_ net756 net757 net501 net477 _1437_ VGND VGND VPWR VPWR _1438_ sky130_fd_sc_hd__a311o_1
XFILLER_69_277 VGND VGND VPWR VPWR sky130_fd_sc_hd__decap_3
X_2335_ net757 net110 _0632_ VGND VGND VPWR VPWR _0709_ sky130_fd_sc_hd__or3_2
XFILLER_84_225 VGND VGND VPWR VPWR sky130_fd_sc_hd__fill_1
X_2266_ net925 net323 _0662_ VGND VGND VPWR VPWR _0467_ sky130_fd_sc_hd__o21a_1
XFILLER_84_269 VGND VGND VPWR VPWR sky130_fd_sc_hd__fill_2
X_2197_ net560 net561 VGND VGND VPWR VPWR _0607_ sky130_fd_sc_hd__nand2b_2
X_4005_ array\[14\]\[21\] net458 net441 array\[12\]\[21\] VGND VGND VPWR VPWR _1923_
+ sky130_fd_sc_hd__a22o_1
XTAP_TAPCELL_ROW_48_681 VGND VPWR sky130_fd_sc_hd__tapvpwrvgnd_1
XFILLER_40_317 VPWR VGND VPWR VGND sky130_ef_sc_hd__decap_12
X_4907_ clknet_leaf_17_clk _0438_ VGND VGND VPWR VPWR array\[6\]\[18\] sky130_fd_sc_hd__dfxtp_1
X_4838_ clknet_leaf_33_clk _0369_ VGND VGND VPWR VPWR net136 sky130_fd_sc_hd__dfxtp_1
X_4769_ clknet_leaf_63_clk _0300_ VGND VGND VPWR VPWR ready_check\[12\] sky130_fd_sc_hd__dfxtp_1
XFILLER_88_531 VGND VGND VPWR VPWR sky130_fd_sc_hd__fill_1
Xhold10 array\[13\]\[16\] VGND VGND VPWR VPWR net776 sky130_fd_sc_hd__dlygate4sd3_1
Xhold32 array\[13\]\[18\] VGND VGND VPWR VPWR net798 sky130_fd_sc_hd__dlygate4sd3_1
Xhold21 array\[13\]\[28\] VGND VGND VPWR VPWR net787 sky130_fd_sc_hd__dlygate4sd3_1
XFILLER_29_32 VPWR VGND VPWR VGND sky130_ef_sc_hd__decap_12
XFILLER_48_417 VGND VGND VPWR VPWR sky130_fd_sc_hd__decap_3
Xhold54 array\[13\]\[27\] VGND VGND VPWR VPWR net820 sky130_fd_sc_hd__dlygate4sd3_1
XFILLER_75_225 VGND VGND VPWR VPWR sky130_fd_sc_hd__fill_1
XFILLER_29_76 VGND VGND VPWR VPWR sky130_fd_sc_hd__fill_2
Xhold65 array\[13\]\[6\] VGND VGND VPWR VPWR net831 sky130_fd_sc_hd__dlygate4sd3_1
Xhold43 array\[14\]\[23\] VGND VGND VPWR VPWR net809 sky130_fd_sc_hd__dlygate4sd3_1
Xhold87 array\[6\]\[26\] VGND VGND VPWR VPWR net853 sky130_fd_sc_hd__dlygate4sd3_1
Xhold98 array\[15\]\[24\] VGND VGND VPWR VPWR net864 sky130_fd_sc_hd__dlygate4sd3_1
Xhold76 net120 VGND VGND VPWR VPWR net842 sky130_fd_sc_hd__dlygate4sd3_1
XFILLER_28_141 VGND VGND VPWR VPWR sky130_fd_sc_hd__fill_1
XTAP_TAPCELL_ROW_74_949 VGND VPWR sky130_fd_sc_hd__tapvpwrvgnd_1
XPHY_EDGE_ROW_11_Left_106 VGND VGND VPWR VPWR sky130_fd_sc_hd__decap_3
XFILLER_71_420 VPWR VGND VPWR VGND sky130_ef_sc_hd__decap_12
XFILLER_16_336 VGND VGND VPWR VPWR sky130_fd_sc_hd__decap_4
XFILLER_43_177 VGND VGND VPWR VPWR sky130_fd_sc_hd__fill_2
XFILLER_12_531 VGND VGND VPWR VPWR sky130_fd_sc_hd__fill_1
XFILLER_8_513 VPWR VGND VPWR VGND sky130_ef_sc_hd__decap_12
XFILLER_8_557 VGND VGND VPWR VPWR sky130_fd_sc_hd__decap_4
XPHY_EDGE_ROW_20_Left_115 VGND VGND VPWR VPWR sky130_fd_sc_hd__decap_3
XANTENNA_7 _0787_ VGND VGND VPWR VPWR sky130_fd_sc_hd__diode_2
XFILLER_3_273 VGND VGND VPWR VPWR sky130_fd_sc_hd__decap_6
XFILLER_79_553 VGND VGND VPWR VPWR sky130_fd_sc_hd__decap_6
XFILLER_20_6 VGND VGND VPWR VPWR sky130_fd_sc_hd__fill_2
XFILLER_94_545 VPWR VGND VPWR VGND sky130_ef_sc_hd__decap_12
XFILLER_19_185 VGND VGND VPWR VPWR sky130_fd_sc_hd__decap_3
XTAP_TAPCELL_ROW_45_651 VGND VPWR sky130_fd_sc_hd__tapvpwrvgnd_1
XTAP_TAPCELL_ROW_17_375 VGND VPWR sky130_fd_sc_hd__tapvpwrvgnd_1
XFILLER_22_317 VGND VGND VPWR VPWR sky130_fd_sc_hd__decap_4
X_2953_ net713 net272 _1135_ net385 net270 VGND VGND VPWR VPWR _1136_ sky130_fd_sc_hd__a221o_1
X_2884_ net701 net273 _1089_ net386 net270 VGND VGND VPWR VPWR _1090_ sky130_fd_sc_hd__a221o_1
X_4623_ clknet_leaf_8_clk _0154_ VGND VGND VPWR VPWR array\[14\]\[20\] sky130_fd_sc_hd__dfxtp_1
Xhold502 array\[4\]\[7\] VGND VGND VPWR VPWR net1268 sky130_fd_sc_hd__dlygate4sd3_1
X_4554_ clknet_leaf_38_clk _0085_ VGND VGND VPWR VPWR array\[0\]\[15\] sky130_fd_sc_hd__dfxtp_1
Xhold524 array\[8\]\[27\] VGND VGND VPWR VPWR net1290 sky130_fd_sc_hd__dlygate4sd3_1
Xhold535 array\[3\]\[22\] VGND VGND VPWR VPWR net1301 sky130_fd_sc_hd__dlygate4sd3_1
Xhold513 array\[11\]\[4\] VGND VGND VPWR VPWR net1279 sky130_fd_sc_hd__dlygate4sd3_1
X_3505_ net709 net247 VGND VGND VPWR VPWR _1523_ sky130_fd_sc_hd__and2_1
X_4485_ clknet_leaf_45_clk _0016_ VGND VGND VPWR VPWR array\[5\]\[10\] sky130_fd_sc_hd__dfxtp_1
Xhold546 array\[7\]\[7\] VGND VGND VPWR VPWR net1312 sky130_fd_sc_hd__dlygate4sd3_1
X_3436_ net1076 net262 _1473_ _1474_ VGND VGND VPWR VPWR _0245_ sky130_fd_sc_hd__o22a_1
X_3367_ net584 net484 net369 net660 net179 VGND VGND VPWR VPWR _1426_ sky130_fd_sc_hd__a221o_1
X_2318_ net659 net583 net524 VGND VGND VPWR VPWR _0697_ sky130_fd_sc_hd__mux2_1
XFILLER_57_203 VPWR VGND VPWR VGND sky130_ef_sc_hd__decap_12
X_3298_ net1231 net153 _1379_ _1380_ VGND VGND VPWR VPWR _0201_ sky130_fd_sc_hd__o22a_1
X_2249_ net639 net569 net521 VGND VGND VPWR VPWR _0651_ sky130_fd_sc_hd__mux2_1
XFILLER_82_29 VPWR VGND VPWR VGND sky130_ef_sc_hd__decap_12
XFILLER_25_111 VGND VGND VPWR VPWR sky130_fd_sc_hd__fill_1
XTAP_TAPCELL_ROW_84_1045 VGND VPWR sky130_fd_sc_hd__tapvpwrvgnd_1
XTAP_TAPCELL_ROW_71_919 VGND VPWR sky130_fd_sc_hd__tapvpwrvgnd_1
XFILLER_80_272 VGND VGND VPWR VPWR sky130_fd_sc_hd__fill_2
XFILLER_25_199 VGND VGND VPWR VPWR sky130_fd_sc_hd__fill_1
XFILLER_5_505 VPWR VGND VPWR VGND sky130_ef_sc_hd__decap_12
XFILLER_88_361 VGND VGND VPWR VPWR sky130_fd_sc_hd__decap_3
Xinput100 value2[7] VGND VGND VPWR VPWR net100 sky130_fd_sc_hd__buf_1
Xinput111 write_location2[0] VGND VGND VPWR VPWR net111 sky130_fd_sc_hd__dlymetal6s2s_1
XFILLER_76_512 VPWR VGND VPWR VGND sky130_ef_sc_hd__decap_12
XFILLER_36_409 VGND VGND VPWR VPWR sky130_fd_sc_hd__fill_1
XTAP_TAPCELL_ROW_59_798 VGND VPWR sky130_fd_sc_hd__tapvpwrvgnd_1
XFILLER_63_206 VGND VGND VPWR VPWR sky130_fd_sc_hd__decap_8
XFILLER_91_559 VGND VGND VPWR VPWR sky130_fd_sc_hd__fill_1
XFILLER_16_166 VGND VGND VPWR VPWR sky130_fd_sc_hd__fill_1
XFILLER_44_453 VGND VGND VPWR VPWR sky130_fd_sc_hd__decap_4
XFILLER_44_475 VGND VGND VPWR VPWR sky130_fd_sc_hd__fill_1
XFILLER_72_62 VGND VGND VPWR VPWR sky130_fd_sc_hd__decap_3
XTAP_TAPCELL_ROW_42_621 VGND VPWR sky130_fd_sc_hd__tapvpwrvgnd_1
XTAP_TAPCELL_ROW_14_345 VGND VPWR sky130_fd_sc_hd__tapvpwrvgnd_1
XFILLER_12_372 VGND VGND VPWR VPWR sky130_fd_sc_hd__decap_8
XFILLER_31_169 VGND VGND VPWR VPWR sky130_fd_sc_hd__decap_3
X_4270_ net760 net430 net334 net631 net224 VGND VGND VPWR VPWR _2130_ sky130_fd_sc_hd__a221o_1
X_3221_ net620 net487 net183 net765 _1326_ VGND VGND VPWR VPWR _1327_ sky130_fd_sc_hd__a221o_1
XFILLER_39_225 VGND VGND VPWR VPWR sky130_fd_sc_hd__decap_6
X_3152_ net730 net187 _1277_ net191 VGND VGND VPWR VPWR _1278_ sky130_fd_sc_hd__a211o_1
X_3083_ net740 net185 _1231_ net189 VGND VGND VPWR VPWR _1232_ sky130_fd_sc_hd__a211o_1
XFILLER_50_434 VGND VGND VPWR VPWR sky130_fd_sc_hd__fill_2
X_3985_ array\[9\]\[19\] net550 net526 array\[11\]\[19\] _1904_ VGND VGND VPWR VPWR
+ _1905_ sky130_fd_sc_hd__a221o_1
XFILLER_10_309 VGND VGND VPWR VPWR sky130_fd_sc_hd__decap_3
X_2936_ net1096 net201 _1124_ VGND VGND VPWR VPWR _0095_ sky130_fd_sc_hd__o21a_1
X_2867_ net1284 net200 _1078_ VGND VGND VPWR VPWR _0072_ sky130_fd_sc_hd__o21a_1
X_4606_ clknet_leaf_8_clk _0137_ VGND VGND VPWR VPWR array\[14\]\[3\] sky130_fd_sc_hd__dfxtp_1
X_2798_ net764 net280 VGND VGND VPWR VPWR _1032_ sky130_fd_sc_hd__and2_1
Xhold310 array\[11\]\[15\] VGND VGND VPWR VPWR net1076 sky130_fd_sc_hd__dlygate4sd3_1
Xhold332 array\[9\]\[9\] VGND VGND VPWR VPWR net1098 sky130_fd_sc_hd__dlygate4sd3_1
Xhold321 array\[15\]\[25\] VGND VGND VPWR VPWR net1087 sky130_fd_sc_hd__dlygate4sd3_1
Xhold343 array\[3\]\[2\] VGND VGND VPWR VPWR net1109 sky130_fd_sc_hd__dlygate4sd3_1
X_4537_ clknet_leaf_19_clk _0068_ VGND VGND VPWR VPWR array\[8\]\[30\] sky130_fd_sc_hd__dfxtp_1
XFILLER_89_125 VPWR VGND VPWR VGND sky130_ef_sc_hd__decap_12
XFILLER_77_18 VPWR VGND VPWR VGND sky130_ef_sc_hd__decap_12
Xhold376 array\[7\]\[24\] VGND VGND VPWR VPWR net1142 sky130_fd_sc_hd__dlygate4sd3_1
Xhold354 array\[3\]\[29\] VGND VGND VPWR VPWR net1120 sky130_fd_sc_hd__dlygate4sd3_1
X_4468_ clknet_leaf_41_clk _0579_ VGND VGND VPWR VPWR array\[4\]\[25\] sky130_fd_sc_hd__dfxtp_1
Xhold365 array\[0\]\[14\] VGND VGND VPWR VPWR net1131 sky130_fd_sc_hd__dlygate4sd3_1
Xhold387 array\[2\]\[15\] VGND VGND VPWR VPWR net1153 sky130_fd_sc_hd__dlygate4sd3_1
XFILLER_89_169 VGND VGND VPWR VPWR sky130_fd_sc_hd__decap_4
X_3419_ net623 net479 net365 net695 VGND VGND VPWR VPWR _1463_ sky130_fd_sc_hd__a22o_1
Xhold398 array\[10\]\[1\] VGND VGND VPWR VPWR net1164 sky130_fd_sc_hd__dlygate4sd3_1
X_4399_ clknet_leaf_8_clk _0510_ VGND VGND VPWR VPWR array\[2\]\[20\] sky130_fd_sc_hd__dfxtp_1
XFILLER_93_39 VPWR VGND VPWR VGND sky130_ef_sc_hd__decap_12
XFILLER_85_386 VGND VGND VPWR VPWR sky130_fd_sc_hd__decap_6
XFILLER_45_239 VGND VGND VPWR VPWR sky130_fd_sc_hd__fill_1
XFILLER_26_55 VGND VGND VPWR VPWR sky130_fd_sc_hd__fill_1
XTAP_TAPCELL_ROW_56_768 VGND VPWR sky130_fd_sc_hd__tapvpwrvgnd_1
XFILLER_26_497 VGND VGND VPWR VPWR sky130_fd_sc_hd__fill_2
XFILLER_41_401 VGND VGND VPWR VPWR sky130_fd_sc_hd__decap_3
XTAP_TAPCELL_ROW_11_315 VGND VPWR sky130_fd_sc_hd__tapvpwrvgnd_1
XFILLER_5_335 VGND VGND VPWR VPWR sky130_fd_sc_hd__fill_1
XFILLER_68_309 VPWR VGND VPWR VGND sky130_ef_sc_hd__decap_12
XFILLER_1_541 VPWR VGND VPWR VGND sky130_ef_sc_hd__decap_12
XFILLER_3_15 VPWR VGND VPWR VGND sky130_ef_sc_hd__decap_12
XFILLER_3_37 VGND VGND VPWR VPWR sky130_fd_sc_hd__decap_8
XFILLER_76_320 VGND VGND VPWR VPWR sky130_fd_sc_hd__decap_4
XFILLER_17_486 VGND VGND VPWR VPWR sky130_fd_sc_hd__decap_4
XTAP_TAPCELL_ROW_27_470 VGND VPWR sky130_fd_sc_hd__tapvpwrvgnd_1
XFILLER_44_294 VGND VGND VPWR VPWR sky130_fd_sc_hd__decap_6
X_3770_ array\[5\]\[0\] net544 net527 array\[7\]\[0\] _1708_ VGND VGND VPWR VPWR _1709_
+ sky130_fd_sc_hd__a221o_1
X_2721_ net879 _0978_ net294 VGND VGND VPWR VPWR _0026_ sky130_fd_sc_hd__mux2_1
X_2652_ _0630_ _0856_ VGND VGND VPWR VPWR _0930_ sky130_fd_sc_hd__nor2_1
X_2583_ net760 net512 net398 net631 VGND VGND VPWR VPWR _0885_ sky130_fd_sc_hd__a22o_1
X_4322_ net583 net430 net334 net659 net224 VGND VGND VPWR VPWR _2163_ sky130_fd_sc_hd__a221o_1
X_4253_ net577 net429 net333 net647 net223 VGND VGND VPWR VPWR _2119_ sky130_fd_sc_hd__a221o_1
X_3204_ net831 _1315_ net159 VGND VGND VPWR VPWR _0172_ sky130_fd_sc_hd__mux2_1
X_4184_ net619 net432 net340 net691 VGND VGND VPWR VPWR _2072_ sky130_fd_sc_hd__a22o_1
X_3135_ net1166 net164 _1266_ VGND VGND VPWR VPWR _0152_ sky130_fd_sc_hd__o21a_1
X_3066_ net714 net194 _1216_ net380 VGND VGND VPWR VPWR _1217_ sky130_fd_sc_hd__a22o_1
XTAP_TAPCELL_ROW_81_1015 VGND VPWR sky130_fd_sc_hd__tapvpwrvgnd_1
XTAP_TAPCELL_ROW_53_738 VGND VPWR sky130_fd_sc_hd__tapvpwrvgnd_1
X_3968_ net781 net172 _1888_ _1889_ VGND VGND VPWR VPWR _0362_ sky130_fd_sc_hd__o22a_1
X_2919_ net599 net673 net497 VGND VGND VPWR VPWR _1113_ sky130_fd_sc_hd__mux2_1
X_3899_ net437 _1820_ _1824_ net355 VGND VGND VPWR VPWR _1827_ sky130_fd_sc_hd__a22o_1
XFILLER_12_79 VGND VGND VPWR VPWR sky130_fd_sc_hd__decap_4
XFILLER_2_305 VGND VGND VPWR VPWR sky130_fd_sc_hd__decap_3
XTAP_TAPCELL_ROW_92_1122 VGND VPWR sky130_fd_sc_hd__tapvpwrvgnd_1
Xhold140 array\[10\]\[28\] VGND VGND VPWR VPWR net906 sky130_fd_sc_hd__dlygate4sd3_1
Xhold162 array\[1\]\[10\] VGND VGND VPWR VPWR net928 sky130_fd_sc_hd__dlygate4sd3_1
Xhold151 array\[7\]\[4\] VGND VGND VPWR VPWR net917 sky130_fd_sc_hd__dlygate4sd3_1
Xhold195 array\[5\]\[18\] VGND VGND VPWR VPWR net961 sky130_fd_sc_hd__dlygate4sd3_1
Xhold184 array\[15\]\[13\] VGND VGND VPWR VPWR net950 sky130_fd_sc_hd__dlygate4sd3_1
Xhold173 array\[11\]\[27\] VGND VGND VPWR VPWR net939 sky130_fd_sc_hd__dlygate4sd3_1
Xfanout620 net74 VGND VGND VPWR VPWR net620 sky130_fd_sc_hd__dlymetal6s2s_1
Xfanout631 net69 VGND VGND VPWR VPWR net631 sky130_fd_sc_hd__buf_2
Xfanout642 net64 VGND VGND VPWR VPWR net642 sky130_fd_sc_hd__clkbuf_2
Xfanout653 net656 VGND VGND VPWR VPWR net653 sky130_fd_sc_hd__buf_2
Xfanout664 net56 VGND VGND VPWR VPWR net664 sky130_fd_sc_hd__dlymetal6s2s_1
Xfanout675 net676 VGND VGND VPWR VPWR net675 sky130_fd_sc_hd__buf_2
XFILLER_58_331 VGND VGND VPWR VPWR sky130_fd_sc_hd__fill_1
XFILLER_92_109 VPWR VGND VPWR VGND sky130_ef_sc_hd__decap_12
Xfanout697 net39 VGND VGND VPWR VPWR net697 sky130_fd_sc_hd__buf_2
Xfanout686 net45 VGND VGND VPWR VPWR net686 sky130_fd_sc_hd__clkbuf_2
XFILLER_73_323 VGND VGND VPWR VPWR sky130_fd_sc_hd__fill_2
XTAP_TAPCELL_ROW_69_893 VGND VPWR sky130_fd_sc_hd__tapvpwrvgnd_1
XFILLER_18_217 VPWR VGND VPWR VGND sky130_ef_sc_hd__decap_12
XFILLER_14_489 VGND VGND VPWR VPWR sky130_fd_sc_hd__decap_4
XTAP_TAPCELL_ROW_24_440 VGND VPWR sky130_fd_sc_hd__tapvpwrvgnd_1
XFILLER_53_86 VGND VGND VPWR VPWR sky130_fd_sc_hd__fill_2
XFILLER_5_110 VGND VGND VPWR VPWR sky130_fd_sc_hd__fill_2
XFILLER_78_94 VGND VGND VPWR VPWR sky130_fd_sc_hd__fill_1
XFILLER_1_393 VPWR VGND VPWR VGND sky130_ef_sc_hd__decap_12
XFILLER_64_389 VGND VGND VPWR VPWR sky130_fd_sc_hd__decap_4
X_4871_ clknet_leaf_3_clk _0402_ VGND VGND VPWR VPWR array\[7\]\[14\] sky130_fd_sc_hd__dfxtp_1
X_3822_ array\[14\]\[5\] net471 net454 array\[12\]\[5\] VGND VGND VPWR VPWR _1756_
+ sky130_fd_sc_hd__a22o_1
XTAP_TAPCELL_ROW_50_708 VGND VPWR sky130_fd_sc_hd__tapvpwrvgnd_1
X_3753_ net721 net349 net421 VGND VGND VPWR VPWR _1696_ sky130_fd_sc_hd__and3_1
X_3684_ net709 net349 net421 VGND VGND VPWR VPWR _1651_ sky130_fd_sc_hd__and3_1
X_2704_ net685 net613 net394 VGND VGND VPWR VPWR _0967_ sky130_fd_sc_hd__mux2_1
X_2635_ net725 net400 net507 VGND VGND VPWR VPWR _0919_ sky130_fd_sc_hd__and3_1
X_4305_ net736 net335 VGND VGND VPWR VPWR _2152_ sky130_fd_sc_hd__and2_1
X_2566_ net577 net511 net397 net647 VGND VGND VPWR VPWR _0874_ sky130_fd_sc_hd__a22o_1
X_2497_ net748 net307 _0822_ net404 net311 VGND VGND VPWR VPWR _0823_ sky130_fd_sc_hd__a221o_1
X_4236_ net1138 net226 _2105_ _2106_ VGND VGND VPWR VPWR _0417_ sky130_fd_sc_hd__o22a_1
X_4167_ net706 net234 VGND VGND VPWR VPWR _2061_ sky130_fd_sc_hd__and2_1
X_3118_ net617 net490 net378 net689 VGND VGND VPWR VPWR _1255_ sky130_fd_sc_hd__a22o_1
XFILLER_82_153 VGND VGND VPWR VPWR sky130_fd_sc_hd__fill_2
XTAP_TAPCELL_ROW_66_863 VGND VPWR sky130_fd_sc_hd__tapvpwrvgnd_1
X_4098_ array\[1\]\[29\] net550 net529 array\[3\]\[29\] _2007_ VGND VGND VPWR VPWR
+ _2008_ sky130_fd_sc_hd__a221o_1
XFILLER_55_345 VGND VGND VPWR VPWR sky130_fd_sc_hd__fill_2
XFILLER_82_175 VGND VGND VPWR VPWR sky130_fd_sc_hd__decap_4
XFILLER_82_164 VGND VGND VPWR VPWR sky130_fd_sc_hd__decap_4
X_3049_ net1087 _1205_ net166 VGND VGND VPWR VPWR _0127_ sky130_fd_sc_hd__mux2_1
XTAP_TAPCELL_ROW_38_587 VGND VPWR sky130_fd_sc_hd__tapvpwrvgnd_1
XFILLER_55_389 VGND VGND VPWR VPWR sky130_fd_sc_hd__decap_3
XFILLER_90_29 VPWR VGND VPWR VGND sky130_ef_sc_hd__decap_12
XTAP_TAPCELL_ROW_21_410 VGND VPWR sky130_fd_sc_hd__tapvpwrvgnd_1
Xfanout450 net455 VGND VGND VPWR VPWR net450 sky130_fd_sc_hd__clkbuf_4
XFILLER_93_429 VGND VGND VPWR VPWR sky130_fd_sc_hd__decap_4
Xfanout483 _1368_ VGND VGND VPWR VPWR net483 sky130_fd_sc_hd__buf_4
Xfanout472 _1588_ VGND VGND VPWR VPWR net472 sky130_fd_sc_hd__clkbuf_4
Xfanout461 net463 VGND VGND VPWR VPWR net461 sky130_fd_sc_hd__clkbuf_4
Xfanout494 _1149_ VGND VGND VPWR VPWR net494 sky130_fd_sc_hd__buf_2
XFILLER_46_301 VGND VGND VPWR VPWR sky130_fd_sc_hd__decap_6
XFILLER_48_97 VPWR VGND VPWR VGND sky130_ef_sc_hd__decap_12
XFILLER_0_27 VGND VGND VPWR VPWR sky130_fd_sc_hd__fill_1
XFILLER_46_389 VGND VGND VPWR VPWR sky130_fd_sc_hd__decap_8
XFILLER_61_304 VGND VGND VPWR VPWR sky130_fd_sc_hd__decap_3
XFILLER_61_337 VGND VGND VPWR VPWR sky130_fd_sc_hd__decap_3
XFILLER_9_47 VGND VGND VPWR VPWR sky130_fd_sc_hd__decap_8
XPHY_EDGE_ROW_94_Left_189 VGND VGND VPWR VPWR sky130_fd_sc_hd__decap_3
X_2420_ net587 net661 net519 VGND VGND VPWR VPWR _0768_ sky130_fd_sc_hd__mux2_1
XFILLER_89_93 VPWR VGND VPWR VGND sky130_ef_sc_hd__decap_12
X_2351_ net571 net641 net520 VGND VGND VPWR VPWR _0722_ sky130_fd_sc_hd__mux2_1
XTAP_TAPCELL_ROW_9_290 VGND VPWR sky130_fd_sc_hd__tapvpwrvgnd_1
X_2282_ net685 net613 net524 VGND VGND VPWR VPWR _0673_ sky130_fd_sc_hd__mux2_1
X_4021_ array\[2\]\[22\] net457 net440 array\[0\]\[22\] VGND VGND VPWR VPWR _1938_
+ sky130_fd_sc_hd__a22o_1
XFILLER_52_304 VGND VGND VPWR VPWR sky130_fd_sc_hd__decap_4
XTAP_TAPCELL_ROW_63_833 VGND VPWR sky130_fd_sc_hd__tapvpwrvgnd_1
XTAP_TAPCELL_ROW_35_557 VGND VPWR sky130_fd_sc_hd__tapvpwrvgnd_1
X_4854_ clknet_leaf_62_clk _0385_ VGND VGND VPWR VPWR net152 sky130_fd_sc_hd__dfxtp_1
X_3805_ array\[1\]\[3\] net546 net534 array\[3\]\[3\] _1740_ VGND VGND VPWR VPWR _1741_
+ sky130_fd_sc_hd__a221o_1
X_4785_ clknet_leaf_3_clk _0316_ VGND VGND VPWR VPWR array\[9\]\[3\] sky130_fd_sc_hd__dfxtp_1
X_3736_ net595 net423 net344 net669 net241 VGND VGND VPWR VPWR _1685_ sky130_fd_sc_hd__a221o_1
X_3667_ _0931_ net501 net423 net419 VGND VGND VPWR VPWR _1638_ sky130_fd_sc_hd__a211o_1
X_3598_ tail\[3\] _1581_ VGND VGND VPWR VPWR _1585_ sky130_fd_sc_hd__nand2_1
X_2618_ net737 net400 net507 VGND VGND VPWR VPWR _0908_ sky130_fd_sc_hd__and3_1
X_2549_ net653 net1 net109 net4 VGND VGND VPWR VPWR _0859_ sky130_fd_sc_hd__and4b_1
X_4219_ net592 net434 net343 net666 VGND VGND VPWR VPWR _2095_ sky130_fd_sc_hd__a22o_1
XFILLER_18_34 VGND VGND VPWR VPWR sky130_fd_sc_hd__fill_1
XFILLER_55_120 VGND VGND VPWR VPWR sky130_fd_sc_hd__decap_3
XTAP_TAPCELL_ROW_87_1076 VGND VPWR sky130_fd_sc_hd__tapvpwrvgnd_1
XFILLER_83_484 VGND VGND VPWR VPWR sky130_fd_sc_hd__decap_4
XFILLER_43_337 VGND VGND VPWR VPWR sky130_fd_sc_hd__decap_4
XFILLER_51_370 VGND VGND VPWR VPWR sky130_fd_sc_hd__decap_6
XFILLER_11_245 VGND VGND VPWR VPWR sky130_fd_sc_hd__fill_1
XFILLER_50_54 VGND VGND VPWR VPWR sky130_fd_sc_hd__fill_2
XFILLER_50_65 VGND VGND VPWR VPWR sky130_fd_sc_hd__fill_2
XFILLER_59_30 VGND VGND VPWR VPWR sky130_fd_sc_hd__decap_4
XTAP_TAPCELL_ROW_6_260 VGND VPWR sky130_fd_sc_hd__tapvpwrvgnd_1
Xfanout291 net292 VGND VGND VPWR VPWR net291 sky130_fd_sc_hd__clkbuf_4
Xfanout280 net281 VGND VGND VPWR VPWR net280 sky130_fd_sc_hd__buf_2
XFILLER_93_248 VGND VGND VPWR VPWR sky130_fd_sc_hd__fill_2
XFILLER_34_337 VGND VGND VPWR VPWR sky130_fd_sc_hd__decap_4
XFILLER_15_540 VPWR VGND VPWR VGND sky130_ef_sc_hd__decap_12
XTAP_TAPCELL_ROW_60_803 VGND VPWR sky130_fd_sc_hd__tapvpwrvgnd_1
XTAP_TAPCELL_ROW_32_527 VGND VPWR sky130_fd_sc_hd__tapvpwrvgnd_1
X_4570_ clknet_leaf_41_clk _0101_ VGND VGND VPWR VPWR array\[0\]\[31\] sky130_fd_sc_hd__dfxtp_1
X_3521_ net758 net476 net359 net627 net254 VGND VGND VPWR VPWR _1534_ sky130_fd_sc_hd__a221o_1
XFILLER_6_282 VGND VGND VPWR VPWR sky130_fd_sc_hd__fill_1
X_3452_ net736 net255 VGND VGND VPWR VPWR _1485_ sky130_fd_sc_hd__and2_1
X_3383_ _0591_ _0784_ _1004_ VGND VGND VPWR VPWR _1437_ sky130_fd_sc_hd__and3_1
X_2403_ net737 net315 _0756_ net407 _0715_ VGND VGND VPWR VPWR _0757_ sky130_fd_sc_hd__a221o_1
X_2334_ net753 _0628_ _0707_ VGND VGND VPWR VPWR _0708_ sky130_fd_sc_hd__or3b_1
X_2265_ net699 net319 _0661_ net410 net327 VGND VGND VPWR VPWR _0662_ sky130_fd_sc_hd__a221o_1
XFILLER_57_429 VGND VGND VPWR VPWR sky130_fd_sc_hd__decap_4
X_2196_ net560 net561 VGND VGND VPWR VPWR _0606_ sky130_fd_sc_hd__and2b_2
X_4004_ array\[1\]\[21\] net545 net527 array\[3\]\[21\] _1921_ VGND VGND VPWR VPWR
+ _1922_ sky130_fd_sc_hd__a221o_1
XFILLER_1_70 VGND VGND VPWR VPWR sky130_fd_sc_hd__fill_1
XFILLER_25_304 VGND VGND VPWR VPWR sky130_fd_sc_hd__fill_1
XTAP_TAPCELL_ROW_48_682 VGND VPWR sky130_fd_sc_hd__tapvpwrvgnd_1
XFILLER_52_123 VGND VGND VPWR VPWR sky130_fd_sc_hd__fill_1
X_4906_ clknet_leaf_23_clk _0437_ VGND VGND VPWR VPWR array\[6\]\[17\] sky130_fd_sc_hd__dfxtp_1
XFILLER_40_329 VPWR VGND VPWR VGND sky130_ef_sc_hd__decap_12
X_4837_ clknet_leaf_33_clk _0368_ VGND VGND VPWR VPWR net135 sky130_fd_sc_hd__dfxtp_1
X_4768_ clknet_leaf_64_clk _0299_ VGND VGND VPWR VPWR ready_check\[13\] sky130_fd_sc_hd__dfxtp_1
X_3719_ net611 net425 net347 net683 VGND VGND VPWR VPWR _1674_ sky130_fd_sc_hd__a22o_1
X_4699_ clknet_leaf_57_clk _0230_ VGND VGND VPWR VPWR array\[11\]\[0\] sky130_fd_sc_hd__dfxtp_1
Xhold22 net138 VGND VGND VPWR VPWR net788 sky130_fd_sc_hd__dlygate4sd3_1
Xhold11 array\[13\]\[11\] VGND VGND VPWR VPWR net777 sky130_fd_sc_hd__dlygate4sd3_1
XFILLER_0_447 VGND VGND VPWR VPWR sky130_fd_sc_hd__fill_1
XFILLER_29_44 VGND VGND VPWR VPWR sky130_fd_sc_hd__decap_4
Xhold44 array\[5\]\[12\] VGND VGND VPWR VPWR net810 sky130_fd_sc_hd__dlygate4sd3_1
Xhold55 net121 VGND VGND VPWR VPWR net821 sky130_fd_sc_hd__dlygate4sd3_1
Xhold33 array\[5\]\[15\] VGND VGND VPWR VPWR net799 sky130_fd_sc_hd__dlygate4sd3_1
Xhold99 array\[1\]\[3\] VGND VGND VPWR VPWR net865 sky130_fd_sc_hd__dlygate4sd3_1
Xhold77 net134 VGND VGND VPWR VPWR net843 sky130_fd_sc_hd__dlygate4sd3_1
Xhold66 net151 VGND VGND VPWR VPWR net832 sky130_fd_sc_hd__dlygate4sd3_1
XTAP_TAPCELL_ROW_3_230 VGND VPWR sky130_fd_sc_hd__tapvpwrvgnd_1
Xhold88 array\[12\]\[6\] VGND VGND VPWR VPWR net854 sky130_fd_sc_hd__dlygate4sd3_1
XFILLER_71_432 VPWR VGND VPWR VGND sky130_ef_sc_hd__decap_12
XFILLER_28_197 VGND VGND VPWR VPWR sky130_fd_sc_hd__fill_2
XFILLER_8_525 VGND VGND VPWR VPWR sky130_fd_sc_hd__decap_6
XFILLER_6_15 VPWR VGND VPWR VGND sky130_ef_sc_hd__decap_12
XANTENNA_8 _0862_ VGND VGND VPWR VPWR sky130_fd_sc_hd__diode_2
XFILLER_86_83 VGND VGND VPWR VPWR sky130_fd_sc_hd__fill_1
XFILLER_66_215 VGND VGND VPWR VPWR sky130_fd_sc_hd__decap_3
XFILLER_94_557 VGND VGND VPWR VPWR sky130_fd_sc_hd__decap_3
XFILLER_81_229 VGND VGND VPWR VPWR sky130_fd_sc_hd__fill_1
XFILLER_62_432 VGND VGND VPWR VPWR sky130_fd_sc_hd__decap_6
XFILLER_34_167 VGND VGND VPWR VPWR sky130_fd_sc_hd__fill_2
XTAP_TAPCELL_ROW_45_652 VGND VPWR sky130_fd_sc_hd__tapvpwrvgnd_1
XFILLER_62_454 VGND VGND VPWR VPWR sky130_fd_sc_hd__fill_1
XFILLER_15_370 VGND VGND VPWR VPWR sky130_fd_sc_hd__decap_3
XTAP_TAPCELL_ROW_17_376 VGND VPWR sky130_fd_sc_hd__tapvpwrvgnd_1
X_2952_ net573 net643 net498 VGND VGND VPWR VPWR _1135_ sky130_fd_sc_hd__mux2_1
X_2883_ net760 net631 net499 VGND VGND VPWR VPWR _1089_ sky130_fd_sc_hd__mux2_1
X_4622_ clknet_leaf_58_clk _0153_ VGND VGND VPWR VPWR array\[14\]\[19\] sky130_fd_sc_hd__dfxtp_1
X_4553_ clknet_leaf_1_clk _0084_ VGND VGND VPWR VPWR array\[0\]\[14\] sky130_fd_sc_hd__dfxtp_1
Xhold536 array\[2\]\[7\] VGND VGND VPWR VPWR net1302 sky130_fd_sc_hd__dlygate4sd3_1
Xhold514 array\[6\]\[9\] VGND VGND VPWR VPWR net1280 sky130_fd_sc_hd__dlygate4sd3_1
X_4484_ clknet_leaf_40_clk _0015_ VGND VGND VPWR VPWR array\[5\]\[9\] sky130_fd_sc_hd__dfxtp_1
X_3504_ net1000 net250 _1521_ _1522_ VGND VGND VPWR VPWR _0265_ sky130_fd_sc_hd__o22a_1
Xhold525 array\[6\]\[15\] VGND VGND VPWR VPWR net1291 sky130_fd_sc_hd__dlygate4sd3_1
Xhold503 array\[9\]\[30\] VGND VGND VPWR VPWR net1269 sky130_fd_sc_hd__dlygate4sd3_1
Xhold547 array\[3\]\[21\] VGND VGND VPWR VPWR net1313 sky130_fd_sc_hd__dlygate4sd3_1
X_3435_ net613 net480 net366 net685 net266 VGND VGND VPWR VPWR _1474_ sky130_fd_sc_hd__a221o_1
X_3366_ net724 net175 VGND VGND VPWR VPWR _1425_ sky130_fd_sc_hd__and2_1
X_2317_ net953 net326 _0696_ VGND VGND VPWR VPWR _0484_ sky130_fd_sc_hd__o21a_1
X_3297_ net571 net481 net367 net641 net177 VGND VGND VPWR VPWR _1380_ sky130_fd_sc_hd__a221o_1
XFILLER_57_215 VGND VGND VPWR VPWR sky130_fd_sc_hd__fill_2
X_2248_ net865 net325 _0650_ VGND VGND VPWR VPWR _0461_ sky130_fd_sc_hd__o21a_1
XFILLER_72_218 VGND VGND VPWR VPWR sky130_fd_sc_hd__decap_8
XTAP_TAPCELL_ROW_0_200 VGND VPWR sky130_fd_sc_hd__tapvpwrvgnd_1
XFILLER_38_473 VGND VGND VPWR VPWR sky130_fd_sc_hd__decap_3
XFILLER_65_281 VGND VGND VPWR VPWR sky130_fd_sc_hd__fill_1
X_2179_ net110 VGND VGND VPWR VPWR _0590_ sky130_fd_sc_hd__inv_2
XTAP_TAPCELL_ROW_84_1046 VGND VPWR sky130_fd_sc_hd__tapvpwrvgnd_1
XFILLER_15_35 VGND VGND VPWR VPWR sky130_fd_sc_hd__fill_1
XFILLER_40_159 VGND VGND VPWR VPWR sky130_fd_sc_hd__decap_4
XFILLER_5_517 VPWR VGND VPWR VGND sky130_ef_sc_hd__decap_12
Xinput101 value2[8] VGND VGND VPWR VPWR net101 sky130_fd_sc_hd__buf_1
XFILLER_0_244 VGND VGND VPWR VPWR sky130_fd_sc_hd__decap_8
XFILLER_88_373 VGND VGND VPWR VPWR sky130_fd_sc_hd__fill_2
XFILLER_0_266 VGND VGND VPWR VPWR sky130_fd_sc_hd__decap_3
Xinput112 write_location2[1] VGND VGND VPWR VPWR net112 sky130_fd_sc_hd__dlymetal6s2s_1
XFILLER_48_248 VGND VGND VPWR VPWR sky130_fd_sc_hd__decap_4
XFILLER_91_505 VPWR VGND VPWR VGND sky130_ef_sc_hd__decap_12
XFILLER_29_484 VGND VGND VPWR VPWR sky130_fd_sc_hd__decap_4
XTAP_TAPCELL_ROW_59_799 VGND VPWR sky130_fd_sc_hd__tapvpwrvgnd_1
XFILLER_31_104 VGND VGND VPWR VPWR sky130_fd_sc_hd__fill_2
XTAP_TAPCELL_ROW_42_622 VGND VPWR sky130_fd_sc_hd__tapvpwrvgnd_1
XFILLER_72_85 VPWR VGND VPWR VGND sky130_ef_sc_hd__decap_12
XFILLER_72_74 VGND VGND VPWR VPWR sky130_fd_sc_hd__decap_8
XTAP_TAPCELL_ROW_14_346 VGND VPWR sky130_fd_sc_hd__tapvpwrvgnd_1
XFILLER_4_561 VGND VGND VPWR VPWR sky130_fd_sc_hd__fill_1
X_3220_ net692 net373 VGND VGND VPWR VPWR _1326_ sky130_fd_sc_hd__and2_1
X_3151_ net592 net492 net377 net666 VGND VGND VPWR VPWR _1277_ sky130_fd_sc_hd__a22o_1
XFILLER_11_3 VGND VGND VPWR VPWR sky130_fd_sc_hd__decap_8
X_3082_ net602 net489 net375 net676 VGND VGND VPWR VPWR _1231_ sky130_fd_sc_hd__a22o_1
XFILLER_47_270 VGND VGND VPWR VPWR sky130_fd_sc_hd__decap_8
XFILLER_35_465 VGND VGND VPWR VPWR sky130_fd_sc_hd__fill_2
XFILLER_35_487 VGND VGND VPWR VPWR sky130_fd_sc_hd__fill_1
X_3984_ array\[10\]\[19\] net456 net439 array\[8\]\[19\] VGND VGND VPWR VPWR _1904_
+ sky130_fd_sc_hd__a22o_1
XFILLER_50_457 VGND VGND VPWR VPWR sky130_fd_sc_hd__decap_4
X_2935_ net727 net272 _1123_ net385 net269 VGND VGND VPWR VPWR _1124_ sky130_fd_sc_hd__a221o_1
X_2866_ net717 net272 _1077_ net385 net269 VGND VGND VPWR VPWR _1078_ sky130_fd_sc_hd__a221o_1
XFILLER_30_192 VGND VGND VPWR VPWR sky130_fd_sc_hd__decap_4
X_4605_ clknet_leaf_43_clk _0136_ VGND VGND VPWR VPWR array\[14\]\[2\] sky130_fd_sc_hd__dfxtp_1
Xhold311 array\[1\]\[18\] VGND VGND VPWR VPWR net1077 sky130_fd_sc_hd__dlygate4sd3_1
Xhold300 array\[4\]\[5\] VGND VGND VPWR VPWR net1066 sky130_fd_sc_hd__dlygate4sd3_1
X_2797_ net972 net283 _1030_ _1031_ VGND VGND VPWR VPWR _0049_ sky130_fd_sc_hd__o22a_1
Xhold322 array\[3\]\[13\] VGND VGND VPWR VPWR net1088 sky130_fd_sc_hd__dlygate4sd3_1
X_4536_ clknet_leaf_51_clk _0067_ VGND VGND VPWR VPWR array\[8\]\[29\] sky130_fd_sc_hd__dfxtp_1
Xhold333 array\[2\]\[4\] VGND VGND VPWR VPWR net1099 sky130_fd_sc_hd__dlygate4sd3_1
Xhold344 array\[7\]\[20\] VGND VGND VPWR VPWR net1110 sky130_fd_sc_hd__dlygate4sd3_1
XFILLER_89_137 VGND VGND VPWR VPWR sky130_fd_sc_hd__decap_8
Xhold366 array\[2\]\[0\] VGND VGND VPWR VPWR net1132 sky130_fd_sc_hd__dlygate4sd3_1
Xhold355 array\[2\]\[31\] VGND VGND VPWR VPWR net1121 sky130_fd_sc_hd__dlygate4sd3_1
Xhold377 array\[7\]\[30\] VGND VGND VPWR VPWR net1143 sky130_fd_sc_hd__dlygate4sd3_1
X_4467_ clknet_leaf_36_clk _0578_ VGND VGND VPWR VPWR array\[4\]\[24\] sky130_fd_sc_hd__dfxtp_1
Xhold399 array\[14\]\[16\] VGND VGND VPWR VPWR net1165 sky130_fd_sc_hd__dlygate4sd3_1
X_3418_ net1209 net261 _1461_ _1462_ VGND VGND VPWR VPWR _0239_ sky130_fd_sc_hd__o22a_1
X_4398_ clknet_leaf_56_clk _0509_ VGND VGND VPWR VPWR array\[2\]\[19\] sky130_fd_sc_hd__dfxtp_1
Xhold388 array\[6\]\[7\] VGND VGND VPWR VPWR net1154 sky130_fd_sc_hd__dlygate4sd3_1
X_3349_ net597 net481 net367 net671 net177 VGND VGND VPWR VPWR _1414_ sky130_fd_sc_hd__a221o_1
XFILLER_73_549 VGND VGND VPWR VPWR sky130_fd_sc_hd__fill_1
XFILLER_53_240 VGND VGND VPWR VPWR sky130_fd_sc_hd__decap_3
XTAP_TAPCELL_ROW_56_769 VGND VPWR sky130_fd_sc_hd__tapvpwrvgnd_1
XFILLER_53_251 VGND VGND VPWR VPWR sky130_fd_sc_hd__fill_2
XFILLER_53_273 VGND VGND VPWR VPWR sky130_fd_sc_hd__fill_1
XTAP_TAPCELL_ROW_11_316 VGND VPWR sky130_fd_sc_hd__tapvpwrvgnd_1
XFILLER_1_553 VGND VGND VPWR VPWR sky130_fd_sc_hd__decap_6
XFILLER_3_27 VGND VGND VPWR VPWR sky130_fd_sc_hd__decap_6
XFILLER_88_192 VGND VGND VPWR VPWR sky130_fd_sc_hd__decap_4
XFILLER_36_207 VGND VGND VPWR VPWR sky130_fd_sc_hd__decap_4
XFILLER_83_51 VGND VGND VPWR VPWR sky130_fd_sc_hd__decap_4
XFILLER_17_443 VGND VGND VPWR VPWR sky130_fd_sc_hd__fill_1
XTAP_TAPCELL_ROW_27_471 VGND VPWR sky130_fd_sc_hd__tapvpwrvgnd_1
XFILLER_80_6 VPWR VGND VPWR VGND sky130_ef_sc_hd__decap_12
X_2720_ net737 net290 _0977_ net388 VGND VGND VPWR VPWR _0978_ sky130_fd_sc_hd__a22o_1
XFILLER_12_192 VGND VGND VPWR VPWR sky130_fd_sc_hd__decap_4
XFILLER_8_152 VGND VGND VPWR VPWR sky130_fd_sc_hd__fill_2
XFILLER_8_141 VGND VGND VPWR VPWR sky130_fd_sc_hd__decap_6
X_2651_ net1254 _0867_ _0928_ _0929_ VGND VGND VPWR VPWR _0005_ sky130_fd_sc_hd__o22a_1
X_2582_ net1268 net297 _0883_ _0884_ VGND VGND VPWR VPWR _0561_ sky130_fd_sc_hd__o22a_1
X_4321_ net723 net338 VGND VGND VPWR VPWR _2162_ sky130_fd_sc_hd__and2_1
X_4252_ net717 net337 VGND VGND VPWR VPWR _2118_ sky130_fd_sc_hd__and2_1
X_3203_ net565 net487 net183 net705 _1314_ VGND VGND VPWR VPWR _1315_ sky130_fd_sc_hd__a221o_1
X_4183_ net621 net432 net229 net1308 _2071_ VGND VGND VPWR VPWR _0399_ sky130_fd_sc_hd__a221o_1
XFILLER_67_321 VGND VGND VPWR VPWR sky130_fd_sc_hd__fill_1
X_3134_ net744 net188 _1265_ net192 VGND VGND VPWR VPWR _1266_ sky130_fd_sc_hd__a211o_1
XFILLER_94_195 VGND VGND VPWR VPWR sky130_fd_sc_hd__fill_1
X_3065_ net644 net574 net494 VGND VGND VPWR VPWR _1216_ sky130_fd_sc_hd__mux2_1
XFILLER_55_527 VGND VGND VPWR VPWR sky130_fd_sc_hd__fill_1
XTAP_TAPCELL_ROW_53_739 VGND VPWR sky130_fd_sc_hd__tapvpwrvgnd_1
XTAP_TAPCELL_ROW_81_1016 VGND VPWR sky130_fd_sc_hd__tapvpwrvgnd_1
X_3967_ net358 _1883_ _1887_ net418 net216 VGND VGND VPWR VPWR _1889_ sky130_fd_sc_hd__a221o_1
X_2918_ net1277 net200 _1112_ VGND VGND VPWR VPWR _0089_ sky130_fd_sc_hd__o21a_1
X_3898_ array\[13\]\[11\] net547 net536 array\[15\]\[11\] _1825_ VGND VGND VPWR VPWR
+ _1826_ sky130_fd_sc_hd__a221o_1
Xclkbuf_leaf_30_clk clknet_3_7__leaf_clk VGND VGND VPWR VPWR clknet_leaf_30_clk sky130_fd_sc_hd__clkbuf_8
X_2849_ net904 net283 _1063_ _1064_ VGND VGND VPWR VPWR _0068_ sky130_fd_sc_hd__o22a_1
XTAP_TAPCELL_ROW_92_1123 VGND VPWR sky130_fd_sc_hd__tapvpwrvgnd_1
XFILLER_88_29 VPWR VGND VPWR VGND sky130_ef_sc_hd__decap_12
Xhold130 array\[2\]\[13\] VGND VGND VPWR VPWR net896 sky130_fd_sc_hd__dlygate4sd3_1
Xhold141 array\[11\]\[5\] VGND VGND VPWR VPWR net907 sky130_fd_sc_hd__dlygate4sd3_1
Xhold152 array\[15\]\[29\] VGND VGND VPWR VPWR net918 sky130_fd_sc_hd__dlygate4sd3_1
X_4519_ clknet_leaf_19_clk _0050_ VGND VGND VPWR VPWR array\[8\]\[12\] sky130_fd_sc_hd__dfxtp_1
Xhold174 array\[2\]\[29\] VGND VGND VPWR VPWR net940 sky130_fd_sc_hd__dlygate4sd3_1
Xhold163 array\[5\]\[0\] VGND VGND VPWR VPWR net929 sky130_fd_sc_hd__dlygate4sd3_1
Xhold185 array\[10\]\[12\] VGND VGND VPWR VPWR net951 sky130_fd_sc_hd__dlygate4sd3_1
Xfanout610 net79 VGND VGND VPWR VPWR net610 sky130_fd_sc_hd__dlymetal6s2s_1
Xfanout621 net73 VGND VGND VPWR VPWR net621 sky130_fd_sc_hd__buf_2
Xfanout632 net69 VGND VGND VPWR VPWR net632 sky130_fd_sc_hd__dlymetal6s2s_1
Xhold196 array\[9\]\[6\] VGND VGND VPWR VPWR net962 sky130_fd_sc_hd__dlygate4sd3_1
Xfanout676 net50 VGND VGND VPWR VPWR net676 sky130_fd_sc_hd__clkbuf_2
Xfanout643 net63 VGND VGND VPWR VPWR net643 sky130_fd_sc_hd__buf_2
Xfanout654 net655 VGND VGND VPWR VPWR net654 sky130_fd_sc_hd__buf_2
Xfanout665 net55 VGND VGND VPWR VPWR net665 sky130_fd_sc_hd__buf_2
Xfanout698 net39 VGND VGND VPWR VPWR net698 sky130_fd_sc_hd__dlymetal6s2s_1
Xfanout687 net44 VGND VGND VPWR VPWR net687 sky130_fd_sc_hd__buf_2
XTAP_TAPCELL_ROW_69_894 VGND VPWR sky130_fd_sc_hd__tapvpwrvgnd_1
XFILLER_18_229 VGND VGND VPWR VPWR sky130_fd_sc_hd__fill_2
XFILLER_54_560 VGND VGND VPWR VPWR sky130_fd_sc_hd__fill_2
XTAP_TAPCELL_ROW_24_441 VGND VPWR sky130_fd_sc_hd__tapvpwrvgnd_1
Xclkbuf_leaf_21_clk clknet_3_6__leaf_clk VGND VGND VPWR VPWR clknet_leaf_21_clk sky130_fd_sc_hd__clkbuf_8
XFILLER_5_177 VGND VGND VPWR VPWR sky130_fd_sc_hd__decap_3
XFILLER_78_73 VGND VGND VPWR VPWR sky130_fd_sc_hd__fill_2
XFILLER_49_310 VGND VGND VPWR VPWR sky130_fd_sc_hd__fill_2
XFILLER_37_505 VPWR VGND VPWR VGND sky130_ef_sc_hd__decap_12
XFILLER_64_357 VGND VGND VPWR VPWR sky130_fd_sc_hd__decap_6
XFILLER_17_240 VGND VGND VPWR VPWR sky130_fd_sc_hd__decap_3
XFILLER_91_198 VGND VGND VPWR VPWR sky130_fd_sc_hd__decap_4
X_4870_ clknet_leaf_13_clk _0401_ VGND VGND VPWR VPWR array\[7\]\[13\] sky130_fd_sc_hd__dfxtp_1
XFILLER_20_405 VGND VGND VPWR VPWR sky130_fd_sc_hd__decap_8
X_3821_ net1091 net171 _1754_ _1755_ VGND VGND VPWR VPWR _0349_ sky130_fd_sc_hd__o22a_1
XTAP_TAPCELL_ROW_50_709 VGND VPWR sky130_fd_sc_hd__tapvpwrvgnd_1
Xclkbuf_leaf_12_clk clknet_3_5__leaf_clk VGND VGND VPWR VPWR clknet_leaf_12_clk sky130_fd_sc_hd__clkbuf_8
X_3752_ net1182 net239 _1694_ _1695_ VGND VGND VPWR VPWR _0340_ sky130_fd_sc_hd__o22a_1
XFILLER_9_461 VPWR VGND VPWR VGND sky130_ef_sc_hd__decap_12
X_2703_ net783 _0966_ net293 VGND VGND VPWR VPWR _0020_ sky130_fd_sc_hd__mux2_1
X_3683_ net1045 net237 _1649_ _1650_ VGND VGND VPWR VPWR _0316_ sky130_fd_sc_hd__o22a_1
X_2634_ net1219 net299 _0917_ _0918_ VGND VGND VPWR VPWR _0579_ sky130_fd_sc_hd__o22a_1
X_2565_ net886 net297 _0872_ _0873_ VGND VGND VPWR VPWR _0555_ sky130_fd_sc_hd__o22a_1
X_4304_ net1048 net219 _2150_ _2151_ VGND VGND VPWR VPWR _0440_ sky130_fd_sc_hd__o22a_1
X_2496_ net684 net612 net515 VGND VGND VPWR VPWR _0822_ sky130_fd_sc_hd__mux2_1
X_4235_ net580 net433 net342 net650 net231 VGND VGND VPWR VPWR _2106_ sky130_fd_sc_hd__a221o_1
X_4166_ net933 net227 _2059_ _2060_ VGND VGND VPWR VPWR _0393_ sky130_fd_sc_hd__o22a_1
X_3117_ net1223 net161 _1254_ VGND VGND VPWR VPWR _0146_ sky130_fd_sc_hd__o21a_1
XFILLER_82_121 VGND VGND VPWR VPWR sky130_fd_sc_hd__decap_4
XTAP_TAPCELL_ROW_66_864 VGND VPWR sky130_fd_sc_hd__tapvpwrvgnd_1
X_4097_ array\[2\]\[29\] net464 net447 array\[0\]\[29\] VGND VGND VPWR VPWR _2007_
+ sky130_fd_sc_hd__a22o_1
XFILLER_55_335 VGND VGND VPWR VPWR sky130_fd_sc_hd__fill_1
XFILLER_70_305 VGND VGND VPWR VPWR sky130_fd_sc_hd__decap_3
X_3048_ net728 net194 _1204_ net380 VGND VGND VPWR VPWR _1205_ sky130_fd_sc_hd__a22o_1
XFILLER_36_560 VGND VGND VPWR VPWR sky130_fd_sc_hd__fill_2
XTAP_TAPCELL_ROW_38_588 VGND VPWR sky130_fd_sc_hd__tapvpwrvgnd_1
XFILLER_63_390 VGND VGND VPWR VPWR sky130_fd_sc_hd__fill_2
XTAP_TAPCELL_ROW_21_411 VGND VPWR sky130_fd_sc_hd__tapvpwrvgnd_1
XFILLER_11_449 VPWR VGND VPWR VGND sky130_ef_sc_hd__decap_12
XFILLER_7_409 VPWR VGND VPWR VGND sky130_ef_sc_hd__decap_12
XFILLER_78_438 VPWR VGND VPWR VGND sky130_ef_sc_hd__decap_12
Xfanout440 net441 VGND VGND VPWR VPWR net440 sky130_fd_sc_hd__buf_2
Xfanout462 net463 VGND VGND VPWR VPWR net462 sky130_fd_sc_hd__buf_2
XFILLER_19_505 VGND VGND VPWR VPWR sky130_fd_sc_hd__decap_4
Xfanout473 net476 VGND VGND VPWR VPWR net473 sky130_fd_sc_hd__buf_4
Xfanout451 net455 VGND VGND VPWR VPWR net451 sky130_fd_sc_hd__clkbuf_4
Xfanout484 _1368_ VGND VGND VPWR VPWR net484 sky130_fd_sc_hd__buf_2
Xfanout495 _1149_ VGND VGND VPWR VPWR net495 sky130_fd_sc_hd__buf_4
XFILLER_14_210 VPWR VGND VPWR VGND sky130_ef_sc_hd__decap_12
XFILLER_80_41 VPWR VGND VPWR VGND sky130_ef_sc_hd__decap_12
XFILLER_6_475 VGND VGND VPWR VPWR sky130_fd_sc_hd__fill_1
XFILLER_50_7 VGND VGND VPWR VPWR sky130_fd_sc_hd__fill_2
XFILLER_69_405 VGND VGND VPWR VPWR sky130_fd_sc_hd__fill_1
X_2350_ net1035 net208 _0721_ VGND VGND VPWR VPWR _0492_ sky130_fd_sc_hd__o21a_1
XFILLER_69_449 VGND VGND VPWR VPWR sky130_fd_sc_hd__decap_4
XTAP_TAPCELL_ROW_9_291 VGND VPWR sky130_fd_sc_hd__tapvpwrvgnd_1
X_2281_ net1072 net324 _0672_ VGND VGND VPWR VPWR _0472_ sky130_fd_sc_hd__o21a_1
X_4020_ array\[13\]\[22\] net543 net526 array\[15\]\[22\] _1936_ VGND VGND VPWR VPWR
+ _1937_ sky130_fd_sc_hd__a221o_1
Xclkbuf_leaf_1_clk clknet_3_1__leaf_clk VGND VGND VPWR VPWR clknet_leaf_1_clk sky130_fd_sc_hd__clkbuf_8
XFILLER_37_335 VGND VGND VPWR VPWR sky130_fd_sc_hd__fill_1
XFILLER_92_474 VGND VGND VPWR VPWR sky130_fd_sc_hd__fill_2
XFILLER_18_560 VGND VGND VPWR VPWR sky130_fd_sc_hd__fill_2
XTAP_TAPCELL_ROW_63_834 VGND VPWR sky130_fd_sc_hd__tapvpwrvgnd_1
XTAP_TAPCELL_ROW_35_558 VGND VPWR sky130_fd_sc_hd__tapvpwrvgnd_1
X_4853_ clknet_leaf_62_clk _0384_ VGND VGND VPWR VPWR net118 sky130_fd_sc_hd__dfxtp_1
X_3804_ array\[2\]\[3\] net460 net443 array\[0\]\[3\] VGND VGND VPWR VPWR _1740_ sky130_fd_sc_hd__a22o_1
X_4784_ clknet_leaf_38_clk _0315_ VGND VGND VPWR VPWR array\[9\]\[2\] sky130_fd_sc_hd__dfxtp_1
X_3735_ net733 net348 net419 VGND VGND VPWR VPWR _1684_ sky130_fd_sc_hd__and3_1
Xclkload50 clknet_leaf_24_clk VGND VGND VPWR VPWR clkload50/Y sky130_fd_sc_hd__clkinv_4
X_3666_ _0591_ _0638_ _1004_ VGND VGND VPWR VPWR _1637_ sky130_fd_sc_hd__and3_1
X_3597_ tail\[2\] _1578_ _1584_ VGND VGND VPWR VPWR _0296_ sky130_fd_sc_hd__o21a_1
X_2617_ net1252 net297 _0907_ VGND VGND VPWR VPWR _0573_ sky130_fd_sc_hd__o21a_1
X_2548_ _0586_ _0854_ _0857_ VGND VGND VPWR VPWR _0858_ sky130_fd_sc_hd__and3_2
XFILLER_87_279 VGND VGND VPWR VPWR sky130_fd_sc_hd__fill_1
X_2479_ net607 net304 _0810_ net402 net308 VGND VGND VPWR VPWR _0811_ sky130_fd_sc_hd__a221o_1
X_4218_ net1271 net226 _2094_ VGND VGND VPWR VPWR _0411_ sky130_fd_sc_hd__o21a_1
X_4149_ net431 _0860_ net107 net108 VGND VGND VPWR VPWR _2049_ sky130_fd_sc_hd__and4b_4
XTAP_TAPCELL_ROW_87_1077 VGND VPWR sky130_fd_sc_hd__tapvpwrvgnd_1
XFILLER_70_102 VGND VGND VPWR VPWR sky130_fd_sc_hd__fill_1
XFILLER_34_56 VGND VGND VPWR VPWR sky130_fd_sc_hd__decap_4
XFILLER_51_382 VGND VGND VPWR VPWR sky130_fd_sc_hd__decap_8
XFILLER_51_393 VGND VGND VPWR VPWR sky130_fd_sc_hd__decap_4
Xclkload0 clknet_3_0__leaf_clk VGND VGND VPWR VPWR clkload0/Y sky130_fd_sc_hd__clkinvlp_4
XTAP_TAPCELL_ROW_6_261 VGND VPWR sky130_fd_sc_hd__tapvpwrvgnd_1
Xfanout270 _1072_ VGND VGND VPWR VPWR net270 sky130_fd_sc_hd__buf_4
Xfanout292 _0937_ VGND VGND VPWR VPWR net292 sky130_fd_sc_hd__buf_4
Xfanout281 net282 VGND VGND VPWR VPWR net281 sky130_fd_sc_hd__clkbuf_4
XFILLER_75_85 VGND VGND VPWR VPWR sky130_fd_sc_hd__fill_2
XFILLER_61_113 VGND VGND VPWR VPWR sky130_fd_sc_hd__fill_1
XFILLER_91_51 VGND VGND VPWR VPWR sky130_fd_sc_hd__decap_4
XFILLER_15_552 VGND VGND VPWR VPWR sky130_fd_sc_hd__decap_4
XTAP_TAPCELL_ROW_60_804 VGND VPWR sky130_fd_sc_hd__tapvpwrvgnd_1
XFILLER_30_522 VGND VGND VPWR VPWR sky130_fd_sc_hd__fill_2
XTAP_TAPCELL_ROW_32_528 VGND VPWR sky130_fd_sc_hd__tapvpwrvgnd_1
XFILLER_42_371 VGND VGND VPWR VPWR sky130_fd_sc_hd__fill_1
X_3520_ net699 net245 VGND VGND VPWR VPWR _1533_ sky130_fd_sc_hd__and2_1
X_3451_ net986 net260 _1484_ VGND VGND VPWR VPWR _0250_ sky130_fd_sc_hd__o21a_1
X_3382_ net756 net757 net501 net477 VGND VGND VPWR VPWR _1436_ sky130_fd_sc_hd__a31o_1
X_2402_ net599 net673 net517 VGND VGND VPWR VPWR _0756_ sky130_fd_sc_hd__mux2_1
X_2333_ net111 net112 VGND VGND VPWR VPWR _0707_ sky130_fd_sc_hd__and2b_1
XFILLER_69_246 VGND VGND VPWR VPWR sky130_fd_sc_hd__fill_1
X_2264_ net627 net758 net521 VGND VGND VPWR VPWR _0661_ sky130_fd_sc_hd__mux2_1
X_2195_ net651 empty _0601_ VGND VGND VPWR VPWR _0605_ sky130_fd_sc_hd__or3_4
XFILLER_37_121 VGND VGND VPWR VPWR sky130_fd_sc_hd__fill_2
X_4003_ array\[2\]\[21\] net458 net441 array\[0\]\[21\] VGND VGND VPWR VPWR _1921_
+ sky130_fd_sc_hd__a22o_1
XFILLER_37_154 VGND VGND VPWR VPWR sky130_fd_sc_hd__fill_1
XTAP_TAPCELL_ROW_48_683 VGND VPWR sky130_fd_sc_hd__tapvpwrvgnd_1
X_4905_ clknet_leaf_23_clk _0436_ VGND VGND VPWR VPWR array\[6\]\[16\] sky130_fd_sc_hd__dfxtp_1
X_4836_ clknet_leaf_59_clk _0367_ VGND VGND VPWR VPWR net134 sky130_fd_sc_hd__dfxtp_1
X_4767_ clknet_leaf_63_clk _0298_ VGND VGND VPWR VPWR ready_check\[14\] sky130_fd_sc_hd__dfxtp_1
X_4698_ clknet_leaf_46_clk _0229_ VGND VGND VPWR VPWR array\[12\]\[31\] sky130_fd_sc_hd__dfxtp_1
XFILLER_20_14 VGND VGND VPWR VPWR sky130_fd_sc_hd__decap_3
X_3718_ net1053 net239 _1672_ _1673_ VGND VGND VPWR VPWR _0328_ sky130_fd_sc_hd__o22a_1
X_3649_ net212 _0607_ _1617_ _1625_ VGND VGND VPWR VPWR _0307_ sky130_fd_sc_hd__o31a_1
XFILLER_88_533 VPWR VGND VPWR VGND sky130_ef_sc_hd__decap_12
Xhold12 net143 VGND VGND VPWR VPWR net778 sky130_fd_sc_hd__dlygate4sd3_1
Xhold23 array\[5\]\[17\] VGND VGND VPWR VPWR net789 sky130_fd_sc_hd__dlygate4sd3_1
Xhold45 net141 VGND VGND VPWR VPWR net811 sky130_fd_sc_hd__dlygate4sd3_1
Xhold56 array\[5\]\[9\] VGND VGND VPWR VPWR net822 sky130_fd_sc_hd__dlygate4sd3_1
Xhold34 array\[15\]\[20\] VGND VGND VPWR VPWR net800 sky130_fd_sc_hd__dlygate4sd3_1
XTAP_TAPCELL_ROW_3_231 VGND VPWR sky130_fd_sc_hd__tapvpwrvgnd_1
Xhold89 array\[0\]\[0\] VGND VGND VPWR VPWR net855 sky130_fd_sc_hd__dlygate4sd3_1
Xhold67 array\[13\]\[10\] VGND VGND VPWR VPWR net833 sky130_fd_sc_hd__dlygate4sd3_1
Xhold78 array\[5\]\[4\] VGND VGND VPWR VPWR net844 sky130_fd_sc_hd__dlygate4sd3_1
XFILLER_28_154 VGND VGND VPWR VPWR sky130_fd_sc_hd__fill_1
XFILLER_45_11 VGND VGND VPWR VPWR sky130_fd_sc_hd__decap_6
XFILLER_16_349 VGND VGND VPWR VPWR sky130_fd_sc_hd__decap_4
XFILLER_43_102 VGND VGND VPWR VPWR sky130_fd_sc_hd__fill_2
XFILLER_43_124 VGND VGND VPWR VPWR sky130_fd_sc_hd__fill_2
XFILLER_71_477 VGND VGND VPWR VPWR sky130_fd_sc_hd__decap_4
XFILLER_71_444 VGND VGND VPWR VPWR sky130_fd_sc_hd__decap_4
XFILLER_24_371 VGND VGND VPWR VPWR sky130_fd_sc_hd__decap_4
XFILLER_12_533 VPWR VGND VPWR VGND sky130_ef_sc_hd__decap_12
XFILLER_6_27 VGND VGND VPWR VPWR sky130_fd_sc_hd__fill_1
XANTENNA_9 _0866_ VGND VGND VPWR VPWR sky130_fd_sc_hd__diode_2
XFILLER_94_503 VGND VGND VPWR VPWR sky130_fd_sc_hd__fill_1
XFILLER_81_208 VPWR VGND VPWR VGND sky130_ef_sc_hd__decap_12
XTAP_TAPCELL_ROW_45_653 VGND VPWR sky130_fd_sc_hd__tapvpwrvgnd_1
X_2951_ net1097 net201 _1134_ VGND VGND VPWR VPWR _0100_ sky130_fd_sc_hd__o21a_1
XTAP_TAPCELL_ROW_17_377 VGND VPWR sky130_fd_sc_hd__tapvpwrvgnd_1
XFILLER_62_477 VGND VGND VPWR VPWR sky130_fd_sc_hd__fill_1
XFILLER_62_499 VGND VGND VPWR VPWR sky130_fd_sc_hd__decap_6
XFILLER_89_3 VPWR VGND VPWR VGND sky130_ef_sc_hd__decap_12
X_4621_ clknet_leaf_12_clk _0152_ VGND VGND VPWR VPWR array\[14\]\[18\] sky130_fd_sc_hd__dfxtp_1
X_2882_ net1194 net199 _1088_ VGND VGND VPWR VPWR _0077_ sky130_fd_sc_hd__o21a_1
XFILLER_30_363 VGND VGND VPWR VPWR sky130_fd_sc_hd__fill_1
XFILLER_30_385 VGND VGND VPWR VPWR sky130_fd_sc_hd__decap_6
X_4552_ clknet_leaf_11_clk _0083_ VGND VGND VPWR VPWR array\[0\]\[13\] sky130_fd_sc_hd__dfxtp_1
X_4483_ clknet_leaf_32_clk _0014_ VGND VGND VPWR VPWR array\[5\]\[8\] sky130_fd_sc_hd__dfxtp_1
Xhold526 array\[8\]\[7\] VGND VGND VPWR VPWR net1292 sky130_fd_sc_hd__dlygate4sd3_1
Xhold515 array\[12\]\[0\] VGND VGND VPWR VPWR net1281 sky130_fd_sc_hd__dlygate4sd3_1
Xhold504 array\[2\]\[25\] VGND VGND VPWR VPWR net1270 sky130_fd_sc_hd__dlygate4sd3_1
X_3503_ net572 net475 net360 net642 net252 VGND VGND VPWR VPWR _1522_ sky130_fd_sc_hd__a221o_1
Xhold548 empty VGND VGND VPWR VPWR net1314 sky130_fd_sc_hd__dlygate4sd3_1
Xhold537 array\[8\]\[20\] VGND VGND VPWR VPWR net1303 sky130_fd_sc_hd__dlygate4sd3_1
X_3434_ net749 net258 VGND VGND VPWR VPWR _1473_ sky130_fd_sc_hd__and2_1
X_3365_ net1060 net156 _1423_ _1424_ VGND VGND VPWR VPWR _0224_ sky130_fd_sc_hd__o22a_1
X_2316_ net726 net321 _0695_ net412 net329 VGND VGND VPWR VPWR _0696_ sky130_fd_sc_hd__a221o_1
X_3296_ net711 net173 VGND VGND VPWR VPWR _1379_ sky130_fd_sc_hd__and2_1
X_2247_ net711 net321 _0649_ net412 net329 VGND VGND VPWR VPWR _0650_ sky130_fd_sc_hd__a221o_1
XTAP_TAPCELL_ROW_0_201 VGND VPWR sky130_fd_sc_hd__tapvpwrvgnd_1
X_2178_ net756 VGND VGND VPWR VPWR _0589_ sky130_fd_sc_hd__inv_2
XTAP_TAPCELL_ROW_84_1047 VGND VPWR sky130_fd_sc_hd__tapvpwrvgnd_1
XFILLER_80_263 VGND VGND VPWR VPWR sky130_fd_sc_hd__fill_1
XFILLER_80_296 VPWR VGND VPWR VGND sky130_ef_sc_hd__decap_12
X_4819_ clknet_leaf_30_clk _0350_ VGND VGND VPWR VPWR net147 sky130_fd_sc_hd__dfxtp_1
XFILLER_5_529 VPWR VGND VPWR VGND sky130_ef_sc_hd__decap_12
XFILLER_31_57 VGND VGND VPWR VPWR sky130_fd_sc_hd__fill_2
XFILLER_88_352 VGND VGND VPWR VPWR sky130_fd_sc_hd__fill_1
Xinput102 value2[9] VGND VGND VPWR VPWR net102 sky130_fd_sc_hd__buf_1
Xinput113 write_location2[2] VGND VGND VPWR VPWR net113 sky130_fd_sc_hd__buf_1
XFILLER_91_517 VPWR VGND VPWR VGND sky130_ef_sc_hd__decap_12
XPHY_EDGE_ROW_19_Right_19 VGND VGND VPWR VPWR sky130_fd_sc_hd__decap_3
XFILLER_44_444 VGND VGND VPWR VPWR sky130_fd_sc_hd__decap_4
XTAP_TAPCELL_ROW_42_623 VGND VPWR sky130_fd_sc_hd__tapvpwrvgnd_1
XFILLER_72_97 VGND VGND VPWR VPWR sky130_fd_sc_hd__decap_3
XTAP_TAPCELL_ROW_14_347 VGND VPWR sky130_fd_sc_hd__tapvpwrvgnd_1
XFILLER_8_323 VGND VGND VPWR VPWR sky130_fd_sc_hd__decap_3
Xclkbuf_3_1__f_clk clknet_0_clk VGND VGND VPWR VPWR clknet_3_1__leaf_clk sky130_fd_sc_hd__clkbuf_16
XPHY_EDGE_ROW_28_Right_28 VGND VGND VPWR VPWR sky130_fd_sc_hd__decap_3
XFILLER_79_341 VGND VGND VPWR VPWR sky130_fd_sc_hd__fill_1
XFILLER_67_514 VPWR VGND VPWR VGND sky130_ef_sc_hd__decap_12
XFILLER_67_503 VGND VGND VPWR VPWR sky130_fd_sc_hd__fill_1
X_3150_ net809 net163 _1276_ VGND VGND VPWR VPWR _0157_ sky130_fd_sc_hd__o21a_1
X_3081_ net1180 net161 _1230_ VGND VGND VPWR VPWR _0134_ sky130_fd_sc_hd__o21a_1
XPHY_EDGE_ROW_37_Right_37 VGND VGND VPWR VPWR sky130_fd_sc_hd__decap_3
XFILLER_90_561 VGND VGND VPWR VPWR sky130_fd_sc_hd__fill_1
XFILLER_50_414 VGND VGND VPWR VPWR sky130_fd_sc_hd__decap_6
X_3983_ array\[13\]\[19\] net550 net529 array\[15\]\[19\] _1902_ VGND VGND VPWR VPWR
+ _1903_ sky130_fd_sc_hd__a221o_1
X_2934_ net589 net663 net498 VGND VGND VPWR VPWR _1123_ sky130_fd_sc_hd__mux2_1
XFILLER_50_469 VGND VGND VPWR VPWR sky130_fd_sc_hd__decap_6
X_2865_ net577 net647 net498 VGND VGND VPWR VPWR _1077_ sky130_fd_sc_hd__mux2_1
X_4604_ clknet_leaf_58_clk _0135_ VGND VGND VPWR VPWR array\[14\]\[1\] sky130_fd_sc_hd__dfxtp_1
XPHY_EDGE_ROW_46_Right_46 VGND VGND VPWR VPWR sky130_fd_sc_hd__decap_3
X_2796_ net621 net504 net276 net693 net286 VGND VGND VPWR VPWR _1031_ sky130_fd_sc_hd__a221o_1
X_4535_ clknet_leaf_52_clk _0066_ VGND VGND VPWR VPWR array\[8\]\[28\] sky130_fd_sc_hd__dfxtp_1
Xhold301 array\[14\]\[7\] VGND VGND VPWR VPWR net1067 sky130_fd_sc_hd__dlygate4sd3_1
Xhold334 net147 VGND VGND VPWR VPWR net1100 sky130_fd_sc_hd__dlygate4sd3_1
Xhold312 array\[11\]\[17\] VGND VGND VPWR VPWR net1078 sky130_fd_sc_hd__dlygate4sd3_1
Xhold323 array\[11\]\[1\] VGND VGND VPWR VPWR net1089 sky130_fd_sc_hd__dlygate4sd3_1
XFILLER_89_105 VGND VGND VPWR VPWR sky130_fd_sc_hd__decap_6
Xhold345 array\[6\]\[21\] VGND VGND VPWR VPWR net1111 sky130_fd_sc_hd__dlygate4sd3_1
Xhold378 array\[7\]\[28\] VGND VGND VPWR VPWR net1144 sky130_fd_sc_hd__dlygate4sd3_1
X_4466_ clknet_leaf_35_clk _0577_ VGND VGND VPWR VPWR array\[4\]\[23\] sky130_fd_sc_hd__dfxtp_1
Xhold367 array\[3\]\[15\] VGND VGND VPWR VPWR net1133 sky130_fd_sc_hd__dlygate4sd3_1
Xhold356 array\[14\]\[15\] VGND VGND VPWR VPWR net1122 sky130_fd_sc_hd__dlygate4sd3_1
X_4397_ clknet_leaf_12_clk _0508_ VGND VGND VPWR VPWR array\[2\]\[18\] sky130_fd_sc_hd__dfxtp_1
X_3417_ net759 net479 net365 net628 net265 VGND VGND VPWR VPWR _1462_ sky130_fd_sc_hd__a221o_1
Xhold389 array\[11\]\[2\] VGND VGND VPWR VPWR net1155 sky130_fd_sc_hd__dlygate4sd3_1
X_3348_ net735 net173 VGND VGND VPWR VPWR _1413_ sky130_fd_sc_hd__and2_1
X_3279_ net806 _1365_ net158 VGND VGND VPWR VPWR _0197_ sky130_fd_sc_hd__mux2_1
XPHY_EDGE_ROW_55_Right_55 VGND VGND VPWR VPWR sky130_fd_sc_hd__decap_3
XFILLER_81_561 VGND VGND VPWR VPWR sky130_fd_sc_hd__fill_1
XFILLER_26_68 VGND VGND VPWR VPWR sky130_fd_sc_hd__decap_8
XFILLER_26_488 VGND VGND VPWR VPWR sky130_fd_sc_hd__fill_1
XPHY_EDGE_ROW_64_Right_64 VGND VGND VPWR VPWR sky130_fd_sc_hd__decap_3
XTAP_TAPCELL_ROW_11_317 VGND VPWR sky130_fd_sc_hd__tapvpwrvgnd_1
XFILLER_42_45 VGND VGND VPWR VPWR sky130_fd_sc_hd__fill_1
XFILLER_88_182 VGND VGND VPWR VPWR sky130_fd_sc_hd__decap_3
XPHY_EDGE_ROW_73_Right_73 VGND VGND VPWR VPWR sky130_fd_sc_hd__decap_3
XFILLER_36_219 VPWR VGND VPWR VGND sky130_ef_sc_hd__decap_12
XPHY_EDGE_ROW_17_Left_112 VGND VGND VPWR VPWR sky130_fd_sc_hd__decap_3
XTAP_TAPCELL_ROW_27_472 VGND VPWR sky130_fd_sc_hd__tapvpwrvgnd_1
XPHY_EDGE_ROW_82_Right_82 VGND VGND VPWR VPWR sky130_fd_sc_hd__decap_3
XFILLER_8_131 VGND VGND VPWR VPWR sky130_fd_sc_hd__decap_8
X_2650_ net573 net511 net397 net643 net302 VGND VGND VPWR VPWR _0929_ sky130_fd_sc_hd__a221o_1
X_2581_ net762 net509 net395 net633 net300 VGND VGND VPWR VPWR _0884_ sky130_fd_sc_hd__a221o_1
X_4320_ net853 net218 _2160_ _2161_ VGND VGND VPWR VPWR _0446_ sky130_fd_sc_hd__o22a_1
XPHY_EDGE_ROW_26_Left_121 VGND VGND VPWR VPWR sky130_fd_sc_hd__decap_3
X_4251_ net1137 net221 net335 net740 _2117_ VGND VGND VPWR VPWR _0421_ sky130_fd_sc_hd__a221o_1
XPHY_EDGE_ROW_91_Right_91 VGND VGND VPWR VPWR sky130_fd_sc_hd__decap_3
X_3202_ net635 net373 VGND VGND VPWR VPWR _1314_ sky130_fd_sc_hd__and2_1
X_4182_ net585 net233 net340 net693 VGND VGND VPWR VPWR _2071_ sky130_fd_sc_hd__a22o_1
XFILLER_94_141 VGND VGND VPWR VPWR sky130_fd_sc_hd__fill_2
X_3133_ net606 net490 net378 net680 VGND VGND VPWR VPWR _1265_ sky130_fd_sc_hd__a22o_1
XFILLER_67_344 VGND VGND VPWR VPWR sky130_fd_sc_hd__decap_4
X_3064_ net1128 _1215_ net168 VGND VGND VPWR VPWR _0132_ sky130_fd_sc_hd__mux2_1
XPHY_EDGE_ROW_35_Left_130 VGND VGND VPWR VPWR sky130_fd_sc_hd__decap_3
XFILLER_63_561 VGND VGND VPWR VPWR sky130_fd_sc_hd__fill_1
XTAP_TAPCELL_ROW_81_1017 VGND VPWR sky130_fd_sc_hd__tapvpwrvgnd_1
XFILLER_23_447 VGND VGND VPWR VPWR sky130_fd_sc_hd__fill_1
X_3966_ net354 _1881_ _1885_ net438 VGND VGND VPWR VPWR _1888_ sky130_fd_sc_hd__a22o_1
XFILLER_10_108 VPWR VGND VPWR VGND sky130_ef_sc_hd__decap_12
X_2917_ net742 net272 _1111_ net385 net269 VGND VGND VPWR VPWR _1112_ sky130_fd_sc_hd__a221o_1
X_3897_ array\[14\]\[11\] net462 net445 array\[12\]\[11\] VGND VGND VPWR VPWR _1825_
+ sky130_fd_sc_hd__a22o_1
XFILLER_12_15 VGND VGND VPWR VPWR sky130_fd_sc_hd__decap_6
X_2848_ net575 net503 net277 net645 net287 VGND VGND VPWR VPWR _1064_ sky130_fd_sc_hd__a221o_1
X_2779_ net1086 _1008_ _1019_ _1020_ VGND VGND VPWR VPWR _0042_ sky130_fd_sc_hd__o22a_1
XTAP_TAPCELL_ROW_92_1124 VGND VPWR sky130_fd_sc_hd__tapvpwrvgnd_1
Xhold142 array\[1\]\[16\] VGND VGND VPWR VPWR net908 sky130_fd_sc_hd__dlygate4sd3_1
Xhold120 array\[4\]\[1\] VGND VGND VPWR VPWR net886 sky130_fd_sc_hd__dlygate4sd3_1
Xhold131 array\[13\]\[23\] VGND VGND VPWR VPWR net897 sky130_fd_sc_hd__dlygate4sd3_1
Xhold153 array\[1\]\[1\] VGND VGND VPWR VPWR net919 sky130_fd_sc_hd__dlygate4sd3_1
X_4518_ clknet_leaf_18_clk _0049_ VGND VGND VPWR VPWR array\[8\]\[11\] sky130_fd_sc_hd__dfxtp_1
Xhold175 array\[10\]\[29\] VGND VGND VPWR VPWR net941 sky130_fd_sc_hd__dlygate4sd3_1
Xhold164 array\[9\]\[31\] VGND VGND VPWR VPWR net930 sky130_fd_sc_hd__dlygate4sd3_1
X_4449_ clknet_leaf_7_clk _0560_ VGND VGND VPWR VPWR array\[4\]\[6\] sky130_fd_sc_hd__dfxtp_1
Xhold186 array\[14\]\[6\] VGND VGND VPWR VPWR net952 sky130_fd_sc_hd__dlygate4sd3_1
Xfanout622 net73 VGND VGND VPWR VPWR net622 sky130_fd_sc_hd__dlymetal6s2s_1
Xfanout611 net78 VGND VGND VPWR VPWR net611 sky130_fd_sc_hd__buf_2
Xfanout600 net83 VGND VGND VPWR VPWR net600 sky130_fd_sc_hd__clkbuf_2
Xfanout633 net68 VGND VGND VPWR VPWR net633 sky130_fd_sc_hd__buf_2
Xhold197 array\[13\]\[4\] VGND VGND VPWR VPWR net963 sky130_fd_sc_hd__dlygate4sd3_1
Xfanout666 net55 VGND VGND VPWR VPWR net666 sky130_fd_sc_hd__dlymetal6s2s_1
Xfanout644 net63 VGND VGND VPWR VPWR net644 sky130_fd_sc_hd__clkbuf_2
Xfanout655 net656 VGND VGND VPWR VPWR net655 sky130_fd_sc_hd__clkbuf_2
Xfanout699 net38 VGND VGND VPWR VPWR net699 sky130_fd_sc_hd__buf_2
Xfanout677 net49 VGND VGND VPWR VPWR net677 sky130_fd_sc_hd__buf_2
Xfanout688 net44 VGND VGND VPWR VPWR net688 sky130_fd_sc_hd__clkbuf_2
XTAP_TAPCELL_ROW_69_895 VGND VPWR sky130_fd_sc_hd__tapvpwrvgnd_1
XFILLER_14_414 VGND VGND VPWR VPWR sky130_fd_sc_hd__decap_6
XFILLER_81_391 VGND VGND VPWR VPWR sky130_fd_sc_hd__fill_1
XFILLER_14_425 VGND VGND VPWR VPWR sky130_fd_sc_hd__fill_1
XFILLER_41_211 VPWR VGND VPWR VGND sky130_ef_sc_hd__decap_12
XFILLER_41_233 VGND VGND VPWR VPWR sky130_fd_sc_hd__fill_2
XTAP_TAPCELL_ROW_24_442 VGND VPWR sky130_fd_sc_hd__tapvpwrvgnd_1
XFILLER_41_266 VGND VGND VPWR VPWR sky130_fd_sc_hd__decap_4
XFILLER_41_288 VPWR VGND VPWR VGND sky130_ef_sc_hd__decap_12
XFILLER_5_167 VGND VGND VPWR VPWR sky130_fd_sc_hd__fill_1
XFILLER_78_41 VPWR VGND VPWR VGND sky130_ef_sc_hd__decap_12
XFILLER_89_480 VPWR VGND VPWR VGND sky130_ef_sc_hd__decap_12
XFILLER_1_373 VGND VGND VPWR VPWR sky130_fd_sc_hd__fill_1
XFILLER_91_111 VGND VGND VPWR VPWR sky130_fd_sc_hd__fill_1
XFILLER_37_517 VGND VGND VPWR VPWR sky130_fd_sc_hd__decap_8
XFILLER_91_133 VGND VGND VPWR VPWR sky130_fd_sc_hd__fill_2
XFILLER_91_177 VGND VGND VPWR VPWR sky130_fd_sc_hd__fill_1
XFILLER_45_561 VGND VGND VPWR VPWR sky130_fd_sc_hd__fill_1
XFILLER_17_296 VGND VGND VPWR VPWR sky130_fd_sc_hd__decap_8
XFILLER_60_531 VGND VGND VPWR VPWR sky130_fd_sc_hd__fill_1
X_3820_ net351 _1749_ _1753_ net435 net215 VGND VGND VPWR VPWR _1755_ sky130_fd_sc_hd__a221o_1
X_3751_ net583 net426 net347 net659 net244 VGND VGND VPWR VPWR _1695_ sky130_fd_sc_hd__a221o_1
X_2702_ net751 net289 _0965_ net387 VGND VGND VPWR VPWR _0966_ sky130_fd_sc_hd__a22o_1
XFILLER_71_3 VPWR VGND VPWR VGND sky130_ef_sc_hd__decap_12
XFILLER_9_473 VPWR VGND VPWR VGND sky130_ef_sc_hd__decap_12
X_3682_ net572 net423 net344 net642 net241 VGND VGND VPWR VPWR _1650_ sky130_fd_sc_hd__a221o_1
X_2633_ net589 net511 net397 net663 net302 VGND VGND VPWR VPWR _0918_ sky130_fd_sc_hd__a221o_1
X_2564_ net601 net510 net395 net675 net300 VGND VGND VPWR VPWR _0873_ sky130_fd_sc_hd__a221o_1
X_4303_ net600 net428 net332 net674 net222 VGND VGND VPWR VPWR _2151_ sky130_fd_sc_hd__a221o_1
XFILLER_87_417 VPWR VGND VPWR VGND sky130_ef_sc_hd__decap_12
X_2495_ net1133 net203 _0821_ VGND VGND VPWR VPWR _0537_ sky130_fd_sc_hd__o21a_1
X_4234_ net720 net235 VGND VGND VPWR VPWR _2105_ sky130_fd_sc_hd__and2_1
X_4165_ net567 net434 net343 net637 net232 VGND VGND VPWR VPWR _2060_ sky130_fd_sc_hd__a221o_1
X_3116_ net765 net185 _1253_ net189 VGND VGND VPWR VPWR _1254_ sky130_fd_sc_hd__a211o_1
X_4096_ array\[9\]\[29\] net550 net529 array\[11\]\[29\] _2005_ VGND VGND VPWR VPWR
+ _2006_ sky130_fd_sc_hd__a221o_1
XTAP_TAPCELL_ROW_66_865 VGND VPWR sky130_fd_sc_hd__tapvpwrvgnd_1
X_3047_ net664 net590 net494 VGND VGND VPWR VPWR _1204_ sky130_fd_sc_hd__mux2_1
XTAP_TAPCELL_ROW_38_589 VGND VPWR sky130_fd_sc_hd__tapvpwrvgnd_1
XTAP_TAPCELL_ROW_21_412 VGND VPWR sky130_fd_sc_hd__tapvpwrvgnd_1
XFILLER_23_36 VGND VGND VPWR VPWR sky130_fd_sc_hd__fill_1
X_3949_ array\[2\]\[16\] net468 net451 array\[0\]\[16\] VGND VGND VPWR VPWR _1872_
+ sky130_fd_sc_hd__a22o_1
XFILLER_2_137 VGND VGND VPWR VPWR sky130_fd_sc_hd__decap_3
Xfanout430 _1619_ VGND VGND VPWR VPWR net430 sky130_fd_sc_hd__clkbuf_2
Xfanout441 net446 VGND VGND VPWR VPWR net441 sky130_fd_sc_hd__clkbuf_4
Xfanout452 net455 VGND VGND VPWR VPWR net452 sky130_fd_sc_hd__buf_2
Xfanout463 _1588_ VGND VGND VPWR VPWR net463 sky130_fd_sc_hd__buf_2
Xfanout474 net476 VGND VGND VPWR VPWR net474 sky130_fd_sc_hd__clkbuf_4
Xfanout485 _1296_ VGND VGND VPWR VPWR net485 sky130_fd_sc_hd__clkbuf_4
XFILLER_46_325 VGND VGND VPWR VPWR sky130_fd_sc_hd__decap_8
Xfanout496 _1149_ VGND VGND VPWR VPWR net496 sky130_fd_sc_hd__clkbuf_4
XFILLER_0_29 VPWR VGND VPWR VGND sky130_ef_sc_hd__decap_12
XFILLER_27_561 VGND VGND VPWR VPWR sky130_fd_sc_hd__fill_1
XFILLER_14_222 VGND VGND VPWR VPWR sky130_fd_sc_hd__decap_4
XFILLER_80_53 VPWR VGND VPWR VGND sky130_ef_sc_hd__decap_12
XFILLER_6_421 VPWR VGND VPWR VGND sky130_ef_sc_hd__decap_12
XFILLER_89_51 VGND VGND VPWR VPWR sky130_fd_sc_hd__decap_4
XTAP_TAPCELL_ROW_9_292 VGND VPWR sky130_fd_sc_hd__tapvpwrvgnd_1
XFILLER_36_6 VPWR VGND VPWR VGND sky130_ef_sc_hd__decap_12
X_2280_ net751 net320 _0671_ net411 net328 VGND VGND VPWR VPWR _0672_ sky130_fd_sc_hd__a221o_1
XFILLER_1_181 VPWR VGND VPWR VGND sky130_ef_sc_hd__decap_12
XFILLER_77_461 VGND VGND VPWR VPWR sky130_fd_sc_hd__decap_6
X_4921_ clknet_leaf_60_clk _0452_ VGND VGND VPWR VPWR ready_check\[9\] sky130_fd_sc_hd__dfxtp_1
XTAP_TAPCELL_ROW_63_835 VGND VPWR sky130_fd_sc_hd__tapvpwrvgnd_1
X_4852_ clknet_leaf_62_clk _0383_ VGND VGND VPWR VPWR net117 sky130_fd_sc_hd__dfxtp_1
XTAP_TAPCELL_ROW_35_559 VGND VPWR sky130_fd_sc_hd__tapvpwrvgnd_1
X_3803_ array\[9\]\[3\] net548 net535 array\[11\]\[3\] _1738_ VGND VGND VPWR VPWR
+ _1739_ sky130_fd_sc_hd__a221o_1
X_4783_ clknet_leaf_55_clk _0314_ VGND VGND VPWR VPWR array\[9\]\[1\] sky130_fd_sc_hd__dfxtp_1
X_3734_ net1191 net237 _1682_ _1683_ VGND VGND VPWR VPWR _0334_ sky130_fd_sc_hd__o22a_1
XFILLER_9_281 VGND VGND VPWR VPWR sky130_fd_sc_hd__fill_2
X_3665_ _0931_ net501 net423 VGND VGND VPWR VPWR _1636_ sky130_fd_sc_hd__a21oi_1
Xclkload51 clknet_leaf_25_clk VGND VGND VPWR VPWR clkload51/X sky130_fd_sc_hd__clkbuf_4
Xclkload40 clknet_leaf_17_clk VGND VGND VPWR VPWR clkload40/X sky130_fd_sc_hd__clkbuf_4
X_2616_ net741 _0868_ _0906_ net300 VGND VGND VPWR VPWR _0907_ sky130_fd_sc_hd__a211o_1
X_3596_ _1578_ _1583_ net651 VGND VGND VPWR VPWR _1584_ sky130_fd_sc_hd__a21oi_1
XFILLER_87_203 VGND VGND VPWR VPWR sky130_fd_sc_hd__decap_4
X_2547_ net112 net111 VGND VGND VPWR VPWR _0857_ sky130_fd_sc_hd__nor2_1
XFILLER_87_225 VGND VGND VPWR VPWR sky130_fd_sc_hd__decap_6
X_2478_ net695 net623 net513 VGND VGND VPWR VPWR _0810_ sky130_fd_sc_hd__mux2_1
X_4217_ net732 net235 net231 _2093_ VGND VGND VPWR VPWR _2094_ sky130_fd_sc_hd__a211o_1
XFILLER_28_303 VGND VGND VPWR VPWR sky130_fd_sc_hd__decap_4
XTAP_TAPCELL_ROW_79_990 VGND VPWR sky130_fd_sc_hd__tapvpwrvgnd_1
X_4148_ net655 _1612_ VGND VGND VPWR VPWR _2048_ sky130_fd_sc_hd__or2_1
XFILLER_28_325 VGND VGND VPWR VPWR sky130_fd_sc_hd__fill_2
XFILLER_83_464 VPWR VGND VPWR VGND sky130_ef_sc_hd__decap_12
X_4079_ net358 _1985_ _1989_ net354 net216 VGND VGND VPWR VPWR _1991_ sky130_fd_sc_hd__a221o_1
XTAP_TAPCELL_ROW_87_1078 VGND VPWR sky130_fd_sc_hd__tapvpwrvgnd_1
XFILLER_34_13 VPWR VGND VPWR VGND sky130_ef_sc_hd__decap_12
XFILLER_36_380 VPWR VGND VPWR VGND sky130_ef_sc_hd__decap_12
XFILLER_55_177 VGND VGND VPWR VPWR sky130_fd_sc_hd__fill_1
XFILLER_24_542 VGND VGND VPWR VPWR sky130_fd_sc_hd__fill_2
XFILLER_11_225 VGND VGND VPWR VPWR sky130_fd_sc_hd__decap_4
Xclkload1 clknet_3_1__leaf_clk VGND VGND VPWR VPWR clkload1/Y sky130_fd_sc_hd__clkinv_8
XFILLER_1_3 VPWR VGND VPWR VGND sky130_ef_sc_hd__decap_12
XFILLER_78_214 VGND VGND VPWR VPWR sky130_fd_sc_hd__fill_1
XFILLER_59_65 VPWR VGND VPWR VGND sky130_ef_sc_hd__decap_12
XTAP_TAPCELL_ROW_6_262 VGND VPWR sky130_fd_sc_hd__tapvpwrvgnd_1
XFILLER_93_206 VGND VGND VPWR VPWR sky130_fd_sc_hd__fill_2
Xfanout282 _1009_ VGND VGND VPWR VPWR net282 sky130_fd_sc_hd__clkbuf_4
XFILLER_19_314 VGND VGND VPWR VPWR sky130_fd_sc_hd__fill_2
Xfanout271 net274 VGND VGND VPWR VPWR net271 sky130_fd_sc_hd__buf_4
Xfanout260 _1440_ VGND VGND VPWR VPWR net260 sky130_fd_sc_hd__clkbuf_2
Xfanout293 _0936_ VGND VGND VPWR VPWR net293 sky130_fd_sc_hd__buf_4
XFILLER_74_497 VGND VGND VPWR VPWR sky130_fd_sc_hd__fill_1
XTAP_TAPCELL_ROW_60_805 VGND VPWR sky130_fd_sc_hd__tapvpwrvgnd_1
XTAP_TAPCELL_ROW_32_529 VGND VPWR sky130_fd_sc_hd__tapvpwrvgnd_1
X_3450_ net738 net256 _1483_ net264 VGND VGND VPWR VPWR _1484_ sky130_fd_sc_hd__a211o_1
X_2401_ net997 net208 _0755_ VGND VGND VPWR VPWR _0509_ sky130_fd_sc_hd__o21a_1
X_3381_ net753 _0627_ _0780_ VGND VGND VPWR VPWR _1435_ sky130_fd_sc_hd__and3_2
XFILLER_69_225 VGND VGND VPWR VPWR sky130_fd_sc_hd__fill_2
X_2332_ net1021 net323 _0706_ VGND VGND VPWR VPWR _0489_ sky130_fd_sc_hd__o21a_1
XFILLER_69_269 VGND VGND VPWR VPWR sky130_fd_sc_hd__decap_8
XFILLER_84_206 VGND VGND VPWR VPWR sky130_fd_sc_hd__decap_4
X_2263_ net976 net325 _0660_ VGND VGND VPWR VPWR _0466_ sky130_fd_sc_hd__o21a_1
X_4002_ net913 net170 _1919_ _1920_ VGND VGND VPWR VPWR _0365_ sky130_fd_sc_hd__o22a_1
X_2194_ net562 _0602_ VGND VGND VPWR VPWR _0604_ sky130_fd_sc_hd__and2_4
XFILLER_37_111 VGND VGND VPWR VPWR sky130_fd_sc_hd__fill_1
XTAP_TAPCELL_ROW_76_960 VGND VPWR sky130_fd_sc_hd__tapvpwrvgnd_1
XPHY_EDGE_ROW_9_Left_104 VGND VGND VPWR VPWR sky130_fd_sc_hd__decap_3
XFILLER_1_83 VGND VGND VPWR VPWR sky130_fd_sc_hd__fill_1
XTAP_TAPCELL_ROW_48_684 VGND VPWR sky130_fd_sc_hd__tapvpwrvgnd_1
XFILLER_21_512 VGND VGND VPWR VPWR sky130_fd_sc_hd__decap_4
XFILLER_33_361 VGND VGND VPWR VPWR sky130_fd_sc_hd__fill_2
X_4904_ clknet_leaf_34_clk _0435_ VGND VGND VPWR VPWR array\[6\]\[15\] sky130_fd_sc_hd__dfxtp_1
X_4835_ clknet_leaf_0_clk _0366_ VGND VGND VPWR VPWR net133 sky130_fd_sc_hd__dfxtp_1
X_4766_ clknet_leaf_62_clk _0297_ VGND VGND VPWR VPWR tail\[3\] sky130_fd_sc_hd__dfxtp_2
X_3717_ net613 net426 net347 net685 net244 VGND VGND VPWR VPWR _1673_ sky130_fd_sc_hd__a221o_1
X_4697_ clknet_leaf_25_clk _0228_ VGND VGND VPWR VPWR array\[12\]\[30\] sky130_fd_sc_hd__dfxtp_1
X_3648_ net564 ready_check\[5\] _1624_ _0935_ net387 VGND VGND VPWR VPWR _1625_ sky130_fd_sc_hd__a311o_1
XFILLER_88_501 VPWR VGND VPWR VGND sky130_ef_sc_hd__decap_12
X_3579_ net719 net245 VGND VGND VPWR VPWR _1572_ sky130_fd_sc_hd__and2_1
XFILLER_0_405 VGND VGND VPWR VPWR sky130_fd_sc_hd__decap_4
XFILLER_88_545 VPWR VGND VPWR VGND sky130_ef_sc_hd__decap_12
XFILLER_0_449 VPWR VGND VPWR VGND sky130_ef_sc_hd__decap_12
Xhold13 net135 VGND VGND VPWR VPWR net779 sky130_fd_sc_hd__dlygate4sd3_1
Xhold24 net144 VGND VGND VPWR VPWR net790 sky130_fd_sc_hd__dlygate4sd3_1
Xhold35 array\[3\]\[6\] VGND VGND VPWR VPWR net801 sky130_fd_sc_hd__dlygate4sd3_1
Xhold46 array\[4\]\[30\] VGND VGND VPWR VPWR net812 sky130_fd_sc_hd__dlygate4sd3_1
Xhold79 array\[15\]\[5\] VGND VGND VPWR VPWR net845 sky130_fd_sc_hd__dlygate4sd3_1
Xhold57 array\[9\]\[18\] VGND VGND VPWR VPWR net823 sky130_fd_sc_hd__dlygate4sd3_1
XTAP_TAPCELL_ROW_3_232 VGND VPWR sky130_fd_sc_hd__tapvpwrvgnd_1
Xhold68 array\[12\]\[20\] VGND VGND VPWR VPWR net834 sky130_fd_sc_hd__dlygate4sd3_1
XFILLER_45_45 VGND VGND VPWR VPWR sky130_fd_sc_hd__decap_3
XFILLER_43_147 VGND VGND VPWR VPWR sky130_fd_sc_hd__decap_4
XFILLER_12_501 VPWR VGND VPWR VGND sky130_ef_sc_hd__decap_12
XFILLER_12_545 VPWR VGND VPWR VGND sky130_ef_sc_hd__decap_12
XFILLER_79_501 VGND VGND VPWR VPWR sky130_fd_sc_hd__decap_3
XFILLER_86_41 VPWR VGND VPWR VGND sky130_ef_sc_hd__decap_12
XFILLER_66_206 VGND VGND VPWR VPWR sky130_fd_sc_hd__fill_1
XFILLER_86_85 VPWR VGND VPWR VGND sky130_ef_sc_hd__decap_12
XFILLER_47_420 VGND VGND VPWR VPWR sky130_fd_sc_hd__decap_4
XTAP_TAPCELL_ROW_73_930 VGND VPWR sky130_fd_sc_hd__tapvpwrvgnd_1
XTAP_TAPCELL_ROW_45_654 VGND VPWR sky130_fd_sc_hd__tapvpwrvgnd_1
X_2950_ net716 net273 _1133_ net386 net270 VGND VGND VPWR VPWR _1134_ sky130_fd_sc_hd__a221o_1
XTAP_TAPCELL_ROW_17_378 VGND VPWR sky130_fd_sc_hd__tapvpwrvgnd_1
X_2881_ net704 net271 _1087_ net383 net268 VGND VGND VPWR VPWR _1088_ sky130_fd_sc_hd__a221o_1
X_4620_ clknet_leaf_25_clk _0151_ VGND VGND VPWR VPWR array\[14\]\[17\] sky130_fd_sc_hd__dfxtp_1
X_4551_ clknet_leaf_17_clk _0082_ VGND VGND VPWR VPWR array\[0\]\[12\] sky130_fd_sc_hd__dfxtp_1
Xhold516 array\[1\]\[28\] VGND VGND VPWR VPWR net1282 sky130_fd_sc_hd__dlygate4sd3_1
X_4482_ clknet_leaf_2_clk _0013_ VGND VGND VPWR VPWR array\[5\]\[7\] sky130_fd_sc_hd__dfxtp_1
Xhold527 array\[15\]\[21\] VGND VGND VPWR VPWR net1293 sky130_fd_sc_hd__dlygate4sd3_1
Xhold505 array\[7\]\[23\] VGND VGND VPWR VPWR net1271 sky130_fd_sc_hd__dlygate4sd3_1
X_3502_ net712 net246 VGND VGND VPWR VPWR _1521_ sky130_fd_sc_hd__and2_1
Xhold549 net152 VGND VGND VPWR VPWR net1315 sky130_fd_sc_hd__dlygate4sd3_1
Xhold538 array\[6\]\[22\] VGND VGND VPWR VPWR net1304 sky130_fd_sc_hd__dlygate4sd3_1
X_3433_ net1065 net259 _1471_ _1472_ VGND VGND VPWR VPWR _0244_ sky130_fd_sc_hd__o22a_1
X_3364_ net588 net482 net370 net662 net180 VGND VGND VPWR VPWR _1424_ sky130_fd_sc_hd__a221o_1
X_2315_ net662 net588 net523 VGND VGND VPWR VPWR _0695_ sky130_fd_sc_hd__mux2_1
X_3295_ net1129 net178 net174 net718 _1378_ VGND VGND VPWR VPWR _0200_ sky130_fd_sc_hd__a221o_1
XFILLER_85_559 VGND VGND VPWR VPWR sky130_fd_sc_hd__fill_1
X_2246_ net641 net571 net523 VGND VGND VPWR VPWR _0649_ sky130_fd_sc_hd__mux2_1
XTAP_TAPCELL_ROW_0_202 VGND VPWR sky130_fd_sc_hd__tapvpwrvgnd_1
X_2177_ full VGND VGND VPWR VPWR _0588_ sky130_fd_sc_hd__inv_2
XTAP_TAPCELL_ROW_84_1048 VGND VPWR sky130_fd_sc_hd__tapvpwrvgnd_1
XFILLER_80_253 VGND VGND VPWR VPWR sky130_fd_sc_hd__fill_2
XFILLER_15_15 VPWR VGND VPWR VGND sky130_ef_sc_hd__decap_12
XFILLER_25_169 VGND VGND VPWR VPWR sky130_fd_sc_hd__fill_1
XFILLER_21_331 VGND VGND VPWR VPWR sky130_fd_sc_hd__decap_4
XFILLER_21_397 VPWR VGND VPWR VGND sky130_ef_sc_hd__decap_12
X_4818_ clknet_leaf_43_clk _0349_ VGND VGND VPWR VPWR net146 sky130_fd_sc_hd__dfxtp_1
X_4749_ clknet_leaf_18_clk _0280_ VGND VGND VPWR VPWR array\[10\]\[18\] sky130_fd_sc_hd__dfxtp_1
XFILLER_0_202 VPWR VGND VPWR VGND sky130_ef_sc_hd__decap_12
XFILLER_0_279 VGND VGND VPWR VPWR sky130_fd_sc_hd__fill_1
Xinput103 write_location0[0] VGND VGND VPWR VPWR net103 sky130_fd_sc_hd__dlymetal6s2s_1
Xinput114 write_location2[3] VGND VGND VPWR VPWR net114 sky130_fd_sc_hd__buf_1
XFILLER_91_529 VPWR VGND VPWR VGND sky130_ef_sc_hd__decap_12
XFILLER_16_103 VGND VGND VPWR VPWR sky130_fd_sc_hd__fill_2
XTAP_TAPCELL_ROW_70_900 VGND VPWR sky130_fd_sc_hd__tapvpwrvgnd_1
XTAP_TAPCELL_ROW_42_624 VGND VPWR sky130_fd_sc_hd__tapvpwrvgnd_1
XTAP_TAPCELL_ROW_14_348 VGND VPWR sky130_fd_sc_hd__tapvpwrvgnd_1
XFILLER_94_334 VGND VGND VPWR VPWR sky130_fd_sc_hd__fill_2
XFILLER_67_526 VGND VGND VPWR VPWR sky130_fd_sc_hd__decap_4
X_3080_ net629 net185 _1229_ net189 VGND VGND VPWR VPWR _1230_ sky130_fd_sc_hd__a211o_1
XFILLER_35_401 VGND VGND VPWR VPWR sky130_fd_sc_hd__fill_2
XFILLER_62_231 VGND VGND VPWR VPWR sky130_fd_sc_hd__decap_4
X_3982_ array\[14\]\[19\] net464 net447 array\[12\]\[19\] VGND VGND VPWR VPWR _1902_
+ sky130_fd_sc_hd__a22o_1
X_2933_ net1095 net201 _1122_ VGND VGND VPWR VPWR _0094_ sky130_fd_sc_hd__o21a_1
X_2864_ net1206 net199 _1076_ VGND VGND VPWR VPWR _0071_ sky130_fd_sc_hd__o21a_1
X_2795_ net585 net280 VGND VGND VPWR VPWR _1030_ sky130_fd_sc_hd__and2_1
X_4603_ clknet_leaf_59_clk _0134_ VGND VGND VPWR VPWR array\[14\]\[0\] sky130_fd_sc_hd__dfxtp_1
X_4534_ clknet_leaf_21_clk _0065_ VGND VGND VPWR VPWR array\[8\]\[27\] sky130_fd_sc_hd__dfxtp_1
Xhold302 array\[13\]\[14\] VGND VGND VPWR VPWR net1068 sky130_fd_sc_hd__dlygate4sd3_1
Xhold324 array\[6\]\[27\] VGND VGND VPWR VPWR net1090 sky130_fd_sc_hd__dlygate4sd3_1
Xhold335 array\[10\]\[5\] VGND VGND VPWR VPWR net1101 sky130_fd_sc_hd__dlygate4sd3_1
Xhold313 array\[8\]\[3\] VGND VGND VPWR VPWR net1079 sky130_fd_sc_hd__dlygate4sd3_1
Xhold368 array\[4\]\[12\] VGND VGND VPWR VPWR net1134 sky130_fd_sc_hd__dlygate4sd3_1
X_4465_ clknet_leaf_2_clk _0576_ VGND VGND VPWR VPWR array\[4\]\[22\] sky130_fd_sc_hd__dfxtp_1
Xhold357 array\[9\]\[2\] VGND VGND VPWR VPWR net1123 sky130_fd_sc_hd__dlygate4sd3_1
Xhold346 array\[3\]\[20\] VGND VGND VPWR VPWR net1112 sky130_fd_sc_hd__dlygate4sd3_1
X_4396_ clknet_leaf_23_clk _0507_ VGND VGND VPWR VPWR array\[2\]\[17\] sky130_fd_sc_hd__dfxtp_1
X_3416_ net699 net257 VGND VGND VPWR VPWR _1461_ sky130_fd_sc_hd__and2_1
Xhold379 array\[2\]\[6\] VGND VGND VPWR VPWR net1145 sky130_fd_sc_hd__dlygate4sd3_1
X_3347_ net834 net156 _1411_ _1412_ VGND VGND VPWR VPWR _0218_ sky130_fd_sc_hd__o22a_1
XFILLER_85_323 VGND VGND VPWR VPWR sky130_fd_sc_hd__decap_3
XFILLER_85_334 VGND VGND VPWR VPWR sky130_fd_sc_hd__fill_2
X_3278_ net574 net486 net182 net714 _1364_ VGND VGND VPWR VPWR _1365_ sky130_fd_sc_hd__a221o_1
XFILLER_73_529 VGND VGND VPWR VPWR sky130_fd_sc_hd__decap_4
X_2229_ net653 net766 net3 VGND VGND VPWR VPWR _0635_ sky130_fd_sc_hd__nand3b_1
XFILLER_38_261 VGND VGND VPWR VPWR sky130_fd_sc_hd__fill_2
XTAP_TAPCELL_ROW_11_318 VGND VPWR sky130_fd_sc_hd__tapvpwrvgnd_1
XFILLER_91_326 VGND VGND VPWR VPWR sky130_fd_sc_hd__fill_1
XFILLER_29_261 VGND VGND VPWR VPWR sky130_fd_sc_hd__decap_4
XTAP_TAPCELL_ROW_27_473 VGND VPWR sky130_fd_sc_hd__tapvpwrvgnd_1
XFILLER_12_172 VGND VGND VPWR VPWR sky130_fd_sc_hd__fill_2
XFILLER_40_481 VGND VGND VPWR VPWR sky130_fd_sc_hd__fill_1
XFILLER_66_6 VPWR VGND VPWR VGND sky130_ef_sc_hd__decap_12
X_2580_ net703 net399 net506 VGND VGND VPWR VPWR _0883_ sky130_fd_sc_hd__and3_1
XFILLER_4_360 VGND VGND VPWR VPWR sky130_fd_sc_hd__decap_4
X_4250_ net601 net428 net331 net675 VGND VGND VPWR VPWR _2117_ sky130_fd_sc_hd__a22o_1
XFILLER_86_109 VPWR VGND VPWR VGND sky130_ef_sc_hd__decap_12
X_3201_ net792 _1313_ net159 VGND VGND VPWR VPWR _0171_ sky130_fd_sc_hd__mux2_1
X_4181_ net1140 net226 _2070_ VGND VGND VPWR VPWR _0398_ sky130_fd_sc_hd__o21a_1
X_3132_ net932 net162 _1264_ VGND VGND VPWR VPWR _0151_ sky130_fd_sc_hd__o21a_1
XFILLER_67_356 VGND VGND VPWR VPWR sky130_fd_sc_hd__decap_4
X_3063_ net716 net196 _1214_ net381 VGND VGND VPWR VPWR _1215_ sky130_fd_sc_hd__a22o_1
XFILLER_35_264 VPWR VGND VPWR VGND sky130_ef_sc_hd__decap_12
XTAP_TAPCELL_ROW_81_1018 VGND VPWR sky130_fd_sc_hd__tapvpwrvgnd_1
X_3965_ array\[13\]\[17\] net554 net540 array\[15\]\[17\] _1886_ VGND VGND VPWR VPWR
+ _1887_ sky130_fd_sc_hd__a221o_1
XFILLER_50_234 VGND VGND VPWR VPWR sky130_fd_sc_hd__fill_1
X_3896_ array\[9\]\[11\] net548 net535 array\[11\]\[11\] _1823_ VGND VGND VPWR VPWR
+ _1824_ sky130_fd_sc_hd__a221o_1
X_2916_ net604 net678 net498 VGND VGND VPWR VPWR _1111_ sky130_fd_sc_hd__mux2_1
XFILLER_12_27 VGND VGND VPWR VPWR sky130_fd_sc_hd__fill_1
X_2847_ net715 net281 VGND VGND VPWR VPWR _1063_ sky130_fd_sc_hd__and2_1
Xhold110 array\[12\]\[12\] VGND VGND VPWR VPWR net876 sky130_fd_sc_hd__dlygate4sd3_1
X_2778_ net569 net503 net278 net639 net287 VGND VGND VPWR VPWR _1020_ sky130_fd_sc_hd__a221o_1
XTAP_TAPCELL_ROW_92_1125 VGND VPWR sky130_fd_sc_hd__tapvpwrvgnd_1
X_4517_ clknet_leaf_49_clk _0048_ VGND VGND VPWR VPWR array\[8\]\[10\] sky130_fd_sc_hd__dfxtp_1
Xhold121 array\[13\]\[25\] VGND VGND VPWR VPWR net887 sky130_fd_sc_hd__dlygate4sd3_1
Xhold132 array\[11\]\[23\] VGND VGND VPWR VPWR net898 sky130_fd_sc_hd__dlygate4sd3_1
Xhold143 array\[7\]\[3\] VGND VGND VPWR VPWR net909 sky130_fd_sc_hd__dlygate4sd3_1
Xhold154 array\[15\]\[16\] VGND VGND VPWR VPWR net920 sky130_fd_sc_hd__dlygate4sd3_1
Xhold165 array\[1\]\[11\] VGND VGND VPWR VPWR net931 sky130_fd_sc_hd__dlygate4sd3_1
Xhold176 array\[12\]\[5\] VGND VGND VPWR VPWR net942 sky130_fd_sc_hd__dlygate4sd3_1
X_4448_ clknet_leaf_31_clk _0559_ VGND VGND VPWR VPWR array\[4\]\[5\] sky130_fd_sc_hd__dfxtp_1
Xfanout612 net78 VGND VGND VPWR VPWR net612 sky130_fd_sc_hd__dlymetal6s2s_1
Xhold187 array\[1\]\[26\] VGND VGND VPWR VPWR net953 sky130_fd_sc_hd__dlygate4sd3_1
Xhold198 array\[12\]\[10\] VGND VGND VPWR VPWR net964 sky130_fd_sc_hd__dlygate4sd3_1
Xfanout623 net72 VGND VGND VPWR VPWR net623 sky130_fd_sc_hd__buf_2
Xfanout601 net602 VGND VGND VPWR VPWR net601 sky130_fd_sc_hd__buf_2
Xfanout645 net62 VGND VGND VPWR VPWR net645 sky130_fd_sc_hd__buf_2
Xfanout656 net6 VGND VGND VPWR VPWR net656 sky130_fd_sc_hd__clkbuf_2
Xfanout634 net68 VGND VGND VPWR VPWR net634 sky130_fd_sc_hd__dlymetal6s2s_1
X_4379_ clknet_leaf_56_clk _0490_ VGND VGND VPWR VPWR array\[2\]\[0\] sky130_fd_sc_hd__dfxtp_1
Xfanout667 net668 VGND VGND VPWR VPWR net667 sky130_fd_sc_hd__buf_2
Xfanout689 net43 VGND VGND VPWR VPWR net689 sky130_fd_sc_hd__clkbuf_2
Xfanout678 net49 VGND VGND VPWR VPWR net678 sky130_fd_sc_hd__clkbuf_2
XTAP_TAPCELL_ROW_69_896 VGND VPWR sky130_fd_sc_hd__tapvpwrvgnd_1
XFILLER_37_57 VGND VGND VPWR VPWR sky130_fd_sc_hd__decap_4
XFILLER_26_253 VGND VGND VPWR VPWR sky130_fd_sc_hd__decap_4
XFILLER_41_223 VGND VGND VPWR VPWR sky130_fd_sc_hd__fill_1
XTAP_TAPCELL_ROW_24_443 VGND VPWR sky130_fd_sc_hd__tapvpwrvgnd_1
XFILLER_22_492 VGND VGND VPWR VPWR sky130_fd_sc_hd__fill_1
XFILLER_5_113 VPWR VGND VPWR VGND sky130_ef_sc_hd__decap_12
XFILLER_5_157 VGND VGND VPWR VPWR sky130_fd_sc_hd__fill_1
XFILLER_78_53 VPWR VGND VPWR VGND sky130_ef_sc_hd__decap_12
XFILLER_89_492 VPWR VGND VPWR VGND sky130_ef_sc_hd__decap_12
XFILLER_49_345 VGND VGND VPWR VPWR sky130_fd_sc_hd__decap_4
XFILLER_94_41 VPWR VGND VPWR VGND sky130_ef_sc_hd__decap_12
XFILLER_94_85 VPWR VGND VPWR VGND sky130_ef_sc_hd__decap_12
XFILLER_76_186 VGND VGND VPWR VPWR sky130_fd_sc_hd__fill_1
XFILLER_91_167 VGND VGND VPWR VPWR sky130_fd_sc_hd__fill_1
X_3750_ net723 net350 net422 VGND VGND VPWR VPWR _1694_ sky130_fd_sc_hd__and3_1
XFILLER_13_470 VPWR VGND VPWR VGND sky130_ef_sc_hd__decap_12
XFILLER_32_289 VGND VGND VPWR VPWR sky130_fd_sc_hd__decap_4
XFILLER_9_430 VPWR VGND VPWR VGND sky130_ef_sc_hd__decap_12
X_2701_ net687 net615 net391 VGND VGND VPWR VPWR _0965_ sky130_fd_sc_hd__mux2_1
XFILLER_9_485 VPWR VGND VPWR VGND sky130_ef_sc_hd__decap_12
X_3681_ net712 net348 net419 VGND VGND VPWR VPWR _1649_ sky130_fd_sc_hd__and3_1
X_2632_ net727 net401 net508 VGND VGND VPWR VPWR _0917_ sky130_fd_sc_hd__and3_1
X_2563_ net739 net399 net506 VGND VGND VPWR VPWR _0872_ sky130_fd_sc_hd__and3_1
X_4302_ net738 net336 VGND VGND VPWR VPWR _2150_ sky130_fd_sc_hd__and2_1
XFILLER_87_407 VGND VGND VPWR VPWR sky130_fd_sc_hd__fill_2
X_4233_ net1144 net226 _2104_ VGND VGND VPWR VPWR _0416_ sky130_fd_sc_hd__o21a_1
X_2494_ net749 net306 _0820_ net405 net310 VGND VGND VPWR VPWR _0821_ sky130_fd_sc_hd__a221o_1
XFILLER_87_429 VPWR VGND VPWR VGND sky130_ef_sc_hd__decap_12
XFILLER_4_83 VGND VGND VPWR VPWR sky130_fd_sc_hd__fill_1
X_4164_ net707 net236 VGND VGND VPWR VPWR _2059_ sky130_fd_sc_hd__and2_1
X_3115_ net620 net490 net375 net692 VGND VGND VPWR VPWR _1253_ sky130_fd_sc_hd__a22o_1
X_4095_ array\[10\]\[29\] net464 net447 array\[8\]\[29\] VGND VGND VPWR VPWR _2005_
+ sky130_fd_sc_hd__a22o_1
X_3046_ net864 _1203_ net168 VGND VGND VPWR VPWR _0126_ sky130_fd_sc_hd__mux2_1
XFILLER_55_337 VGND VGND VPWR VPWR sky130_fd_sc_hd__decap_8
XTAP_TAPCELL_ROW_66_866 VGND VPWR sky130_fd_sc_hd__tapvpwrvgnd_1
XFILLER_63_370 VPWR VGND VPWR VGND sky130_ef_sc_hd__decap_12
XFILLER_23_15 VGND VGND VPWR VPWR sky130_fd_sc_hd__decap_4
X_3948_ array\[13\]\[16\] net555 net540 array\[15\]\[16\] _1870_ VGND VGND VPWR VPWR
+ _1871_ sky130_fd_sc_hd__a221o_1
XTAP_TAPCELL_ROW_21_413 VGND VPWR sky130_fd_sc_hd__tapvpwrvgnd_1
X_3879_ net832 net171 _1808_ VGND VGND VPWR VPWR _0354_ sky130_fd_sc_hd__o21a_1
Xfanout431 _1611_ VGND VGND VPWR VPWR net431 sky130_fd_sc_hd__clkbuf_4
Xfanout420 net422 VGND VGND VPWR VPWR net420 sky130_fd_sc_hd__dlymetal6s2s_1
Xfanout464 net472 VGND VGND VPWR VPWR net464 sky130_fd_sc_hd__clkbuf_4
Xfanout475 net476 VGND VGND VPWR VPWR net475 sky130_fd_sc_hd__clkbuf_4
Xfanout453 net455 VGND VGND VPWR VPWR net453 sky130_fd_sc_hd__clkbuf_4
Xfanout442 net446 VGND VGND VPWR VPWR net442 sky130_fd_sc_hd__clkbuf_4
Xfanout486 _1296_ VGND VGND VPWR VPWR net486 sky130_fd_sc_hd__clkbuf_4
Xfanout497 net500 VGND VGND VPWR VPWR net497 sky130_fd_sc_hd__clkbuf_8
XFILLER_73_123 VGND VGND VPWR VPWR sky130_fd_sc_hd__decap_3
XFILLER_73_167 VGND VGND VPWR VPWR sky130_fd_sc_hd__fill_1
XFILLER_64_33 VGND VGND VPWR VPWR sky130_fd_sc_hd__fill_1
XFILLER_64_22 VGND VGND VPWR VPWR sky130_fd_sc_hd__decap_6
XFILLER_14_289 VGND VGND VPWR VPWR sky130_fd_sc_hd__fill_1
XFILLER_80_65 VGND VGND VPWR VPWR sky130_fd_sc_hd__decap_4
XPHY_EDGE_ROW_54_Left_149 VGND VGND VPWR VPWR sky130_fd_sc_hd__decap_3
XFILLER_13_70 VGND VGND VPWR VPWR sky130_fd_sc_hd__decap_3
XFILLER_6_433 VPWR VGND VPWR VGND sky130_ef_sc_hd__decap_12
XFILLER_6_477 VPWR VGND VPWR VGND sky130_ef_sc_hd__decap_12
XTAP_TAPCELL_ROW_9_293 VGND VPWR sky130_fd_sc_hd__tapvpwrvgnd_1
XFILLER_1_193 VPWR VGND VPWR VGND sky130_ef_sc_hd__decap_12
XFILLER_29_6 VGND VGND VPWR VPWR sky130_fd_sc_hd__fill_2
XFILLER_49_131 VGND VGND VPWR VPWR sky130_fd_sc_hd__decap_4
XPHY_EDGE_ROW_63_Left_158 VGND VGND VPWR VPWR sky130_fd_sc_hd__decap_3
XFILLER_92_421 VPWR VGND VPWR VGND sky130_ef_sc_hd__decap_12
X_4920_ clknet_leaf_45_clk _0451_ VGND VGND VPWR VPWR array\[6\]\[31\] sky130_fd_sc_hd__dfxtp_1
XTAP_TAPCELL_ROW_63_836 VGND VPWR sky130_fd_sc_hd__tapvpwrvgnd_1
X_4851_ clknet_leaf_62_clk _0382_ VGND VGND VPWR VPWR net116 sky130_fd_sc_hd__dfxtp_1
XPHY_EDGE_ROW_72_Left_167 VGND VGND VPWR VPWR sky130_fd_sc_hd__decap_3
X_3802_ array\[10\]\[3\] net461 net444 array\[8\]\[3\] VGND VGND VPWR VPWR _1738_
+ sky130_fd_sc_hd__a22o_1
X_4782_ clknet_leaf_58_clk _0313_ VGND VGND VPWR VPWR array\[9\]\[0\] sky130_fd_sc_hd__dfxtp_1
X_3733_ net598 net423 net344 net672 net241 VGND VGND VPWR VPWR _1683_ sky130_fd_sc_hd__a221o_1
X_3664_ net114 _0627_ _0629_ VGND VGND VPWR VPWR _1635_ sky130_fd_sc_hd__and3_2
Xclkload52 clknet_leaf_27_clk VGND VGND VPWR VPWR clkload52/Y sky130_fd_sc_hd__bufinv_16
X_2615_ net603 net509 net395 net677 VGND VGND VPWR VPWR _0906_ sky130_fd_sc_hd__a22o_1
Xclkload30 clknet_leaf_6_clk VGND VGND VPWR VPWR clkload30/X sky130_fd_sc_hd__clkbuf_8
Xclkload41 clknet_leaf_20_clk VGND VGND VPWR VPWR clkload41/X sky130_fd_sc_hd__clkbuf_8
X_3595_ _1581_ _1582_ VGND VGND VPWR VPWR _1583_ sky130_fd_sc_hd__or2_1
XPHY_EDGE_ROW_81_Left_176 VGND VGND VPWR VPWR sky130_fd_sc_hd__decap_3
X_2546_ _0586_ _0854_ VGND VGND VPWR VPWR _0856_ sky130_fd_sc_hd__nand2_1
X_2477_ net924 net203 _0809_ VGND VGND VPWR VPWR _0531_ sky130_fd_sc_hd__o21a_1
X_4216_ net594 net433 net342 net667 VGND VGND VPWR VPWR _2093_ sky130_fd_sc_hd__a22o_1
XFILLER_18_15 VPWR VGND VPWR VGND sky130_ef_sc_hd__decap_12
X_4147_ net655 _1612_ VGND VGND VPWR VPWR _2047_ sky130_fd_sc_hd__nor2_2
XTAP_TAPCELL_ROW_79_991 VGND VPWR sky130_fd_sc_hd__tapvpwrvgnd_1
X_4078_ net438 _1983_ _1987_ net418 VGND VGND VPWR VPWR _1990_ sky130_fd_sc_hd__a22o_1
XFILLER_83_476 VGND VGND VPWR VPWR sky130_fd_sc_hd__fill_1
XTAP_TAPCELL_ROW_87_1079 VGND VPWR sky130_fd_sc_hd__tapvpwrvgnd_1
XFILLER_70_115 VPWR VGND VPWR VGND sky130_ef_sc_hd__decap_12
X_3029_ net677 net603 net493 VGND VGND VPWR VPWR _1192_ sky130_fd_sc_hd__mux2_1
XFILLER_55_189 VGND VGND VPWR VPWR sky130_fd_sc_hd__fill_1
XPHY_EDGE_ROW_90_Left_185 VGND VGND VPWR VPWR sky130_fd_sc_hd__decap_3
XFILLER_34_25 VGND VGND VPWR VPWR sky130_fd_sc_hd__decap_3
XFILLER_36_392 VGND VGND VPWR VPWR sky130_fd_sc_hd__decap_8
Xclkload2 clknet_3_2__leaf_clk VGND VGND VPWR VPWR clkload2/Y sky130_fd_sc_hd__inv_6
XFILLER_50_24 VGND VGND VPWR VPWR sky130_fd_sc_hd__decap_4
XFILLER_3_447 VGND VGND VPWR VPWR sky130_fd_sc_hd__fill_1
XFILLER_59_55 VGND VGND VPWR VPWR sky130_fd_sc_hd__fill_1
XFILLER_59_77 VGND VGND VPWR VPWR sky130_fd_sc_hd__decap_4
Xfanout250 _1512_ VGND VGND VPWR VPWR net250 sky130_fd_sc_hd__clkbuf_4
XTAP_TAPCELL_ROW_6_263 VGND VPWR sky130_fd_sc_hd__tapvpwrvgnd_1
Xfanout261 _1440_ VGND VGND VPWR VPWR net261 sky130_fd_sc_hd__buf_4
Xfanout272 net273 VGND VGND VPWR VPWR net272 sky130_fd_sc_hd__clkbuf_4
Xfanout283 net284 VGND VGND VPWR VPWR net283 sky130_fd_sc_hd__buf_4
XFILLER_75_43 VGND VGND VPWR VPWR sky130_fd_sc_hd__decap_4
Xfanout294 _0936_ VGND VGND VPWR VPWR net294 sky130_fd_sc_hd__clkbuf_4
XPHY_EDGE_ROW_3_Left_98 VGND VGND VPWR VPWR sky130_fd_sc_hd__decap_3
XFILLER_34_307 VGND VGND VPWR VPWR sky130_fd_sc_hd__fill_1
XFILLER_46_145 VGND VGND VPWR VPWR sky130_fd_sc_hd__fill_2
XTAP_TAPCELL_ROW_60_806 VGND VPWR sky130_fd_sc_hd__tapvpwrvgnd_1
XFILLER_30_557 VGND VGND VPWR VPWR sky130_fd_sc_hd__decap_4
X_2400_ net741 net316 _0754_ net408 net313 VGND VGND VPWR VPWR _0755_ sky130_fd_sc_hd__a221o_1
X_3380_ net866 net154 _1433_ _1434_ VGND VGND VPWR VPWR _0229_ sky130_fd_sc_hd__o22a_1
XFILLER_69_204 VGND VGND VPWR VPWR sky130_fd_sc_hd__decap_4
X_2331_ net713 net319 _0705_ net410 net327 VGND VGND VPWR VPWR _0706_ sky130_fd_sc_hd__a221o_1
X_2262_ net701 net321 _0659_ net413 net329 VGND VGND VPWR VPWR _0660_ sky130_fd_sc_hd__a221o_1
X_4001_ net356 _1914_ _1918_ net437 net214 VGND VGND VPWR VPWR _1920_ sky130_fd_sc_hd__a221o_1
XFILLER_77_281 VGND VGND VPWR VPWR sky130_fd_sc_hd__decap_6
X_2193_ net561 net217 _0603_ VGND VGND VPWR VPWR _0453_ sky130_fd_sc_hd__o21a_1
XTAP_TAPCELL_ROW_76_961 VGND VPWR sky130_fd_sc_hd__tapvpwrvgnd_1
XFILLER_92_262 VGND VGND VPWR VPWR sky130_fd_sc_hd__fill_1
XTAP_TAPCELL_ROW_48_685 VGND VPWR sky130_fd_sc_hd__tapvpwrvgnd_1
XFILLER_18_381 VGND VGND VPWR VPWR sky130_fd_sc_hd__fill_2
X_4903_ clknet_leaf_2_clk _0434_ VGND VGND VPWR VPWR array\[6\]\[14\] sky130_fd_sc_hd__dfxtp_1
X_4834_ clknet_leaf_8_clk _0365_ VGND VGND VPWR VPWR net132 sky130_fd_sc_hd__dfxtp_1
X_4765_ clknet_leaf_62_clk _0296_ VGND VGND VPWR VPWR tail\[2\] sky130_fd_sc_hd__dfxtp_1
X_3716_ net749 net349 net421 VGND VGND VPWR VPWR _1672_ sky130_fd_sc_hd__and3_1
X_4696_ clknet_leaf_51_clk _0227_ VGND VGND VPWR VPWR array\[12\]\[29\] sky130_fd_sc_hd__dfxtp_1
XFILLER_20_38 VPWR VGND VPWR VGND sky130_ef_sc_hd__decap_12
X_3647_ _1293_ _1613_ VGND VGND VPWR VPWR _1624_ sky130_fd_sc_hd__nand2_1
X_3578_ net906 _1512_ _1570_ _1571_ VGND VGND VPWR VPWR _0290_ sky130_fd_sc_hd__o22a_1
XFILLER_88_513 VPWR VGND VPWR VGND sky130_ef_sc_hd__decap_12
X_2529_ net660 net584 net516 VGND VGND VPWR VPWR _0844_ sky130_fd_sc_hd__mux2_1
Xhold14 array\[13\]\[17\] VGND VGND VPWR VPWR net780 sky130_fd_sc_hd__dlygate4sd3_1
XFILLER_88_557 VGND VGND VPWR VPWR sky130_fd_sc_hd__decap_4
Xhold25 net127 VGND VGND VPWR VPWR net791 sky130_fd_sc_hd__dlygate4sd3_1
Xhold47 array\[1\]\[5\] VGND VGND VPWR VPWR net813 sky130_fd_sc_hd__dlygate4sd3_1
XFILLER_75_218 VGND VGND VPWR VPWR sky130_fd_sc_hd__decap_6
XFILLER_29_69 VGND VGND VPWR VPWR sky130_fd_sc_hd__fill_1
Xhold36 net142 VGND VGND VPWR VPWR net802 sky130_fd_sc_hd__dlygate4sd3_1
XTAP_TAPCELL_ROW_3_233 VGND VPWR sky130_fd_sc_hd__tapvpwrvgnd_1
Xhold69 array\[5\]\[28\] VGND VGND VPWR VPWR net835 sky130_fd_sc_hd__dlygate4sd3_1
XFILLER_56_421 VGND VGND VPWR VPWR sky130_fd_sc_hd__fill_1
Xhold58 net126 VGND VGND VPWR VPWR net824 sky130_fd_sc_hd__dlygate4sd3_1
XFILLER_12_513 VPWR VGND VPWR VGND sky130_ef_sc_hd__decap_12
XFILLER_12_557 VGND VGND VPWR VPWR sky130_fd_sc_hd__fill_2
XFILLER_6_29 VGND VGND VPWR VPWR sky130_fd_sc_hd__fill_1
XFILLER_94_505 VGND VGND VPWR VPWR sky130_fd_sc_hd__fill_2
XFILLER_86_53 VPWR VGND VPWR VGND sky130_ef_sc_hd__decap_12
XFILLER_86_97 VPWR VGND VPWR VGND sky130_ef_sc_hd__decap_12
XTAP_TAPCELL_ROW_73_931 VGND VPWR sky130_fd_sc_hd__tapvpwrvgnd_1
XFILLER_62_446 VGND VGND VPWR VPWR sky130_fd_sc_hd__fill_1
XTAP_TAPCELL_ROW_17_379 VGND VPWR sky130_fd_sc_hd__tapvpwrvgnd_1
XTAP_TAPCELL_ROW_45_655 VGND VPWR sky130_fd_sc_hd__tapvpwrvgnd_1
X_2880_ net763 net634 net497 VGND VGND VPWR VPWR _1087_ sky130_fd_sc_hd__mux2_1
XFILLER_30_365 VGND VGND VPWR VPWR sky130_fd_sc_hd__fill_2
XFILLER_30_376 VGND VGND VPWR VPWR sky130_fd_sc_hd__fill_1
X_4550_ clknet_leaf_13_clk _0081_ VGND VGND VPWR VPWR array\[0\]\[11\] sky130_fd_sc_hd__dfxtp_1
Xhold517 array\[0\]\[17\] VGND VGND VPWR VPWR net1283 sky130_fd_sc_hd__dlygate4sd3_1
Xhold506 array\[14\]\[19\] VGND VGND VPWR VPWR net1272 sky130_fd_sc_hd__dlygate4sd3_1
XFILLER_7_561 VGND VGND VPWR VPWR sky130_fd_sc_hd__fill_1
X_3501_ net967 net251 _1519_ _1520_ VGND VGND VPWR VPWR _0264_ sky130_fd_sc_hd__o22a_1
X_4481_ clknet_leaf_6_clk _0012_ VGND VGND VPWR VPWR array\[5\]\[6\] sky130_fd_sc_hd__dfxtp_1
Xhold528 array\[0\]\[29\] VGND VGND VPWR VPWR net1294 sky130_fd_sc_hd__dlygate4sd3_1
Xhold539 array\[8\]\[21\] VGND VGND VPWR VPWR net1305 sky130_fd_sc_hd__dlygate4sd3_1
X_3432_ net616 net477 net363 net688 net263 VGND VGND VPWR VPWR _1472_ sky130_fd_sc_hd__a221o_1
X_3363_ net726 net176 VGND VGND VPWR VPWR _1423_ sky130_fd_sc_hd__and2_1
XFILLER_85_505 VPWR VGND VPWR VGND sky130_ef_sc_hd__decap_12
X_2314_ net1073 net323 _0694_ VGND VGND VPWR VPWR _0483_ sky130_fd_sc_hd__o21a_1
X_3294_ net578 net483 net368 net648 VGND VGND VPWR VPWR _1378_ sky130_fd_sc_hd__a22o_1
XFILLER_38_421 VGND VGND VPWR VPWR sky130_fd_sc_hd__decap_4
X_2245_ net1069 net323 _0648_ VGND VGND VPWR VPWR _0460_ sky130_fd_sc_hd__o21a_1
XFILLER_65_240 VGND VGND VPWR VPWR sky130_fd_sc_hd__fill_1
X_2176_ net651 VGND VGND VPWR VPWR _0587_ sky130_fd_sc_hd__inv_2
XTAP_TAPCELL_ROW_0_203 VGND VPWR sky130_fd_sc_hd__tapvpwrvgnd_1
XTAP_TAPCELL_ROW_84_1049 VGND VPWR sky130_fd_sc_hd__tapvpwrvgnd_1
XFILLER_80_232 VGND VGND VPWR VPWR sky130_fd_sc_hd__decap_4
XFILLER_15_27 VGND VGND VPWR VPWR sky130_fd_sc_hd__decap_8
XFILLER_40_129 VGND VGND VPWR VPWR sky130_fd_sc_hd__fill_2
X_4817_ clknet_leaf_15_clk _0348_ VGND VGND VPWR VPWR net145 sky130_fd_sc_hd__dfxtp_1
Xclkbuf_leaf_60_clk clknet_3_0__leaf_clk VGND VGND VPWR VPWR clknet_leaf_60_clk sky130_fd_sc_hd__clkbuf_8
X_4748_ clknet_leaf_20_clk _0279_ VGND VGND VPWR VPWR array\[10\]\[17\] sky130_fd_sc_hd__dfxtp_1
X_4679_ clknet_leaf_15_clk _0210_ VGND VGND VPWR VPWR array\[12\]\[12\] sky130_fd_sc_hd__dfxtp_1
XPHY_EDGE_ROW_1_Right_1 VGND VGND VPWR VPWR sky130_fd_sc_hd__decap_3
XFILLER_0_225 VGND VGND VPWR VPWR sky130_fd_sc_hd__fill_2
XFILLER_0_214 VGND VGND VPWR VPWR sky130_fd_sc_hd__decap_6
XFILLER_88_365 VGND VGND VPWR VPWR sky130_fd_sc_hd__decap_8
XFILLER_0_258 VGND VGND VPWR VPWR sky130_fd_sc_hd__decap_4
Xinput104 write_location0[1] VGND VGND VPWR VPWR net104 sky130_fd_sc_hd__clkbuf_2
XFILLER_48_218 VGND VGND VPWR VPWR sky130_fd_sc_hd__fill_1
XFILLER_56_240 VPWR VGND VPWR VGND sky130_ef_sc_hd__decap_12
XFILLER_29_465 VGND VGND VPWR VPWR sky130_fd_sc_hd__decap_3
XFILLER_71_221 VGND VGND VPWR VPWR sky130_fd_sc_hd__decap_3
XTAP_TAPCELL_ROW_70_901 VGND VPWR sky130_fd_sc_hd__tapvpwrvgnd_1
XTAP_TAPCELL_ROW_42_625 VGND VPWR sky130_fd_sc_hd__tapvpwrvgnd_1
XTAP_TAPCELL_ROW_14_349 VGND VPWR sky130_fd_sc_hd__tapvpwrvgnd_1
Xclkbuf_leaf_51_clk clknet_3_2__leaf_clk VGND VGND VPWR VPWR clknet_leaf_51_clk sky130_fd_sc_hd__clkbuf_8
XFILLER_4_531 VGND VGND VPWR VPWR sky130_fd_sc_hd__fill_1
XFILLER_79_310 VPWR VGND VPWR VGND sky130_ef_sc_hd__decap_12
XFILLER_67_505 VGND VGND VPWR VPWR sky130_fd_sc_hd__fill_1
XFILLER_67_538 VGND VGND VPWR VPWR sky130_fd_sc_hd__fill_1
XFILLER_94_368 VGND VGND VPWR VPWR sky130_fd_sc_hd__fill_1
XTAP_TAPCELL_ROW_58_780 VGND VPWR sky130_fd_sc_hd__tapvpwrvgnd_1
X_3981_ array\[5\]\[19\] net551 net527 array\[7\]\[19\] _1900_ VGND VGND VPWR VPWR
+ _1901_ sky130_fd_sc_hd__a221o_1
XFILLER_50_427 VGND VGND VPWR VPWR sky130_fd_sc_hd__fill_1
X_2932_ net729 net273 _1121_ net386 net270 VGND VGND VPWR VPWR _1122_ sky130_fd_sc_hd__a221o_1
XFILLER_62_298 VGND VGND VPWR VPWR sky130_fd_sc_hd__decap_8
XFILLER_94_3 VPWR VGND VPWR VGND sky130_ef_sc_hd__decap_12
Xclkbuf_leaf_42_clk clknet_3_3__leaf_clk VGND VGND VPWR VPWR clknet_leaf_42_clk sky130_fd_sc_hd__clkbuf_8
X_2863_ net739 net271 _1075_ net383 net268 VGND VGND VPWR VPWR _1076_ sky130_fd_sc_hd__a221o_1
X_4602_ clknet_leaf_47_clk _0133_ VGND VGND VPWR VPWR array\[15\]\[31\] sky130_fd_sc_hd__dfxtp_1
X_2794_ net1119 net285 net279 net607 _1029_ VGND VGND VPWR VPWR _0048_ sky130_fd_sc_hd__a221o_1
X_4533_ clknet_leaf_18_clk _0064_ VGND VGND VPWR VPWR array\[8\]\[26\] sky130_fd_sc_hd__dfxtp_1
XFILLER_7_83 VGND VGND VPWR VPWR sky130_fd_sc_hd__fill_1
Xhold325 net146 VGND VGND VPWR VPWR net1091 sky130_fd_sc_hd__dlygate4sd3_1
Xhold314 array\[5\]\[22\] VGND VGND VPWR VPWR net1080 sky130_fd_sc_hd__dlygate4sd3_1
Xhold303 array\[1\]\[2\] VGND VGND VPWR VPWR net1069 sky130_fd_sc_hd__dlygate4sd3_1
Xhold369 array\[0\]\[26\] VGND VGND VPWR VPWR net1135 sky130_fd_sc_hd__dlygate4sd3_1
Xhold336 array\[8\]\[22\] VGND VGND VPWR VPWR net1102 sky130_fd_sc_hd__dlygate4sd3_1
Xhold358 array\[9\]\[22\] VGND VGND VPWR VPWR net1124 sky130_fd_sc_hd__dlygate4sd3_1
X_4464_ clknet_leaf_1_clk _0575_ VGND VGND VPWR VPWR array\[4\]\[21\] sky130_fd_sc_hd__dfxtp_1
Xhold347 array\[13\]\[21\] VGND VGND VPWR VPWR net1113 sky130_fd_sc_hd__dlygate4sd3_1
X_4395_ clknet_leaf_22_clk _0506_ VGND VGND VPWR VPWR array\[2\]\[16\] sky130_fd_sc_hd__dfxtp_1
X_3415_ net1184 net262 _1459_ _1460_ VGND VGND VPWR VPWR _0238_ sky130_fd_sc_hd__o22a_1
XFILLER_58_516 VGND VGND VPWR VPWR sky130_fd_sc_hd__fill_1
X_3346_ net599 net482 net370 net673 net180 VGND VGND VPWR VPWR _1412_ sky130_fd_sc_hd__a221o_1
X_3277_ net644 net372 VGND VGND VPWR VPWR _1364_ sky130_fd_sc_hd__and2_1
XFILLER_66_560 VGND VGND VPWR VPWR sky130_fd_sc_hd__fill_2
X_2228_ _0589_ net757 _0633_ net522 VGND VGND VPWR VPWR _0634_ sky130_fd_sc_hd__a31o_1
XFILLER_26_26 VGND VGND VPWR VPWR sky130_fd_sc_hd__fill_2
XFILLER_26_37 VGND VGND VPWR VPWR sky130_fd_sc_hd__fill_1
Xclkbuf_leaf_33_clk clknet_3_6__leaf_clk VGND VGND VPWR VPWR clknet_leaf_33_clk sky130_fd_sc_hd__clkbuf_8
XTAP_TAPCELL_ROW_11_319 VGND VPWR sky130_fd_sc_hd__tapvpwrvgnd_1
XFILLER_5_328 VGND VGND VPWR VPWR sky130_fd_sc_hd__fill_1
XFILLER_49_505 VGND VGND VPWR VPWR sky130_fd_sc_hd__decap_3
XFILLER_76_324 VGND VGND VPWR VPWR sky130_fd_sc_hd__fill_1
XFILLER_67_66 VGND VGND VPWR VPWR sky130_fd_sc_hd__decap_4
XFILLER_49_527 VGND VGND VPWR VPWR sky130_fd_sc_hd__fill_1
XFILLER_67_88 VGND VGND VPWR VPWR sky130_fd_sc_hd__decap_4
XTAP_TAPCELL_ROW_55_750 VGND VPWR sky130_fd_sc_hd__tapvpwrvgnd_1
XTAP_TAPCELL_ROW_27_474 VGND VPWR sky130_fd_sc_hd__tapvpwrvgnd_1
XFILLER_32_438 VGND VGND VPWR VPWR sky130_fd_sc_hd__fill_2
Xclkbuf_leaf_24_clk clknet_3_7__leaf_clk VGND VGND VPWR VPWR clknet_leaf_24_clk sky130_fd_sc_hd__clkbuf_8
XFILLER_59_6 VPWR VGND VPWR VGND sky130_ef_sc_hd__decap_12
X_3200_ net568 net487 net183 net708 _1312_ VGND VGND VPWR VPWR _1313_ sky130_fd_sc_hd__a221o_1
X_4180_ net608 net235 net231 _2069_ VGND VGND VPWR VPWR _2070_ sky130_fd_sc_hd__a211o_1
X_3131_ net746 net186 _1263_ net190 VGND VGND VPWR VPWR _1264_ sky130_fd_sc_hd__a211o_1
XFILLER_94_165 VGND VGND VPWR VPWR sky130_fd_sc_hd__decap_3
X_3062_ net646 net576 net496 VGND VGND VPWR VPWR _1214_ sky130_fd_sc_hd__mux2_1
XFILLER_35_210 VPWR VGND VPWR VGND sky130_ef_sc_hd__decap_12
XTAP_TAPCELL_ROW_81_1019 VGND VPWR sky130_fd_sc_hd__tapvpwrvgnd_1
XFILLER_35_276 VGND VGND VPWR VPWR sky130_fd_sc_hd__decap_4
Xclkbuf_leaf_15_clk clknet_3_5__leaf_clk VGND VGND VPWR VPWR clknet_leaf_15_clk sky130_fd_sc_hd__clkbuf_8
X_3964_ array\[14\]\[17\] net469 net452 array\[12\]\[17\] VGND VGND VPWR VPWR _1886_
+ sky130_fd_sc_hd__a22o_1
X_2915_ net1243 net202 _1110_ VGND VGND VPWR VPWR _0088_ sky130_fd_sc_hd__o21a_1
X_3895_ array\[10\]\[11\] net461 net444 array\[8\]\[11\] VGND VGND VPWR VPWR _1823_
+ sky130_fd_sc_hd__a22o_1
X_2846_ net969 net284 _1061_ _1062_ VGND VGND VPWR VPWR _0067_ sky130_fd_sc_hd__o22a_1
Xhold100 array\[12\]\[31\] VGND VGND VPWR VPWR net866 sky130_fd_sc_hd__dlygate4sd3_1
X_2777_ net709 net281 VGND VGND VPWR VPWR _1019_ sky130_fd_sc_hd__and2_1
XTAP_TAPCELL_ROW_92_1126 VGND VPWR sky130_fd_sc_hd__tapvpwrvgnd_1
Xhold133 array\[12\]\[17\] VGND VGND VPWR VPWR net899 sky130_fd_sc_hd__dlygate4sd3_1
Xhold122 array\[14\]\[26\] VGND VGND VPWR VPWR net888 sky130_fd_sc_hd__dlygate4sd3_1
Xhold144 array\[7\]\[12\] VGND VGND VPWR VPWR net910 sky130_fd_sc_hd__dlygate4sd3_1
X_4516_ clknet_leaf_49_clk _0047_ VGND VGND VPWR VPWR array\[8\]\[9\] sky130_fd_sc_hd__dfxtp_1
Xhold111 array\[14\]\[10\] VGND VGND VPWR VPWR net877 sky130_fd_sc_hd__dlygate4sd3_1
Xhold166 array\[14\]\[17\] VGND VGND VPWR VPWR net932 sky130_fd_sc_hd__dlygate4sd3_1
Xhold155 array\[7\]\[16\] VGND VGND VPWR VPWR net921 sky130_fd_sc_hd__dlygate4sd3_1
X_4447_ clknet_leaf_42_clk _0558_ VGND VGND VPWR VPWR array\[4\]\[4\] sky130_fd_sc_hd__dfxtp_1
Xhold177 array\[3\]\[1\] VGND VGND VPWR VPWR net943 sky130_fd_sc_hd__dlygate4sd3_1
Xhold199 array\[14\]\[8\] VGND VGND VPWR VPWR net965 sky130_fd_sc_hd__dlygate4sd3_1
Xfanout602 net82 VGND VGND VPWR VPWR net602 sky130_fd_sc_hd__clkbuf_2
Xfanout624 net72 VGND VGND VPWR VPWR net624 sky130_fd_sc_hd__clkbuf_2
Xhold188 array\[6\]\[4\] VGND VGND VPWR VPWR net954 sky130_fd_sc_hd__dlygate4sd3_1
Xfanout613 net77 VGND VGND VPWR VPWR net613 sky130_fd_sc_hd__buf_2
Xfanout646 net62 VGND VGND VPWR VPWR net646 sky130_fd_sc_hd__dlymetal6s2s_1
Xfanout657 net59 VGND VGND VPWR VPWR net657 sky130_fd_sc_hd__buf_2
X_4378_ clknet_leaf_45_clk _0489_ VGND VGND VPWR VPWR array\[1\]\[31\] sky130_fd_sc_hd__dfxtp_1
Xfanout635 net67 VGND VGND VPWR VPWR net635 sky130_fd_sc_hd__clkbuf_2
XFILLER_85_121 VGND VGND VPWR VPWR sky130_fd_sc_hd__decap_3
Xfanout679 net48 VGND VGND VPWR VPWR net679 sky130_fd_sc_hd__buf_2
X_3329_ net751 net173 VGND VGND VPWR VPWR _1401_ sky130_fd_sc_hd__and2_1
Xfanout668 net54 VGND VGND VPWR VPWR net668 sky130_fd_sc_hd__clkbuf_2
XTAP_TAPCELL_ROW_69_897 VGND VPWR sky130_fd_sc_hd__tapvpwrvgnd_1
XFILLER_14_405 VGND VGND VPWR VPWR sky130_fd_sc_hd__decap_4
XFILLER_41_202 VGND VGND VPWR VPWR sky130_fd_sc_hd__fill_1
XTAP_TAPCELL_ROW_52_720 VGND VPWR sky130_fd_sc_hd__tapvpwrvgnd_1
XFILLER_81_393 VGND VGND VPWR VPWR sky130_fd_sc_hd__decap_3
XTAP_TAPCELL_ROW_24_444 VGND VPWR sky130_fd_sc_hd__tapvpwrvgnd_1
XFILLER_22_460 VGND VGND VPWR VPWR sky130_fd_sc_hd__fill_1
XFILLER_41_279 VGND VGND VPWR VPWR sky130_fd_sc_hd__fill_1
XFILLER_5_125 VPWR VGND VPWR VGND sky130_ef_sc_hd__decap_12
XFILLER_78_65 VGND VGND VPWR VPWR sky130_fd_sc_hd__decap_8
XFILLER_94_53 VGND VGND VPWR VPWR sky130_fd_sc_hd__decap_3
XFILLER_91_113 VPWR VGND VPWR VGND sky130_ef_sc_hd__decap_12
XFILLER_17_221 VGND VGND VPWR VPWR sky130_fd_sc_hd__decap_3
XFILLER_94_97 VPWR VGND VPWR VGND sky130_ef_sc_hd__decap_12
XFILLER_17_232 VGND VGND VPWR VPWR sky130_fd_sc_hd__decap_8
XFILLER_17_265 VGND VGND VPWR VPWR sky130_fd_sc_hd__decap_3
XFILLER_17_276 VGND VGND VPWR VPWR sky130_fd_sc_hd__decap_4
X_2700_ net1006 _0964_ net294 VGND VGND VPWR VPWR _0019_ sky130_fd_sc_hd__mux2_1
XFILLER_13_482 VPWR VGND VPWR VGND sky130_ef_sc_hd__decap_12
XFILLER_9_442 VGND VGND VPWR VPWR sky130_fd_sc_hd__decap_6
X_3680_ net1123 net238 _1648_ VGND VGND VPWR VPWR _0315_ sky130_fd_sc_hd__o21a_1
XFILLER_9_497 VGND VGND VPWR VPWR sky130_fd_sc_hd__decap_6
X_2631_ net873 net299 _0915_ _0916_ VGND VGND VPWR VPWR _0578_ sky130_fd_sc_hd__o22a_1
X_2562_ net1205 net297 _0871_ VGND VGND VPWR VPWR _0554_ sky130_fd_sc_hd__o21a_1
XFILLER_57_3 VPWR VGND VPWR VGND sky130_ef_sc_hd__decap_12
X_4301_ net1070 net218 _2148_ _2149_ VGND VGND VPWR VPWR _0439_ sky130_fd_sc_hd__o22a_1
X_4232_ net722 net235 net231 _2103_ VGND VGND VPWR VPWR _2104_ sky130_fd_sc_hd__a211o_1
X_2493_ net685 net613 net516 VGND VGND VPWR VPWR _0820_ sky130_fd_sc_hd__mux2_1
Xclkbuf_leaf_4_clk clknet_3_4__leaf_clk VGND VGND VPWR VPWR clknet_leaf_4_clk sky130_fd_sc_hd__clkbuf_8
X_4163_ net917 net226 _2057_ _2058_ VGND VGND VPWR VPWR _0392_ sky130_fd_sc_hd__o22a_1
X_3114_ net1092 net161 _1252_ VGND VGND VPWR VPWR _0145_ sky130_fd_sc_hd__o21a_1
X_4094_ array\[5\]\[29\] net551 net531 array\[7\]\[29\] _2003_ VGND VGND VPWR VPWR
+ _2004_ sky130_fd_sc_hd__a221o_1
X_3045_ net730 net196 _1202_ net382 VGND VGND VPWR VPWR _1203_ sky130_fd_sc_hd__a22o_1
XFILLER_82_168 VGND VGND VPWR VPWR sky130_fd_sc_hd__fill_1
XTAP_TAPCELL_ROW_66_867 VGND VPWR sky130_fd_sc_hd__tapvpwrvgnd_1
XFILLER_82_179 VGND VGND VPWR VPWR sky130_fd_sc_hd__fill_1
XFILLER_63_382 VGND VGND VPWR VPWR sky130_fd_sc_hd__fill_2
XFILLER_63_393 VGND VGND VPWR VPWR sky130_fd_sc_hd__fill_2
X_3947_ array\[14\]\[16\] net469 net452 array\[12\]\[16\] VGND VGND VPWR VPWR _1870_
+ sky130_fd_sc_hd__a22o_1
XTAP_TAPCELL_ROW_21_414 VGND VPWR sky130_fd_sc_hd__tapvpwrvgnd_1
X_3878_ net215 _1806_ _1807_ VGND VGND VPWR VPWR _1808_ sky130_fd_sc_hd__or3_1
X_2829_ net593 net503 net278 net667 net287 VGND VGND VPWR VPWR _1052_ sky130_fd_sc_hd__a221o_1
XFILLER_78_419 VGND VGND VPWR VPWR sky130_fd_sc_hd__fill_1
Xfanout421 net422 VGND VGND VPWR VPWR net421 sky130_fd_sc_hd__clkbuf_4
Xfanout410 net414 VGND VGND VPWR VPWR net410 sky130_fd_sc_hd__clkbuf_4
Xfanout432 _1611_ VGND VGND VPWR VPWR net432 sky130_fd_sc_hd__buf_2
Xfanout454 net455 VGND VGND VPWR VPWR net454 sky130_fd_sc_hd__clkbuf_2
Xfanout443 net446 VGND VGND VPWR VPWR net443 sky130_fd_sc_hd__clkbuf_2
Xfanout465 net472 VGND VGND VPWR VPWR net465 sky130_fd_sc_hd__clkbuf_2
Xfanout476 _1507_ VGND VGND VPWR VPWR net476 sky130_fd_sc_hd__buf_4
Xfanout498 net499 VGND VGND VPWR VPWR net498 sky130_fd_sc_hd__buf_4
Xfanout487 _1296_ VGND VGND VPWR VPWR net487 sky130_fd_sc_hd__buf_4
XFILLER_73_113 VGND VGND VPWR VPWR sky130_fd_sc_hd__fill_2
XFILLER_27_541 VPWR VGND VPWR VGND sky130_ef_sc_hd__decap_12
XFILLER_64_56 VPWR VGND VPWR VGND sky130_ef_sc_hd__decap_12
XFILLER_6_445 VPWR VGND VPWR VGND sky130_ef_sc_hd__decap_12
XFILLER_6_489 VPWR VGND VPWR VGND sky130_ef_sc_hd__decap_12
XTAP_TAPCELL_ROW_9_294 VGND VPWR sky130_fd_sc_hd__tapvpwrvgnd_1
XFILLER_77_474 VGND VGND VPWR VPWR sky130_fd_sc_hd__decap_6
XFILLER_92_477 VPWR VGND VPWR VGND sky130_ef_sc_hd__decap_12
XFILLER_92_466 VGND VGND VPWR VPWR sky130_fd_sc_hd__decap_8
Xclkbuf_3_7__f_clk clknet_0_clk VGND VGND VPWR VPWR clknet_3_7__leaf_clk sky130_fd_sc_hd__clkbuf_16
XFILLER_18_552 VGND VGND VPWR VPWR sky130_fd_sc_hd__decap_8
XTAP_TAPCELL_ROW_63_837 VGND VPWR sky130_fd_sc_hd__tapvpwrvgnd_1
X_4850_ clknet_leaf_62_clk _0381_ VGND VGND VPWR VPWR net115 sky130_fd_sc_hd__dfxtp_1
XFILLER_33_533 VGND VGND VPWR VPWR sky130_fd_sc_hd__fill_2
X_3801_ array\[5\]\[3\] net548 net535 array\[7\]\[3\] _1736_ VGND VGND VPWR VPWR _1737_
+ sky130_fd_sc_hd__a221o_1
X_4781_ clknet_leaf_63_clk _0312_ VGND VGND VPWR VPWR ready_check\[15\] sky130_fd_sc_hd__dfxtp_1
X_3732_ net736 net348 net419 VGND VGND VPWR VPWR _1682_ sky130_fd_sc_hd__and3_1
X_3663_ net211 _0609_ _0614_ net379 _1634_ VGND VGND VPWR VPWR _0312_ sky130_fd_sc_hd__o32a_1
Xclkload20 clknet_leaf_51_clk VGND VGND VPWR VPWR clkload20/X sky130_fd_sc_hd__clkbuf_4
Xclkload53 clknet_leaf_28_clk VGND VGND VPWR VPWR clkload53/Y sky130_fd_sc_hd__clkinv_4
X_2614_ net985 net298 _0904_ _0905_ VGND VGND VPWR VPWR _0572_ sky130_fd_sc_hd__o22a_1
Xclkload31 clknet_leaf_7_clk VGND VGND VPWR VPWR clkload31/Y sky130_fd_sc_hd__inv_6
Xclkload42 clknet_leaf_21_clk VGND VGND VPWR VPWR clkload42/X sky130_fd_sc_hd__clkbuf_8
X_3594_ tail\[1\] tail\[0\] tail\[2\] VGND VGND VPWR VPWR _1582_ sky130_fd_sc_hd__a21oi_1
X_2545_ net656 net1 net5 net113 VGND VGND VPWR VPWR _0855_ sky130_fd_sc_hd__nand4b_1
X_2476_ net699 net304 _0808_ net402 net308 VGND VGND VPWR VPWR _0809_ sky130_fd_sc_hd__a221o_1
X_4215_ net1239 net225 _2091_ _2092_ VGND VGND VPWR VPWR _0410_ sky130_fd_sc_hd__o22a_1
XFILLER_68_474 VGND VGND VPWR VPWR sky130_fd_sc_hd__fill_2
X_4146_ net630 net233 VGND VGND VPWR VPWR _2046_ sky130_fd_sc_hd__and2_1
XTAP_TAPCELL_ROW_79_992 VGND VPWR sky130_fd_sc_hd__tapvpwrvgnd_1
XFILLER_18_27 VGND VGND VPWR VPWR sky130_fd_sc_hd__fill_1
X_4077_ array\[5\]\[27\] net555 net540 array\[7\]\[27\] _1988_ VGND VGND VPWR VPWR
+ _1989_ sky130_fd_sc_hd__a221o_1
X_3028_ net1010 _1191_ net167 VGND VGND VPWR VPWR _0120_ sky130_fd_sc_hd__mux2_1
XFILLER_70_127 VPWR VGND VPWR VGND sky130_ef_sc_hd__decap_12
Xclkload3 clknet_3_3__leaf_clk VGND VGND VPWR VPWR clkload3/X sky130_fd_sc_hd__clkbuf_8
XFILLER_78_205 VGND VGND VPWR VPWR sky130_fd_sc_hd__fill_1
Xfanout240 _1640_ VGND VGND VPWR VPWR net240 sky130_fd_sc_hd__clkbuf_4
XTAP_TAPCELL_ROW_6_264 VGND VPWR sky130_fd_sc_hd__tapvpwrvgnd_1
Xfanout273 net274 VGND VGND VPWR VPWR net273 sky130_fd_sc_hd__buf_4
Xfanout251 _1512_ VGND VGND VPWR VPWR net251 sky130_fd_sc_hd__clkbuf_4
Xfanout262 _1440_ VGND VGND VPWR VPWR net262 sky130_fd_sc_hd__buf_2
Xfanout284 _1008_ VGND VGND VPWR VPWR net284 sky130_fd_sc_hd__buf_4
Xfanout295 _0936_ VGND VGND VPWR VPWR net295 sky130_fd_sc_hd__buf_4
XFILLER_27_393 VGND VGND VPWR VPWR sky130_fd_sc_hd__decap_4
XTAP_TAPCELL_ROW_60_807 VGND VPWR sky130_fd_sc_hd__tapvpwrvgnd_1
XFILLER_10_293 VGND VGND VPWR VPWR sky130_fd_sc_hd__fill_1
XFILLER_69_216 VGND VGND VPWR VPWR sky130_fd_sc_hd__decap_8
X_2330_ net643 net573 net521 VGND VGND VPWR VPWR _0705_ sky130_fd_sc_hd__mux2_1
X_2261_ net631 net760 net524 VGND VGND VPWR VPWR _0659_ sky130_fd_sc_hd__mux2_1
XFILLER_84_219 VGND VGND VPWR VPWR sky130_fd_sc_hd__decap_6
X_4000_ net353 _1912_ _1916_ net416 VGND VGND VPWR VPWR _1919_ sky130_fd_sc_hd__a22o_1
X_2192_ net561 net217 net651 VGND VGND VPWR VPWR _0603_ sky130_fd_sc_hd__a21oi_1
XFILLER_37_113 VGND VGND VPWR VPWR sky130_fd_sc_hd__decap_8
XTAP_TAPCELL_ROW_76_962 VGND VPWR sky130_fd_sc_hd__tapvpwrvgnd_1
XTAP_TAPCELL_ROW_48_686 VGND VPWR sky130_fd_sc_hd__tapvpwrvgnd_1
X_4902_ clknet_leaf_10_clk _0433_ VGND VGND VPWR VPWR array\[6\]\[13\] sky130_fd_sc_hd__dfxtp_1
XFILLER_21_503 VGND VGND VPWR VPWR sky130_fd_sc_hd__fill_1
X_4833_ clknet_leaf_51_clk _0364_ VGND VGND VPWR VPWR net130 sky130_fd_sc_hd__dfxtp_1
XFILLER_21_525 VGND VGND VPWR VPWR sky130_fd_sc_hd__decap_6
X_4764_ clknet_leaf_62_clk _0295_ VGND VGND VPWR VPWR tail\[1\] sky130_fd_sc_hd__dfxtp_1
X_3715_ net1159 net242 _1641_ net752 _1671_ VGND VGND VPWR VPWR _0327_ sky130_fd_sc_hd__a221o_1
X_4695_ clknet_leaf_50_clk _0226_ VGND VGND VPWR VPWR array\[12\]\[28\] sky130_fd_sc_hd__dfxtp_1
X_3646_ net212 _1589_ _1617_ _1623_ VGND VGND VPWR VPWR _0306_ sky130_fd_sc_hd__o31a_1
X_3577_ net581 net473 net359 net657 net254 VGND VGND VPWR VPWR _1571_ sky130_fd_sc_hd__a221o_1
XFILLER_88_525 VGND VGND VPWR VPWR sky130_fd_sc_hd__decap_6
X_2528_ net916 net206 _0843_ VGND VGND VPWR VPWR _0548_ sky130_fd_sc_hd__o21a_1
Xhold15 net128 VGND VGND VPWR VPWR net781 sky130_fd_sc_hd__dlygate4sd3_1
Xhold26 array\[13\]\[5\] VGND VGND VPWR VPWR net792 sky130_fd_sc_hd__dlygate4sd3_1
X_2459_ net1163 net205 _0797_ VGND VGND VPWR VPWR _0525_ sky130_fd_sc_hd__o21a_1
XFILLER_29_48 VGND VGND VPWR VPWR sky130_fd_sc_hd__fill_1
Xhold37 array\[6\]\[3\] VGND VGND VPWR VPWR net803 sky130_fd_sc_hd__dlygate4sd3_1
Xhold59 net123 VGND VGND VPWR VPWR net825 sky130_fd_sc_hd__dlygate4sd3_1
Xhold48 array\[2\]\[8\] VGND VGND VPWR VPWR net814 sky130_fd_sc_hd__dlygate4sd3_1
XFILLER_68_282 VPWR VGND VPWR VGND sky130_ef_sc_hd__decap_12
XTAP_TAPCELL_ROW_3_234 VGND VPWR sky130_fd_sc_hd__tapvpwrvgnd_1
X_4129_ tail\[1\] net1114 net652 VGND VGND VPWR VPWR _0382_ sky130_fd_sc_hd__mux2_1
XFILLER_83_263 VGND VGND VPWR VPWR sky130_fd_sc_hd__decap_8
XFILLER_56_477 VGND VGND VPWR VPWR sky130_fd_sc_hd__fill_1
XFILLER_12_525 VGND VGND VPWR VPWR sky130_fd_sc_hd__decap_6
XFILLER_3_223 VGND VGND VPWR VPWR sky130_fd_sc_hd__fill_1
XFILLER_86_65 VPWR VGND VPWR VGND sky130_ef_sc_hd__decap_12
XFILLER_19_70 VGND VGND VPWR VPWR sky130_fd_sc_hd__fill_2
XFILLER_74_285 VGND VGND VPWR VPWR sky130_fd_sc_hd__fill_2
XTAP_TAPCELL_ROW_73_932 VGND VPWR sky130_fd_sc_hd__tapvpwrvgnd_1
XTAP_TAPCELL_ROW_45_656 VGND VPWR sky130_fd_sc_hd__tapvpwrvgnd_1
X_3500_ net578 net474 net361 net648 net253 VGND VGND VPWR VPWR _1520_ sky130_fd_sc_hd__a221o_1
X_4480_ clknet_leaf_31_clk _0011_ VGND VGND VPWR VPWR array\[5\]\[5\] sky130_fd_sc_hd__dfxtp_1
Xhold507 array\[8\]\[31\] VGND VGND VPWR VPWR net1273 sky130_fd_sc_hd__dlygate4sd3_1
Xhold518 array\[0\]\[2\] VGND VGND VPWR VPWR net1284 sky130_fd_sc_hd__dlygate4sd3_1
Xhold529 array\[3\]\[28\] VGND VGND VPWR VPWR net1295 sky130_fd_sc_hd__dlygate4sd3_1
X_3431_ net752 net255 VGND VGND VPWR VPWR _1471_ sky130_fd_sc_hd__and2_1
X_3362_ net993 net154 _1421_ _1422_ VGND VGND VPWR VPWR _0223_ sky130_fd_sc_hd__o22a_1
X_2313_ net727 net319 _0693_ net410 net327 VGND VGND VPWR VPWR _0694_ sky130_fd_sc_hd__a221o_1
XFILLER_85_517 VPWR VGND VPWR VGND sky130_ef_sc_hd__decap_12
X_3293_ net1246 net153 _1376_ _1377_ VGND VGND VPWR VPWR _0199_ sky130_fd_sc_hd__o22a_1
X_2244_ net717 net319 _0647_ net410 net327 VGND VGND VPWR VPWR _0648_ sky130_fd_sc_hd__a221o_1
X_2175_ net753 VGND VGND VPWR VPWR _0586_ sky130_fd_sc_hd__inv_2
XFILLER_93_561 VGND VGND VPWR VPWR sky130_fd_sc_hd__fill_1
XTAP_TAPCELL_ROW_0_204 VGND VPWR sky130_fd_sc_hd__tapvpwrvgnd_1
XFILLER_25_116 VGND VGND VPWR VPWR sky130_fd_sc_hd__fill_2
XFILLER_38_499 VGND VGND VPWR VPWR sky130_fd_sc_hd__decap_8
XFILLER_80_244 VGND VGND VPWR VPWR sky130_fd_sc_hd__decap_8
X_4816_ clknet_leaf_43_clk _0347_ VGND VGND VPWR VPWR net142 sky130_fd_sc_hd__dfxtp_1
XFILLER_61_491 VPWR VGND VPWR VGND sky130_ef_sc_hd__decap_12
X_4747_ clknet_leaf_21_clk _0278_ VGND VGND VPWR VPWR array\[10\]\[16\] sky130_fd_sc_hd__dfxtp_1
X_4678_ clknet_leaf_14_clk _0209_ VGND VGND VPWR VPWR array\[12\]\[11\] sky130_fd_sc_hd__dfxtp_1
X_3629_ net562 ready_check\[8\] _1608_ _1006_ VGND VGND VPWR VPWR _1609_ sky130_fd_sc_hd__a31o_1
XFILLER_88_333 VGND VGND VPWR VPWR sky130_fd_sc_hd__decap_4
XFILLER_0_237 VGND VGND VPWR VPWR sky130_fd_sc_hd__decap_4
Xinput105 write_location0[2] VGND VGND VPWR VPWR net105 sky130_fd_sc_hd__clkbuf_2
XFILLER_56_230 VGND VGND VPWR VPWR sky130_fd_sc_hd__fill_2
XFILLER_84_561 VGND VGND VPWR VPWR sky130_fd_sc_hd__fill_1
XFILLER_29_488 VGND VGND VPWR VPWR sky130_fd_sc_hd__fill_1
XFILLER_56_296 VPWR VGND VPWR VGND sky130_ef_sc_hd__decap_12
XTAP_TAPCELL_ROW_70_902 VGND VPWR sky130_fd_sc_hd__tapvpwrvgnd_1
XFILLER_71_277 VGND VGND VPWR VPWR sky130_fd_sc_hd__decap_3
XTAP_TAPCELL_ROW_42_626 VGND VPWR sky130_fd_sc_hd__tapvpwrvgnd_1
XFILLER_79_322 VGND VGND VPWR VPWR sky130_fd_sc_hd__decap_8
XFILLER_94_325 VGND VGND VPWR VPWR sky130_fd_sc_hd__fill_1
XFILLER_94_358 VGND VGND VPWR VPWR sky130_fd_sc_hd__fill_2
XFILLER_75_561 VGND VGND VPWR VPWR sky130_fd_sc_hd__fill_1
XFILLER_90_531 VGND VGND VPWR VPWR sky130_fd_sc_hd__fill_1
XFILLER_47_296 VGND VGND VPWR VPWR sky130_fd_sc_hd__decap_3
XTAP_TAPCELL_ROW_58_781 VGND VPWR sky130_fd_sc_hd__tapvpwrvgnd_1
X_3980_ array\[6\]\[19\] net457 net440 array\[4\]\[19\] VGND VGND VPWR VPWR _1900_
+ sky130_fd_sc_hd__a22o_1
X_2931_ net591 net665 net499 VGND VGND VPWR VPWR _1121_ sky130_fd_sc_hd__mux2_1
XFILLER_62_288 VGND VGND VPWR VPWR sky130_fd_sc_hd__decap_3
XFILLER_15_193 VGND VGND VPWR VPWR sky130_fd_sc_hd__decap_4
Xclkbuf_0_clk clk VGND VGND VPWR VPWR clknet_0_clk sky130_fd_sc_hd__clkbuf_16
X_4601_ clknet_leaf_25_clk _0132_ VGND VGND VPWR VPWR array\[15\]\[30\] sky130_fd_sc_hd__dfxtp_1
XFILLER_87_3 VPWR VGND VPWR VGND sky130_ef_sc_hd__decap_12
X_2862_ net601 net675 net497 VGND VGND VPWR VPWR _1075_ sky130_fd_sc_hd__mux2_1
X_2793_ net623 net505 net275 net695 VGND VGND VPWR VPWR _1029_ sky130_fd_sc_hd__a22o_1
X_4532_ clknet_leaf_40_clk _0063_ VGND VGND VPWR VPWR array\[8\]\[25\] sky130_fd_sc_hd__dfxtp_1
Xhold326 array\[14\]\[11\] VGND VGND VPWR VPWR net1092 sky130_fd_sc_hd__dlygate4sd3_1
Xhold315 array\[6\]\[5\] VGND VGND VPWR VPWR net1081 sky130_fd_sc_hd__dlygate4sd3_1
Xhold304 array\[6\]\[19\] VGND VGND VPWR VPWR net1070 sky130_fd_sc_hd__dlygate4sd3_1
X_4463_ clknet_leaf_6_clk _0574_ VGND VGND VPWR VPWR array\[4\]\[20\] sky130_fd_sc_hd__dfxtp_1
Xhold359 array\[9\]\[8\] VGND VGND VPWR VPWR net1125 sky130_fd_sc_hd__dlygate4sd3_1
X_3414_ net760 net479 net366 net631 net265 VGND VGND VPWR VPWR _1460_ sky130_fd_sc_hd__a221o_1
Xhold337 array\[15\]\[22\] VGND VGND VPWR VPWR net1103 sky130_fd_sc_hd__dlygate4sd3_1
Xhold348 net116 VGND VGND VPWR VPWR net1114 sky130_fd_sc_hd__dlygate4sd3_1
XPHY_EDGE_ROW_15_Right_15 VGND VGND VPWR VPWR sky130_fd_sc_hd__decap_3
X_4394_ clknet_leaf_38_clk _0505_ VGND VGND VPWR VPWR array\[2\]\[15\] sky130_fd_sc_hd__dfxtp_1
X_3345_ net737 net176 VGND VGND VPWR VPWR _1411_ sky130_fd_sc_hd__and2_1
X_3276_ net770 _1363_ net160 VGND VGND VPWR VPWR _0196_ sky130_fd_sc_hd__mux2_1
XFILLER_85_303 VPWR VGND VPWR VGND sky130_ef_sc_hd__decap_12
X_2227_ net110 _0632_ VGND VGND VPWR VPWR _0633_ sky130_fd_sc_hd__nor2_1
XFILLER_26_436 VGND VGND VPWR VPWR sky130_fd_sc_hd__decap_4
XFILLER_53_222 VGND VGND VPWR VPWR sky130_fd_sc_hd__fill_2
XPHY_EDGE_ROW_24_Right_24 VGND VGND VPWR VPWR sky130_fd_sc_hd__decap_3
XFILLER_41_428 VGND VGND VPWR VPWR sky130_fd_sc_hd__fill_1
XFILLER_53_288 VPWR VGND VPWR VGND sky130_ef_sc_hd__decap_12
XFILLER_34_491 VGND VGND VPWR VPWR sky130_fd_sc_hd__fill_1
XFILLER_21_163 VGND VGND VPWR VPWR sky130_fd_sc_hd__decap_4
XPHY_EDGE_ROW_33_Right_33 VGND VGND VPWR VPWR sky130_fd_sc_hd__decap_3
XFILLER_88_141 VGND VGND VPWR VPWR sky130_fd_sc_hd__decap_8
XFILLER_57_550 VGND VGND VPWR VPWR sky130_fd_sc_hd__fill_2
XFILLER_57_561 VGND VGND VPWR VPWR sky130_fd_sc_hd__fill_1
XFILLER_84_380 VGND VGND VPWR VPWR sky130_fd_sc_hd__fill_1
XPHY_EDGE_ROW_42_Right_42 VGND VGND VPWR VPWR sky130_fd_sc_hd__decap_3
XFILLER_83_55 VGND VGND VPWR VPWR sky130_fd_sc_hd__fill_1
XTAP_TAPCELL_ROW_55_751 VGND VPWR sky130_fd_sc_hd__tapvpwrvgnd_1
XTAP_TAPCELL_ROW_27_475 VGND VPWR sky130_fd_sc_hd__tapvpwrvgnd_1
XPHY_EDGE_ROW_51_Right_51 VGND VGND VPWR VPWR sky130_fd_sc_hd__decap_3
XFILLER_4_395 VPWR VGND VPWR VGND sky130_ef_sc_hd__decap_12
X_3130_ net610 net492 net376 net682 VGND VGND VPWR VPWR _1263_ sky130_fd_sc_hd__a22o_1
XFILLER_94_177 VGND VGND VPWR VPWR sky130_fd_sc_hd__fill_1
X_3061_ net918 _1213_ net166 VGND VGND VPWR VPWR _0131_ sky130_fd_sc_hd__mux2_1
XFILLER_48_561 VGND VGND VPWR VPWR sky130_fd_sc_hd__fill_1
XPHY_EDGE_ROW_60_Right_60 VGND VGND VPWR VPWR sky130_fd_sc_hd__decap_3
XFILLER_94_188 VGND VGND VPWR VPWR sky130_fd_sc_hd__decap_4
XFILLER_75_391 VGND VGND VPWR VPWR sky130_fd_sc_hd__fill_1
XFILLER_35_222 VGND VGND VPWR VPWR sky130_fd_sc_hd__fill_2
XFILLER_35_255 VGND VGND VPWR VPWR sky130_fd_sc_hd__fill_1
XFILLER_23_417 VGND VGND VPWR VPWR sky130_fd_sc_hd__decap_4
XFILLER_90_394 VPWR VGND VPWR VGND sky130_ef_sc_hd__decap_12
X_3963_ array\[1\]\[17\] net554 net540 array\[3\]\[17\] _1884_ VGND VGND VPWR VPWR
+ _1885_ sky130_fd_sc_hd__a221o_1
X_2914_ net743 net274 _1109_ net384 _1072_ VGND VGND VPWR VPWR _1110_ sky130_fd_sc_hd__a221o_1
X_3894_ array\[5\]\[11\] net547 net537 array\[7\]\[11\] _1821_ VGND VGND VPWR VPWR
+ _1822_ sky130_fd_sc_hd__a221o_1
XFILLER_31_461 VGND VGND VPWR VPWR sky130_fd_sc_hd__fill_1
XFILLER_50_269 VGND VGND VPWR VPWR sky130_fd_sc_hd__fill_1
X_2845_ net579 net505 net275 net649 net285 VGND VGND VPWR VPWR _1062_ sky130_fd_sc_hd__a221o_1
X_4515_ clknet_leaf_36_clk _0046_ VGND VGND VPWR VPWR array\[8\]\[8\] sky130_fd_sc_hd__dfxtp_1
Xhold101 array\[10\]\[9\] VGND VGND VPWR VPWR net867 sky130_fd_sc_hd__dlygate4sd3_1
X_2776_ net1079 net283 _1017_ _1018_ VGND VGND VPWR VPWR _0041_ sky130_fd_sc_hd__o22a_1
Xhold123 array\[10\]\[31\] VGND VGND VPWR VPWR net889 sky130_fd_sc_hd__dlygate4sd3_1
Xhold134 net117 VGND VGND VPWR VPWR net900 sky130_fd_sc_hd__dlygate4sd3_1
Xhold112 array\[9\]\[28\] VGND VGND VPWR VPWR net878 sky130_fd_sc_hd__dlygate4sd3_1
XTAP_TAPCELL_ROW_92_1127 VGND VPWR sky130_fd_sc_hd__tapvpwrvgnd_1
Xhold167 array\[7\]\[5\] VGND VGND VPWR VPWR net933 sky130_fd_sc_hd__dlygate4sd3_1
Xhold145 array\[13\]\[29\] VGND VGND VPWR VPWR net911 sky130_fd_sc_hd__dlygate4sd3_1
Xhold156 array\[15\]\[7\] VGND VGND VPWR VPWR net922 sky130_fd_sc_hd__dlygate4sd3_1
X_4446_ clknet_leaf_4_clk _0557_ VGND VGND VPWR VPWR array\[4\]\[3\] sky130_fd_sc_hd__dfxtp_1
X_4377_ clknet_leaf_24_clk _0488_ VGND VGND VPWR VPWR array\[1\]\[30\] sky130_fd_sc_hd__dfxtp_1
Xhold189 array\[14\]\[28\] VGND VGND VPWR VPWR net955 sky130_fd_sc_hd__dlygate4sd3_1
Xfanout603 net81 VGND VGND VPWR VPWR net603 sky130_fd_sc_hd__buf_2
Xhold178 array\[3\]\[0\] VGND VGND VPWR VPWR net944 sky130_fd_sc_hd__dlygate4sd3_1
Xfanout614 net77 VGND VGND VPWR VPWR net614 sky130_fd_sc_hd__clkbuf_2
X_3328_ _1399_ _1400_ VGND VGND VPWR VPWR _0211_ sky130_fd_sc_hd__or2_1
Xfanout625 net71 VGND VGND VPWR VPWR net625 sky130_fd_sc_hd__buf_2
Xfanout658 net59 VGND VGND VPWR VPWR net658 sky130_fd_sc_hd__dlymetal6s2s_1
Xfanout647 net648 VGND VGND VPWR VPWR net647 sky130_fd_sc_hd__clkbuf_2
Xfanout636 net67 VGND VGND VPWR VPWR net636 sky130_fd_sc_hd__clkbuf_2
XFILLER_85_111 VGND VGND VPWR VPWR sky130_fd_sc_hd__fill_1
Xfanout669 net53 VGND VGND VPWR VPWR net669 sky130_fd_sc_hd__buf_2
XFILLER_85_177 VGND VGND VPWR VPWR sky130_fd_sc_hd__decap_3
X_3259_ net664 net372 VGND VGND VPWR VPWR _1352_ sky130_fd_sc_hd__and2_1
XFILLER_39_561 VGND VGND VPWR VPWR sky130_fd_sc_hd__fill_1
XTAP_TAPCELL_ROW_69_898 VGND VPWR sky130_fd_sc_hd__tapvpwrvgnd_1
XFILLER_54_531 VGND VGND VPWR VPWR sky130_fd_sc_hd__fill_1
XFILLER_81_361 VGND VGND VPWR VPWR sky130_fd_sc_hd__decap_6
XTAP_TAPCELL_ROW_24_445 VGND VPWR sky130_fd_sc_hd__tapvpwrvgnd_1
XFILLER_41_225 VGND VGND VPWR VPWR sky130_fd_sc_hd__decap_8
XTAP_TAPCELL_ROW_52_721 VGND VPWR sky130_fd_sc_hd__tapvpwrvgnd_1
XFILLER_22_450 VGND VGND VPWR VPWR sky130_fd_sc_hd__fill_1
XFILLER_5_137 VPWR VGND VPWR VGND sky130_ef_sc_hd__decap_12
XFILLER_49_369 VGND VGND VPWR VPWR sky130_fd_sc_hd__decap_3
XFILLER_91_125 VGND VGND VPWR VPWR sky130_fd_sc_hd__decap_8
XFILLER_91_169 VGND VGND VPWR VPWR sky130_fd_sc_hd__decap_8
XFILLER_17_288 VGND VGND VPWR VPWR sky130_fd_sc_hd__fill_1
XFILLER_13_494 VGND VGND VPWR VPWR sky130_fd_sc_hd__decap_8
X_2630_ net591 net512 net398 net665 net303 VGND VGND VPWR VPWR _0916_ sky130_fd_sc_hd__a221o_1
X_2561_ net629 _0868_ _0870_ net300 VGND VGND VPWR VPWR _0871_ sky130_fd_sc_hd__a211o_1
X_4300_ net604 net427 net331 net678 net221 VGND VGND VPWR VPWR _2149_ sky130_fd_sc_hd__a221o_1
X_2492_ net1238 net204 _0819_ VGND VGND VPWR VPWR _0536_ sky130_fd_sc_hd__o21a_1
X_4231_ net582 net433 net342 net658 VGND VGND VPWR VPWR _2103_ sky130_fd_sc_hd__a22o_1
XFILLER_67_122 VGND VGND VPWR VPWR sky130_fd_sc_hd__decap_3
X_4162_ net570 net433 net342 net640 net231 VGND VGND VPWR VPWR _2058_ sky130_fd_sc_hd__a221o_1
X_3113_ net586 net185 _1251_ net189 VGND VGND VPWR VPWR _1252_ sky130_fd_sc_hd__a211o_1
X_4093_ array\[6\]\[29\] net465 net448 array\[4\]\[29\] VGND VGND VPWR VPWR _2003_
+ sky130_fd_sc_hd__a22o_1
XFILLER_82_125 VGND VGND VPWR VPWR sky130_fd_sc_hd__fill_1
X_3044_ net666 net592 net496 VGND VGND VPWR VPWR _1202_ sky130_fd_sc_hd__mux2_1
XFILLER_70_309 VGND VGND VPWR VPWR sky130_fd_sc_hd__decap_6
XTAP_TAPCELL_ROW_66_868 VGND VPWR sky130_fd_sc_hd__tapvpwrvgnd_1
XFILLER_23_225 VGND VGND VPWR VPWR sky130_fd_sc_hd__decap_4
XFILLER_11_409 VPWR VGND VPWR VGND sky130_ef_sc_hd__decap_12
X_3946_ net824 net172 _1869_ VGND VGND VPWR VPWR _0360_ sky130_fd_sc_hd__o21a_1
XTAP_TAPCELL_ROW_21_415 VGND VPWR sky130_fd_sc_hd__tapvpwrvgnd_1
X_3877_ net357 _1801_ _1805_ net417 VGND VGND VPWR VPWR _1807_ sky130_fd_sc_hd__a22o_1
X_2828_ net731 net281 VGND VGND VPWR VPWR _1051_ sky130_fd_sc_hd__and2_1
X_2759_ _0591_ _1004_ VGND VGND VPWR VPWR _1005_ sky130_fd_sc_hd__and2_1
X_4429_ clknet_leaf_12_clk _0540_ VGND VGND VPWR VPWR array\[3\]\[18\] sky130_fd_sc_hd__dfxtp_1
Xfanout411 net414 VGND VGND VPWR VPWR net411 sky130_fd_sc_hd__clkbuf_4
Xfanout422 _1637_ VGND VGND VPWR VPWR net422 sky130_fd_sc_hd__clkbuf_4
Xfanout400 net401 VGND VGND VPWR VPWR net400 sky130_fd_sc_hd__clkbuf_2
Xfanout455 _1594_ VGND VGND VPWR VPWR net455 sky130_fd_sc_hd__clkbuf_4
Xfanout433 _1611_ VGND VGND VPWR VPWR net433 sky130_fd_sc_hd__clkbuf_4
Xfanout466 net467 VGND VGND VPWR VPWR net466 sky130_fd_sc_hd__clkbuf_4
Xfanout444 net446 VGND VGND VPWR VPWR net444 sky130_fd_sc_hd__clkbuf_4
Xfanout477 _1435_ VGND VGND VPWR VPWR net477 sky130_fd_sc_hd__clkbuf_4
Xfanout499 net500 VGND VGND VPWR VPWR net499 sky130_fd_sc_hd__buf_4
Xfanout488 _1296_ VGND VGND VPWR VPWR net488 sky130_fd_sc_hd__buf_2
XFILLER_46_317 VGND VGND VPWR VPWR sky130_fd_sc_hd__fill_1
XFILLER_27_553 VGND VGND VPWR VPWR sky130_fd_sc_hd__fill_1
XFILLER_39_391 VGND VGND VPWR VPWR sky130_fd_sc_hd__fill_1
XTAP_TAPCELL_ROW_37_570 VGND VPWR sky130_fd_sc_hd__tapvpwrvgnd_1
XFILLER_10_475 VGND VGND VPWR VPWR sky130_fd_sc_hd__fill_1
XFILLER_6_413 VGND VGND VPWR VPWR sky130_fd_sc_hd__decap_6
XFILLER_6_457 VPWR VGND VPWR VGND sky130_ef_sc_hd__decap_12
XFILLER_1_140 VPWR VGND VPWR VGND sky130_ef_sc_hd__decap_12
XTAP_TAPCELL_ROW_9_295 VGND VPWR sky130_fd_sc_hd__tapvpwrvgnd_1
XFILLER_38_80 VGND VGND VPWR VPWR sky130_fd_sc_hd__decap_4
XFILLER_18_542 VGND VGND VPWR VPWR sky130_fd_sc_hd__fill_2
XFILLER_92_489 VPWR VGND VPWR VGND sky130_ef_sc_hd__decap_12
XFILLER_52_309 VPWR VGND VPWR VGND sky130_ef_sc_hd__decap_12
XTAP_TAPCELL_ROW_63_838 VGND VPWR sky130_fd_sc_hd__tapvpwrvgnd_1
XFILLER_60_320 VGND VGND VPWR VPWR sky130_fd_sc_hd__fill_1
X_4780_ clknet_leaf_64_clk _0311_ VGND VGND VPWR VPWR ready_check\[1\] sky130_fd_sc_hd__dfxtp_1
X_3800_ array\[6\]\[3\] net461 net444 array\[4\]\[3\] VGND VGND VPWR VPWR _1736_ sky130_fd_sc_hd__a22o_1
X_3731_ net1047 net240 _1680_ _1681_ VGND VGND VPWR VPWR _0333_ sky130_fd_sc_hd__o22a_1
X_3662_ net563 ready_check\[15\] _1146_ _1147_ VGND VGND VPWR VPWR _1634_ sky130_fd_sc_hd__a31o_1
Xclkload10 clknet_leaf_61_clk VGND VGND VPWR VPWR clkload10/Y sky130_fd_sc_hd__inv_8
X_2613_ net605 net510 net396 net679 net301 VGND VGND VPWR VPWR _0905_ sky130_fd_sc_hd__a221o_1
Xclkload43 clknet_leaf_32_clk VGND VGND VPWR VPWR clkload43/X sky130_fd_sc_hd__clkbuf_8
Xclkload32 clknet_leaf_18_clk VGND VGND VPWR VPWR clkload32/X sky130_fd_sc_hd__clkbuf_4
X_3593_ tail\[2\] tail\[1\] tail\[0\] VGND VGND VPWR VPWR _1581_ sky130_fd_sc_hd__and3_1
Xclkload21 clknet_leaf_39_clk VGND VGND VPWR VPWR clkload21/Y sky130_fd_sc_hd__inv_6
Xclkload54 clknet_leaf_29_clk VGND VGND VPWR VPWR clkload54/Y sky130_fd_sc_hd__clkinv_4
X_2544_ net656 net1 net5 net113 VGND VGND VPWR VPWR _0854_ sky130_fd_sc_hd__and4b_2
X_2475_ net627 net758 net513 VGND VGND VPWR VPWR _0808_ sky130_fd_sc_hd__mux2_1
X_4214_ net596 net431 net340 net670 net229 VGND VGND VPWR VPWR _2092_ sky130_fd_sc_hd__a221o_1
X_4145_ _0781_ _0856_ _0932_ _0589_ _1610_ VGND VGND VPWR VPWR _2045_ sky130_fd_sc_hd__o221a_4
XFILLER_83_423 VGND VGND VPWR VPWR sky130_fd_sc_hd__fill_1
XTAP_TAPCELL_ROW_79_993 VGND VPWR sky130_fd_sc_hd__tapvpwrvgnd_1
X_4076_ array\[6\]\[27\] net469 net452 array\[4\]\[27\] VGND VGND VPWR VPWR _1988_
+ sky130_fd_sc_hd__a22o_1
X_3027_ net744 net195 _1190_ net381 VGND VGND VPWR VPWR _1191_ sky130_fd_sc_hd__a22o_1
XFILLER_55_169 VGND VGND VPWR VPWR sky130_fd_sc_hd__decap_8
XFILLER_70_139 VGND VGND VPWR VPWR sky130_fd_sc_hd__fill_1
XFILLER_24_523 VGND VGND VPWR VPWR sky130_fd_sc_hd__fill_2
XFILLER_34_49 VGND VGND VPWR VPWR sky130_fd_sc_hd__fill_1
XTAP_TAPCELL_ROW_34_540 VGND VPWR sky130_fd_sc_hd__tapvpwrvgnd_1
XFILLER_51_353 VGND VGND VPWR VPWR sky130_fd_sc_hd__decap_6
X_3929_ array\[9\]\[14\] net544 net528 array\[11\]\[14\] _1853_ VGND VGND VPWR VPWR
+ _1854_ sky130_fd_sc_hd__a221o_1
Xclkload4 clknet_3_4__leaf_clk VGND VGND VPWR VPWR clkload4/X sky130_fd_sc_hd__clkbuf_8
XFILLER_3_405 VPWR VGND VPWR VGND sky130_ef_sc_hd__decap_12
XFILLER_3_449 VPWR VGND VPWR VGND sky130_ef_sc_hd__decap_12
Xfanout241 _1639_ VGND VGND VPWR VPWR net241 sky130_fd_sc_hd__clkbuf_4
Xfanout230 _2047_ VGND VGND VPWR VPWR net230 sky130_fd_sc_hd__buf_2
XTAP_TAPCELL_ROW_6_265 VGND VPWR sky130_fd_sc_hd__tapvpwrvgnd_1
Xfanout263 _1439_ VGND VGND VPWR VPWR net263 sky130_fd_sc_hd__clkbuf_4
Xfanout252 net253 VGND VGND VPWR VPWR net252 sky130_fd_sc_hd__clkbuf_4
Xfanout274 _1069_ VGND VGND VPWR VPWR net274 sky130_fd_sc_hd__clkbuf_4
Xfanout296 _0936_ VGND VGND VPWR VPWR net296 sky130_fd_sc_hd__buf_2
XFILLER_75_23 VGND VGND VPWR VPWR sky130_fd_sc_hd__decap_3
Xfanout285 net288 VGND VGND VPWR VPWR net285 sky130_fd_sc_hd__clkbuf_4
XFILLER_15_512 VGND VGND VPWR VPWR sky130_fd_sc_hd__decap_8
XFILLER_34_309 VGND VGND VPWR VPWR sky130_fd_sc_hd__decap_3
XFILLER_91_55 VGND VGND VPWR VPWR sky130_fd_sc_hd__fill_1
XFILLER_15_556 VGND VGND VPWR VPWR sky130_fd_sc_hd__fill_1
XTAP_TAPCELL_ROW_60_808 VGND VPWR sky130_fd_sc_hd__tapvpwrvgnd_1
XFILLER_30_515 VGND VGND VPWR VPWR sky130_fd_sc_hd__fill_1
XFILLER_10_250 VGND VGND VPWR VPWR sky130_fd_sc_hd__fill_2
XFILLER_6_210 VGND VGND VPWR VPWR sky130_fd_sc_hd__fill_2
X_2260_ net1215 net324 _0658_ VGND VGND VPWR VPWR _0465_ sky130_fd_sc_hd__o21a_1
X_2191_ empty _0601_ VGND VGND VPWR VPWR _0602_ sky130_fd_sc_hd__nor2_1
XFILLER_37_103 VGND VGND VPWR VPWR sky130_fd_sc_hd__decap_8
XFILLER_65_445 VGND VGND VPWR VPWR sky130_fd_sc_hd__decap_3
XTAP_TAPCELL_ROW_76_963 VGND VPWR sky130_fd_sc_hd__tapvpwrvgnd_1
XTAP_TAPCELL_ROW_48_687 VGND VPWR sky130_fd_sc_hd__tapvpwrvgnd_1
X_4901_ clknet_leaf_17_clk _0432_ VGND VGND VPWR VPWR array\[6\]\[12\] sky130_fd_sc_hd__dfxtp_1
X_4832_ clknet_leaf_14_clk _0363_ VGND VGND VPWR VPWR net129 sky130_fd_sc_hd__dfxtp_1
XTAP_TAPCELL_ROW_31_510 VGND VPWR sky130_fd_sc_hd__tapvpwrvgnd_1
XFILLER_60_183 VGND VGND VPWR VPWR sky130_fd_sc_hd__decap_3
X_4763_ clknet_leaf_62_clk _0294_ VGND VGND VPWR VPWR tail\[0\] sky130_fd_sc_hd__dfxtp_2
X_4694_ clknet_leaf_28_clk _0225_ VGND VGND VPWR VPWR array\[12\]\[27\] sky130_fd_sc_hd__dfxtp_1
X_3714_ net616 net424 net345 net688 VGND VGND VPWR VPWR _1671_ sky130_fd_sc_hd__a22o_1
X_3645_ net564 ready_check\[6\] _1622_ _1621_ VGND VGND VPWR VPWR _1623_ sky130_fd_sc_hd__a31o_1
X_3576_ net721 net248 VGND VGND VPWR VPWR _1570_ sky130_fd_sc_hd__and2_1
X_2527_ net726 net306 _0842_ net404 net310 VGND VGND VPWR VPWR _0843_ sky130_fd_sc_hd__a221o_1
X_2458_ net711 net306 _0796_ net404 net310 VGND VGND VPWR VPWR _0797_ sky130_fd_sc_hd__a221o_1
XPHY_EDGE_ROW_89_Right_89 VGND VGND VPWR VPWR sky130_fd_sc_hd__decap_3
Xhold38 array\[12\]\[29\] VGND VGND VPWR VPWR net804 sky130_fd_sc_hd__dlygate4sd3_1
Xhold27 array\[5\]\[23\] VGND VGND VPWR VPWR net793 sky130_fd_sc_hd__dlygate4sd3_1
Xhold16 array\[5\]\[6\] VGND VGND VPWR VPWR net782 sky130_fd_sc_hd__dlygate4sd3_1
XTAP_TAPCELL_ROW_3_235 VGND VPWR sky130_fd_sc_hd__tapvpwrvgnd_1
Xhold49 array\[13\]\[2\] VGND VGND VPWR VPWR net815 sky130_fd_sc_hd__dlygate4sd3_1
X_2389_ net1153 net208 _0747_ VGND VGND VPWR VPWR _0505_ sky130_fd_sc_hd__o21a_1
XFILLER_68_294 VPWR VGND VPWR VGND sky130_ef_sc_hd__decap_12
X_4128_ tail\[0\] net934 net651 VGND VGND VPWR VPWR _0381_ sky130_fd_sc_hd__mux2_1
XFILLER_28_125 VGND VGND VPWR VPWR sky130_fd_sc_hd__fill_2
X_4059_ array\[2\]\[26\] net462 net445 array\[0\]\[26\] VGND VGND VPWR VPWR _1972_
+ sky130_fd_sc_hd__a22o_1
XFILLER_83_297 VGND VGND VPWR VPWR sky130_fd_sc_hd__decap_4
XFILLER_24_331 VGND VGND VPWR VPWR sky130_fd_sc_hd__fill_2
XPHY_EDGE_ROW_5_Left_100 VGND VGND VPWR VPWR sky130_fd_sc_hd__decap_3
XFILLER_79_559 VGND VGND VPWR VPWR sky130_fd_sc_hd__fill_1
XFILLER_3_279 VGND VGND VPWR VPWR sky130_fd_sc_hd__fill_1
XFILLER_86_77 VGND VGND VPWR VPWR sky130_fd_sc_hd__decap_6
XFILLER_47_401 VGND VGND VPWR VPWR sky130_fd_sc_hd__decap_4
XFILLER_47_467 VGND VGND VPWR VPWR sky130_fd_sc_hd__fill_2
XTAP_TAPCELL_ROW_73_933 VGND VPWR sky130_fd_sc_hd__tapvpwrvgnd_1
XTAP_TAPCELL_ROW_45_657 VGND VPWR sky130_fd_sc_hd__tapvpwrvgnd_1
XFILLER_7_541 VPWR VGND VPWR VGND sky130_ef_sc_hd__decap_12
Xhold508 array\[4\]\[22\] VGND VGND VPWR VPWR net1274 sky130_fd_sc_hd__dlygate4sd3_1
X_3430_ net1082 net260 _1470_ VGND VGND VPWR VPWR _0243_ sky130_fd_sc_hd__o21a_1
Xhold519 array\[6\]\[25\] VGND VGND VPWR VPWR net1285 sky130_fd_sc_hd__dlygate4sd3_1
X_3361_ net590 net483 net368 net664 net178 VGND VGND VPWR VPWR _1422_ sky130_fd_sc_hd__a221o_1
X_2312_ net663 net589 net521 VGND VGND VPWR VPWR _0693_ sky130_fd_sc_hd__mux2_1
X_3292_ net602 net481 net367 net676 net177 VGND VGND VPWR VPWR _1377_ sky130_fd_sc_hd__a221o_1
XFILLER_85_529 VPWR VGND VPWR VGND sky130_ef_sc_hd__decap_12
X_2243_ net647 net577 net521 VGND VGND VPWR VPWR _0647_ sky130_fd_sc_hd__mux2_1
X_2174_ net559 VGND VGND VPWR VPWR _0585_ sky130_fd_sc_hd__inv_2
XPHY_EDGE_ROW_69_Left_164 VGND VGND VPWR VPWR sky130_fd_sc_hd__decap_3
XTAP_TAPCELL_ROW_0_205 VGND VPWR sky130_fd_sc_hd__tapvpwrvgnd_1
XFILLER_38_489 VGND VGND VPWR VPWR sky130_fd_sc_hd__decap_3
X_4815_ clknet_leaf_43_clk _0346_ VGND VGND VPWR VPWR net131 sky130_fd_sc_hd__dfxtp_1
XPHY_EDGE_ROW_78_Left_173 VGND VGND VPWR VPWR sky130_fd_sc_hd__decap_3
X_4746_ clknet_leaf_38_clk _0277_ VGND VGND VPWR VPWR array\[10\]\[15\] sky130_fd_sc_hd__dfxtp_1
X_4677_ clknet_leaf_46_clk _0208_ VGND VGND VPWR VPWR array\[12\]\[10\] sky130_fd_sc_hd__dfxtp_1
X_3628_ _1366_ _1597_ VGND VGND VPWR VPWR _1608_ sky130_fd_sc_hd__nand2b_1
X_3559_ net733 net245 _1558_ net254 VGND VGND VPWR VPWR _1559_ sky130_fd_sc_hd__a211o_1
Xinput106 write_location0[3] VGND VGND VPWR VPWR net106 sky130_fd_sc_hd__buf_1
XPHY_EDGE_ROW_87_Left_182 VGND VGND VPWR VPWR sky130_fd_sc_hd__decap_3
XFILLER_29_445 VGND VGND VPWR VPWR sky130_fd_sc_hd__decap_3
XFILLER_44_448 VGND VGND VPWR VPWR sky130_fd_sc_hd__fill_1
XTAP_TAPCELL_ROW_70_903 VGND VPWR sky130_fd_sc_hd__tapvpwrvgnd_1
XTAP_TAPCELL_ROW_42_627 VGND VPWR sky130_fd_sc_hd__tapvpwrvgnd_1
XFILLER_52_492 VGND VGND VPWR VPWR sky130_fd_sc_hd__fill_2
XFILLER_12_389 VGND VGND VPWR VPWR sky130_fd_sc_hd__fill_1
XANTENNA_90 net350 VGND VGND VPWR VPWR sky130_fd_sc_hd__diode_2
XFILLER_4_533 VPWR VGND VPWR VGND sky130_ef_sc_hd__decap_12
XFILLER_21_50 VGND VGND VPWR VPWR sky130_fd_sc_hd__decap_6
XFILLER_75_551 VGND VGND VPWR VPWR sky130_fd_sc_hd__decap_8
XFILLER_35_437 VGND VGND VPWR VPWR sky130_fd_sc_hd__decap_4
XTAP_TAPCELL_ROW_58_782 VGND VPWR sky130_fd_sc_hd__tapvpwrvgnd_1
X_2930_ net1157 net200 _1120_ VGND VGND VPWR VPWR _0093_ sky130_fd_sc_hd__o21a_1
X_4600_ clknet_leaf_51_clk _0131_ VGND VGND VPWR VPWR array\[15\]\[29\] sky130_fd_sc_hd__dfxtp_1
X_2861_ net855 _1074_ net199 VGND VGND VPWR VPWR _0070_ sky130_fd_sc_hd__mux2_1
X_2792_ net1257 net284 _1027_ _1028_ VGND VGND VPWR VPWR _0047_ sky130_fd_sc_hd__o22a_1
X_4531_ clknet_leaf_37_clk _0062_ VGND VGND VPWR VPWR array\[8\]\[24\] sky130_fd_sc_hd__dfxtp_1
Xhold305 array\[4\]\[11\] VGND VGND VPWR VPWR net1071 sky130_fd_sc_hd__dlygate4sd3_1
Xhold316 array\[11\]\[13\] VGND VGND VPWR VPWR net1082 sky130_fd_sc_hd__dlygate4sd3_1
X_4462_ clknet_leaf_56_clk _0573_ VGND VGND VPWR VPWR array\[4\]\[19\] sky130_fd_sc_hd__dfxtp_1
Xhold338 array\[15\]\[27\] VGND VGND VPWR VPWR net1104 sky130_fd_sc_hd__dlygate4sd3_1
Xhold349 array\[9\]\[26\] VGND VGND VPWR VPWR net1115 sky130_fd_sc_hd__dlygate4sd3_1
X_3413_ net701 net258 VGND VGND VPWR VPWR _1459_ sky130_fd_sc_hd__and2_1
Xhold327 array\[15\]\[14\] VGND VGND VPWR VPWR net1093 sky130_fd_sc_hd__dlygate4sd3_1
X_4393_ clknet_leaf_1_clk _0504_ VGND VGND VPWR VPWR array\[2\]\[14\] sky130_fd_sc_hd__dfxtp_1
X_3344_ net1003 net154 _1409_ _1410_ VGND VGND VPWR VPWR _0217_ sky130_fd_sc_hd__o22a_1
X_3275_ net576 net488 net184 net716 _1362_ VGND VGND VPWR VPWR _1363_ sky130_fd_sc_hd__a221o_1
XFILLER_85_315 VGND VGND VPWR VPWR sky130_fd_sc_hd__decap_8
X_2226_ net653 net109 net4 net766 VGND VGND VPWR VPWR _0632_ sky130_fd_sc_hd__or4bb_1
XFILLER_38_253 VGND VGND VPWR VPWR sky130_fd_sc_hd__fill_1
XFILLER_26_448 VGND VGND VPWR VPWR sky130_fd_sc_hd__fill_1
XFILLER_53_267 VGND VGND VPWR VPWR sky130_fd_sc_hd__decap_6
XFILLER_21_131 VGND VGND VPWR VPWR sky130_fd_sc_hd__fill_1
X_4729_ clknet_leaf_20_clk _0260_ VGND VGND VPWR VPWR array\[11\]\[30\] sky130_fd_sc_hd__dfxtp_1
XFILLER_1_503 VGND VGND VPWR VPWR sky130_fd_sc_hd__fill_1
XFILLER_88_197 VPWR VGND VPWR VGND sky130_ef_sc_hd__decap_12
XFILLER_44_234 VGND VGND VPWR VPWR sky130_fd_sc_hd__fill_2
XTAP_TAPCELL_ROW_55_752 VGND VPWR sky130_fd_sc_hd__tapvpwrvgnd_1
XTAP_TAPCELL_ROW_27_476 VGND VPWR sky130_fd_sc_hd__tapvpwrvgnd_1
XFILLER_12_131 VGND VGND VPWR VPWR sky130_fd_sc_hd__decap_8
X_3060_ net719 net194 _1212_ net380 VGND VGND VPWR VPWR _1213_ sky130_fd_sc_hd__a22o_1
XFILLER_50_204 VGND VGND VPWR VPWR sky130_fd_sc_hd__fill_2
X_3962_ array\[2\]\[17\] net469 net452 array\[0\]\[17\] VGND VGND VPWR VPWR _1884_
+ sky130_fd_sc_hd__a22o_1
XFILLER_50_226 VGND VGND VPWR VPWR sky130_fd_sc_hd__decap_8
X_2913_ net605 net679 net500 VGND VGND VPWR VPWR _1109_ sky130_fd_sc_hd__mux2_1
X_3893_ array\[6\]\[11\] net462 net445 array\[4\]\[11\] VGND VGND VPWR VPWR _1821_
+ sky130_fd_sc_hd__a22o_1
X_2844_ net719 net279 VGND VGND VPWR VPWR _1061_ sky130_fd_sc_hd__and2_1
X_4514_ clknet_leaf_60_clk _0045_ VGND VGND VPWR VPWR array\[8\]\[7\] sky130_fd_sc_hd__dfxtp_1
X_2775_ net572 net504 net276 net642 net286 VGND VGND VPWR VPWR _1018_ sky130_fd_sc_hd__a221o_1
Xhold124 array\[5\]\[16\] VGND VGND VPWR VPWR net890 sky130_fd_sc_hd__dlygate4sd3_1
Xhold135 array\[5\]\[8\] VGND VGND VPWR VPWR net901 sky130_fd_sc_hd__dlygate4sd3_1
Xhold102 array\[5\]\[25\] VGND VGND VPWR VPWR net868 sky130_fd_sc_hd__dlygate4sd3_1
Xhold113 array\[5\]\[20\] VGND VGND VPWR VPWR net879 sky130_fd_sc_hd__dlygate4sd3_1
XTAP_TAPCELL_ROW_92_1128 VGND VPWR sky130_fd_sc_hd__tapvpwrvgnd_1
Xhold157 array\[12\]\[30\] VGND VGND VPWR VPWR net923 sky130_fd_sc_hd__dlygate4sd3_1
Xhold146 array\[1\]\[27\] VGND VGND VPWR VPWR net912 sky130_fd_sc_hd__dlygate4sd3_1
Xhold168 net115 VGND VGND VPWR VPWR net934 sky130_fd_sc_hd__dlygate4sd3_1
X_4445_ clknet_leaf_39_clk _0556_ VGND VGND VPWR VPWR array\[4\]\[2\] sky130_fd_sc_hd__dfxtp_1
Xfanout604 net81 VGND VGND VPWR VPWR net604 sky130_fd_sc_hd__dlymetal6s2s_1
X_4376_ clknet_leaf_54_clk _0487_ VGND VGND VPWR VPWR array\[1\]\[29\] sky130_fd_sc_hd__dfxtp_1
Xfanout615 net76 VGND VGND VPWR VPWR net615 sky130_fd_sc_hd__buf_2
Xhold179 array\[9\]\[24\] VGND VGND VPWR VPWR net945 sky130_fd_sc_hd__dlygate4sd3_1
Xfanout637 net66 VGND VGND VPWR VPWR net637 sky130_fd_sc_hd__buf_2
X_3327_ net617 net482 net180 net1318 VGND VGND VPWR VPWR _1400_ sky130_fd_sc_hd__a22o_1
Xfanout626 net71 VGND VGND VPWR VPWR net626 sky130_fd_sc_hd__dlymetal6s2s_1
Xfanout648 net61 VGND VGND VPWR VPWR net648 sky130_fd_sc_hd__clkbuf_2
Xfanout659 net58 VGND VGND VPWR VPWR net659 sky130_fd_sc_hd__buf_2
XFILLER_85_156 VPWR VGND VPWR VGND sky130_ef_sc_hd__decap_12
X_3258_ net827 _1351_ net160 VGND VGND VPWR VPWR _0190_ sky130_fd_sc_hd__mux2_1
XTAP_TAPCELL_ROW_69_899 VGND VPWR sky130_fd_sc_hd__tapvpwrvgnd_1
X_2209_ head\[3\] net217 _0616_ net562 VGND VGND VPWR VPWR _0456_ sky130_fd_sc_hd__o211a_1
X_3189_ net861 _1305_ net157 VGND VGND VPWR VPWR _0167_ sky130_fd_sc_hd__mux2_1
XFILLER_66_392 VGND VGND VPWR VPWR sky130_fd_sc_hd__fill_1
XFILLER_53_15 VPWR VGND VPWR VGND sky130_ef_sc_hd__decap_12
XTAP_TAPCELL_ROW_52_722 VGND VPWR sky130_fd_sc_hd__tapvpwrvgnd_1
XTAP_TAPCELL_ROW_24_446 VGND VPWR sky130_fd_sc_hd__tapvpwrvgnd_1
XFILLER_5_149 VGND VGND VPWR VPWR sky130_fd_sc_hd__decap_3
XFILLER_76_112 VGND VGND VPWR VPWR sky130_fd_sc_hd__decap_4
XFILLER_64_307 VGND VGND VPWR VPWR sky130_fd_sc_hd__fill_1
XFILLER_64_329 VGND VGND VPWR VPWR sky130_fd_sc_hd__decap_4
XFILLER_17_212 VGND VGND VPWR VPWR sky130_fd_sc_hd__fill_1
XFILLER_91_159 VGND VGND VPWR VPWR sky130_fd_sc_hd__decap_8
XFILLER_72_373 VGND VGND VPWR VPWR sky130_fd_sc_hd__fill_2
XFILLER_64_6 VPWR VGND VPWR VGND sky130_ef_sc_hd__decap_12
X_2560_ net625 net509 net395 net697 VGND VGND VPWR VPWR _0870_ sky130_fd_sc_hd__a22o_1
X_2491_ net751 net305 _0818_ net403 net309 VGND VGND VPWR VPWR _0819_ sky130_fd_sc_hd__a221o_1
X_4230_ net859 net227 _2101_ _2102_ VGND VGND VPWR VPWR _0415_ sky130_fd_sc_hd__o22a_1
X_4161_ net710 net235 VGND VGND VPWR VPWR _2057_ sky130_fd_sc_hd__and2_1
X_3112_ net622 net490 net375 net694 VGND VGND VPWR VPWR _1251_ sky130_fd_sc_hd__a22o_1
X_4092_ net769 net171 _2002_ VGND VGND VPWR VPWR _0373_ sky130_fd_sc_hd__o21a_1
X_3043_ net1026 _1201_ net168 VGND VGND VPWR VPWR _0125_ sky130_fd_sc_hd__mux2_1
XTAP_TAPCELL_ROW_89_1090 VGND VPWR sky130_fd_sc_hd__tapvpwrvgnd_1
XTAP_TAPCELL_ROW_66_869 VGND VPWR sky130_fd_sc_hd__tapvpwrvgnd_1
XFILLER_90_181 VGND VGND VPWR VPWR sky130_fd_sc_hd__fill_2
X_3945_ net216 _1867_ _1868_ VGND VGND VPWR VPWR _1869_ sky130_fd_sc_hd__or3_1
XTAP_TAPCELL_ROW_21_416 VGND VPWR sky130_fd_sc_hd__tapvpwrvgnd_1
X_3876_ net435 _1799_ _1803_ net351 VGND VGND VPWR VPWR _1806_ sky130_fd_sc_hd__a22o_1
XFILLER_31_281 VGND VGND VPWR VPWR sky130_fd_sc_hd__decap_6
X_2827_ net1102 net284 _1049_ _1050_ VGND VGND VPWR VPWR _0060_ sky130_fd_sc_hd__o22a_1
X_2758_ net653 net1 net106 net3 VGND VGND VPWR VPWR _1004_ sky130_fd_sc_hd__and4b_1
X_4428_ clknet_leaf_24_clk _0539_ VGND VGND VPWR VPWR array\[3\]\[17\] sky130_fd_sc_hd__dfxtp_1
X_2689_ net696 net624 net393 VGND VGND VPWR VPWR _0957_ sky130_fd_sc_hd__mux2_1
Xfanout401 _0862_ VGND VGND VPWR VPWR net401 sky130_fd_sc_hd__buf_4
Xfanout423 _1635_ VGND VGND VPWR VPWR net423 sky130_fd_sc_hd__clkbuf_4
XFILLER_48_15 VPWR VGND VPWR VGND sky130_ef_sc_hd__decap_12
Xfanout412 net414 VGND VGND VPWR VPWR net412 sky130_fd_sc_hd__clkbuf_4
X_4359_ clknet_leaf_16_clk _0470_ VGND VGND VPWR VPWR array\[1\]\[12\] sky130_fd_sc_hd__dfxtp_1
Xfanout434 _1611_ VGND VGND VPWR VPWR net434 sky130_fd_sc_hd__clkbuf_2
Xfanout445 net446 VGND VGND VPWR VPWR net445 sky130_fd_sc_hd__buf_2
Xfanout456 net458 VGND VGND VPWR VPWR net456 sky130_fd_sc_hd__clkbuf_4
Xfanout467 net472 VGND VGND VPWR VPWR net467 sky130_fd_sc_hd__clkbuf_4
Xfanout489 _1221_ VGND VGND VPWR VPWR net489 sky130_fd_sc_hd__buf_4
XFILLER_46_307 VGND VGND VPWR VPWR sky130_fd_sc_hd__fill_1
Xfanout478 _1435_ VGND VGND VPWR VPWR net478 sky130_fd_sc_hd__buf_2
XFILLER_39_370 VGND VGND VPWR VPWR sky130_fd_sc_hd__fill_1
XPHY_EDGE_ROW_14_Left_109 VGND VGND VPWR VPWR sky130_fd_sc_hd__decap_3
XFILLER_81_181 VGND VGND VPWR VPWR sky130_fd_sc_hd__fill_1
XFILLER_14_226 VGND VGND VPWR VPWR sky130_fd_sc_hd__fill_1
XTAP_TAPCELL_ROW_37_571 VGND VPWR sky130_fd_sc_hd__tapvpwrvgnd_1
XFILLER_13_51 VGND VGND VPWR VPWR sky130_fd_sc_hd__decap_4
XFILLER_10_421 VPWR VGND VPWR VGND sky130_ef_sc_hd__decap_12
XFILLER_13_62 VGND VGND VPWR VPWR sky130_fd_sc_hd__decap_8
XFILLER_6_469 VGND VGND VPWR VPWR sky130_fd_sc_hd__decap_6
XPHY_EDGE_ROW_23_Left_118 VGND VGND VPWR VPWR sky130_fd_sc_hd__decap_3
XFILLER_89_55 VGND VGND VPWR VPWR sky130_fd_sc_hd__fill_1
XFILLER_1_152 VPWR VGND VPWR VGND sky130_ef_sc_hd__decap_12
XTAP_TAPCELL_ROW_9_296 VGND VPWR sky130_fd_sc_hd__tapvpwrvgnd_1
XFILLER_64_137 VGND VGND VPWR VPWR sky130_fd_sc_hd__decap_3
XPHY_EDGE_ROW_32_Left_127 VGND VGND VPWR VPWR sky130_fd_sc_hd__decap_3
XFILLER_33_513 VGND VGND VPWR VPWR sky130_fd_sc_hd__decap_4
XTAP_TAPCELL_ROW_63_839 VGND VPWR sky130_fd_sc_hd__tapvpwrvgnd_1
XFILLER_20_229 VGND VGND VPWR VPWR sky130_fd_sc_hd__fill_1
X_3730_ net600 net424 net345 net674 net242 VGND VGND VPWR VPWR _1681_ sky130_fd_sc_hd__a221o_1
XFILLER_9_241 VPWR VGND VPWR VGND sky130_ef_sc_hd__decap_12
XFILLER_9_263 VGND VGND VPWR VPWR sky130_fd_sc_hd__decap_6
X_3661_ net211 _0607_ _1607_ _1633_ VGND VGND VPWR VPWR _0311_ sky130_fd_sc_hd__o31a_1
XPHY_EDGE_ROW_41_Left_136 VGND VGND VPWR VPWR sky130_fd_sc_hd__decap_3
X_2612_ net743 net400 net507 VGND VGND VPWR VPWR _0904_ sky130_fd_sc_hd__and3_1
XFILLER_9_296 VGND VGND VPWR VPWR sky130_fd_sc_hd__fill_1
X_3592_ tail\[1\] _1578_ _1580_ net562 VGND VGND VPWR VPWR _0295_ sky130_fd_sc_hd__o211a_1
Xclkload11 clknet_leaf_62_clk VGND VGND VPWR VPWR clkload11/X sky130_fd_sc_hd__clkbuf_8
Xclkload22 clknet_leaf_41_clk VGND VGND VPWR VPWR clkload22/X sky130_fd_sc_hd__clkbuf_8
Xclkload33 clknet_leaf_19_clk VGND VGND VPWR VPWR clkload33/X sky130_fd_sc_hd__clkbuf_4
Xclkload44 clknet_leaf_33_clk VGND VGND VPWR VPWR clkload44/X sky130_fd_sc_hd__clkbuf_4
Xclkload55 clknet_leaf_30_clk VGND VGND VPWR VPWR clkload55/Y sky130_fd_sc_hd__inv_8
X_2543_ net975 net203 _0853_ VGND VGND VPWR VPWR _0553_ sky130_fd_sc_hd__o21a_1
XFILLER_87_207 VGND VGND VPWR VPWR sky130_fd_sc_hd__fill_1
X_2474_ net1216 net205 _0807_ VGND VGND VPWR VPWR _0530_ sky130_fd_sc_hd__o21a_1
X_4213_ net734 net233 VGND VGND VPWR VPWR _2091_ sky130_fd_sc_hd__and2_1
X_4144_ _2035_ _2044_ VGND VGND VPWR VPWR _0387_ sky130_fd_sc_hd__and2_1
XTAP_TAPCELL_ROW_79_994 VGND VPWR sky130_fd_sc_hd__tapvpwrvgnd_1
XFILLER_28_307 VGND VGND VPWR VPWR sky130_fd_sc_hd__fill_1
XPHY_EDGE_ROW_50_Left_145 VGND VGND VPWR VPWR sky130_fd_sc_hd__decap_3
X_4075_ array\[13\]\[27\] net557 net541 array\[15\]\[27\] _1986_ VGND VGND VPWR VPWR
+ _1987_ sky130_fd_sc_hd__a221o_1
X_3026_ net680 net606 net495 VGND VGND VPWR VPWR _1190_ sky130_fd_sc_hd__mux2_1
XFILLER_63_181 VGND VGND VPWR VPWR sky130_fd_sc_hd__fill_2
XTAP_TAPCELL_ROW_34_541 VGND VPWR sky130_fd_sc_hd__tapvpwrvgnd_1
XFILLER_11_229 VGND VGND VPWR VPWR sky130_fd_sc_hd__fill_1
Xclkload5 clknet_3_5__leaf_clk VGND VGND VPWR VPWR clkload5/Y sky130_fd_sc_hd__clkinvlp_4
X_3928_ array\[10\]\[14\] net461 net444 array\[8\]\[14\] VGND VGND VPWR VPWR _1853_
+ sky130_fd_sc_hd__a22o_1
X_3859_ array\[9\]\[8\] net556 net538 array\[11\]\[8\] _1789_ VGND VGND VPWR VPWR
+ _1790_ sky130_fd_sc_hd__a221o_1
XFILLER_3_417 VPWR VGND VPWR VGND sky130_ef_sc_hd__decap_12
Xfanout231 _2047_ VGND VGND VPWR VPWR net231 sky130_fd_sc_hd__clkbuf_4
Xfanout220 _2112_ VGND VGND VPWR VPWR net220 sky130_fd_sc_hd__buf_4
XTAP_TAPCELL_ROW_6_266 VGND VPWR sky130_fd_sc_hd__tapvpwrvgnd_1
Xfanout253 _1511_ VGND VGND VPWR VPWR net253 sky130_fd_sc_hd__buf_4
Xfanout264 _1439_ VGND VGND VPWR VPWR net264 sky130_fd_sc_hd__clkbuf_2
Xfanout242 _1639_ VGND VGND VPWR VPWR net242 sky130_fd_sc_hd__clkbuf_2
XFILLER_59_432 VGND VGND VPWR VPWR sky130_fd_sc_hd__decap_3
XFILLER_59_465 VGND VGND VPWR VPWR sky130_fd_sc_hd__fill_1
XFILLER_74_413 VGND VGND VPWR VPWR sky130_fd_sc_hd__decap_6
Xfanout275 net278 VGND VGND VPWR VPWR net275 sky130_fd_sc_hd__clkbuf_4
Xfanout297 net299 VGND VGND VPWR VPWR net297 sky130_fd_sc_hd__buf_4
Xfanout286 net287 VGND VGND VPWR VPWR net286 sky130_fd_sc_hd__clkbuf_4
XFILLER_59_498 VGND VGND VPWR VPWR sky130_fd_sc_hd__fill_2
XFILLER_54_170 VGND VGND VPWR VPWR sky130_fd_sc_hd__fill_2
XTAP_TAPCELL_ROW_60_809 VGND VPWR sky130_fd_sc_hd__tapvpwrvgnd_1
XFILLER_42_365 VGND VGND VPWR VPWR sky130_fd_sc_hd__decap_6
XFILLER_42_387 VPWR VGND VPWR VGND sky130_ef_sc_hd__decap_12
XFILLER_24_83 VGND VGND VPWR VPWR sky130_fd_sc_hd__fill_1
X_2190_ _0003_ _0598_ _0600_ _0595_ _0596_ VGND VGND VPWR VPWR _0601_ sky130_fd_sc_hd__o32a_1
XFILLER_27_6 VPWR VGND VPWR VGND sky130_ef_sc_hd__decap_12
XTAP_TAPCELL_ROW_76_964 VGND VPWR sky130_fd_sc_hd__tapvpwrvgnd_1
XTAP_TAPCELL_ROW_86_1060 VGND VPWR sky130_fd_sc_hd__tapvpwrvgnd_1
X_4900_ clknet_leaf_17_clk _0431_ VGND VGND VPWR VPWR array\[6\]\[11\] sky130_fd_sc_hd__dfxtp_1
XFILLER_65_90 VGND VGND VPWR VPWR sky130_fd_sc_hd__decap_3
XFILLER_18_373 VGND VGND VPWR VPWR sky130_fd_sc_hd__decap_8
XTAP_TAPCELL_ROW_48_688 VGND VPWR sky130_fd_sc_hd__tapvpwrvgnd_1
X_4831_ clknet_leaf_25_clk _0362_ VGND VGND VPWR VPWR net128 sky130_fd_sc_hd__dfxtp_1
XFILLER_21_516 VGND VGND VPWR VPWR sky130_fd_sc_hd__fill_1
XANTENNA_180 net330 VGND VGND VPWR VPWR sky130_fd_sc_hd__diode_2
X_4762_ clknet_leaf_49_clk _0293_ VGND VGND VPWR VPWR array\[10\]\[31\] sky130_fd_sc_hd__dfxtp_1
XTAP_TAPCELL_ROW_31_511 VGND VPWR sky130_fd_sc_hd__tapvpwrvgnd_1
X_4693_ clknet_leaf_15_clk _0224_ VGND VGND VPWR VPWR array\[12\]\[26\] sky130_fd_sc_hd__dfxtp_1
X_3713_ net850 net240 _1670_ VGND VGND VPWR VPWR _0326_ sky130_fd_sc_hd__o21a_1
X_3644_ _1218_ _1613_ VGND VGND VPWR VPWR _1622_ sky130_fd_sc_hd__nand2_1
X_3575_ net1160 net251 _1568_ _1569_ VGND VGND VPWR VPWR _0289_ sky130_fd_sc_hd__o22a_1
X_2526_ net662 net588 net515 VGND VGND VPWR VPWR _0842_ sky130_fd_sc_hd__mux2_1
X_2457_ net641 net571 net515 VGND VGND VPWR VPWR _0796_ sky130_fd_sc_hd__mux2_1
Xhold17 array\[5\]\[14\] VGND VGND VPWR VPWR net783 sky130_fd_sc_hd__dlygate4sd3_1
Xhold28 net136 VGND VGND VPWR VPWR net794 sky130_fd_sc_hd__dlygate4sd3_1
Xhold39 array\[12\]\[16\] VGND VGND VPWR VPWR net805 sky130_fd_sc_hd__dlygate4sd3_1
X_2388_ net749 net316 _0746_ net408 net313 VGND VGND VPWR VPWR _0747_ sky130_fd_sc_hd__a221o_1
XFILLER_56_413 VGND VGND VPWR VPWR sky130_fd_sc_hd__decap_6
XTAP_TAPCELL_ROW_3_236 VGND VPWR sky130_fd_sc_hd__tapvpwrvgnd_1
X_4127_ net790 net171 _2034_ VGND VGND VPWR VPWR _0376_ sky130_fd_sc_hd__o21a_1
X_4058_ net936 net171 _1970_ _1971_ VGND VGND VPWR VPWR _0370_ sky130_fd_sc_hd__o22a_1
XFILLER_56_468 VGND VGND VPWR VPWR sky130_fd_sc_hd__decap_8
X_3009_ net765 net195 _1178_ net381 VGND VGND VPWR VPWR _1179_ sky130_fd_sc_hd__a22o_1
XFILLER_71_449 VPWR VGND VPWR VGND sky130_ef_sc_hd__decap_12
Xclkbuf_leaf_63_clk clknet_3_0__leaf_clk VGND VGND VPWR VPWR clknet_leaf_63_clk sky130_fd_sc_hd__clkbuf_8
XTAP_TAPCELL_ROW_19_390 VGND VPWR sky130_fd_sc_hd__tapvpwrvgnd_1
XFILLER_24_398 VGND VGND VPWR VPWR sky130_fd_sc_hd__decap_3
XFILLER_61_37 VGND VGND VPWR VPWR sky130_fd_sc_hd__decap_6
XFILLER_3_225 VPWR VGND VPWR VGND sky130_ef_sc_hd__decap_12
XFILLER_79_505 VPWR VGND VPWR VGND sky130_ef_sc_hd__decap_12
XFILLER_19_159 VGND VGND VPWR VPWR sky130_fd_sc_hd__fill_2
XTAP_TAPCELL_ROW_73_934 VGND VPWR sky130_fd_sc_hd__tapvpwrvgnd_1
XFILLER_62_438 VGND VGND VPWR VPWR sky130_fd_sc_hd__fill_1
Xclkbuf_leaf_54_clk clknet_3_3__leaf_clk VGND VGND VPWR VPWR clknet_leaf_54_clk sky130_fd_sc_hd__clkbuf_8
XTAP_TAPCELL_ROW_45_658 VGND VPWR sky130_fd_sc_hd__tapvpwrvgnd_1
XFILLER_70_493 VGND VGND VPWR VPWR sky130_fd_sc_hd__fill_1
XFILLER_7_553 VGND VGND VPWR VPWR sky130_fd_sc_hd__decap_6
Xhold509 array\[10\]\[25\] VGND VGND VPWR VPWR net1275 sky130_fd_sc_hd__dlygate4sd3_1
X_3360_ net728 net174 VGND VGND VPWR VPWR _1421_ sky130_fd_sc_hd__and2_1
X_2311_ net1094 net325 _0692_ VGND VGND VPWR VPWR _0482_ sky130_fd_sc_hd__o21a_1
X_3291_ net740 net173 VGND VGND VPWR VPWR _1376_ sky130_fd_sc_hd__and2_1
X_2242_ net919 net324 _0646_ VGND VGND VPWR VPWR _0459_ sky130_fd_sc_hd__o21a_1
XFILLER_93_541 VPWR VGND VPWR VGND sky130_ef_sc_hd__decap_12
X_2173_ head\[3\] VGND VGND VPWR VPWR _0584_ sky130_fd_sc_hd__inv_2
XFILLER_65_254 VGND VGND VPWR VPWR sky130_fd_sc_hd__decap_3
XTAP_TAPCELL_ROW_0_206 VGND VPWR sky130_fd_sc_hd__tapvpwrvgnd_1
XFILLER_80_213 VGND VGND VPWR VPWR sky130_fd_sc_hd__decap_3
Xclkbuf_leaf_45_clk clknet_3_3__leaf_clk VGND VGND VPWR VPWR clknet_leaf_45_clk sky130_fd_sc_hd__clkbuf_8
XFILLER_21_302 VGND VGND VPWR VPWR sky130_fd_sc_hd__decap_3
XFILLER_61_460 VGND VGND VPWR VPWR sky130_fd_sc_hd__decap_8
XTAP_TAPCELL_ROW_16_360 VGND VPWR sky130_fd_sc_hd__tapvpwrvgnd_1
X_4814_ clknet_leaf_59_clk _0345_ VGND VGND VPWR VPWR net120 sky130_fd_sc_hd__dfxtp_1
XFILLER_21_335 VGND VGND VPWR VPWR sky130_fd_sc_hd__fill_1
X_4745_ clknet_leaf_4_clk _0276_ VGND VGND VPWR VPWR array\[10\]\[14\] sky130_fd_sc_hd__dfxtp_1
XFILLER_31_18 VPWR VGND VPWR VGND sky130_ef_sc_hd__decap_12
X_4676_ clknet_leaf_50_clk _0207_ VGND VGND VPWR VPWR array\[12\]\[9\] sky130_fd_sc_hd__dfxtp_1
X_3627_ net211 _1595_ _1607_ _1605_ _1071_ VGND VGND VPWR VPWR _0303_ sky130_fd_sc_hd__o32a_1
X_3558_ net595 net473 net359 net669 VGND VGND VPWR VPWR _1558_ sky130_fd_sc_hd__a22o_1
XFILLER_88_302 VGND VGND VPWR VPWR sky130_fd_sc_hd__decap_6
X_2509_ net737 net306 _0830_ net404 net310 VGND VGND VPWR VPWR _0831_ sky130_fd_sc_hd__a221o_1
X_3489_ net652 _1510_ VGND VGND VPWR VPWR _1511_ sky130_fd_sc_hd__nor2_2
Xinput107 write_location1[0] VGND VGND VPWR VPWR net107 sky130_fd_sc_hd__buf_1
XFILLER_56_15 VPWR VGND VPWR VGND sky130_ef_sc_hd__decap_12
XTAP_TAPCELL_ROW_70_904 VGND VPWR sky130_fd_sc_hd__tapvpwrvgnd_1
Xclkbuf_leaf_36_clk clknet_3_6__leaf_clk VGND VGND VPWR VPWR clknet_leaf_36_clk sky130_fd_sc_hd__clkbuf_8
XTAP_TAPCELL_ROW_42_628 VGND VPWR sky130_fd_sc_hd__tapvpwrvgnd_1
XFILLER_52_471 VGND VGND VPWR VPWR sky130_fd_sc_hd__decap_4
XFILLER_12_335 VGND VGND VPWR VPWR sky130_fd_sc_hd__fill_1
XFILLER_4_501 VPWR VGND VPWR VGND sky130_ef_sc_hd__decap_12
XFILLER_20_390 VGND VGND VPWR VPWR sky130_fd_sc_hd__fill_1
XANTENNA_80 net257 VGND VGND VPWR VPWR sky130_fd_sc_hd__diode_2
XANTENNA_91 net350 VGND VGND VPWR VPWR sky130_fd_sc_hd__diode_2
XFILLER_4_545 VPWR VGND VPWR VGND sky130_ef_sc_hd__decap_12
XFILLER_79_357 VGND VGND VPWR VPWR sky130_fd_sc_hd__decap_3
XFILLER_47_221 VGND VGND VPWR VPWR sky130_fd_sc_hd__decap_3
XFILLER_90_533 VPWR VGND VPWR VGND sky130_ef_sc_hd__decap_12
XTAP_TAPCELL_ROW_58_783 VGND VPWR sky130_fd_sc_hd__tapvpwrvgnd_1
Xclkbuf_leaf_27_clk clknet_3_7__leaf_clk VGND VGND VPWR VPWR clknet_leaf_27_clk sky130_fd_sc_hd__clkbuf_8
XFILLER_62_235 VGND VGND VPWR VPWR sky130_fd_sc_hd__fill_1
XTAP_TAPCELL_ROW_83_1030 VGND VPWR sky130_fd_sc_hd__tapvpwrvgnd_1
XFILLER_15_151 VGND VGND VPWR VPWR sky130_fd_sc_hd__decap_3
X_2860_ net630 net271 _1070_ net383 VGND VGND VPWR VPWR _1074_ sky130_fd_sc_hd__a22o_1
XFILLER_30_121 VGND VGND VPWR VPWR sky130_fd_sc_hd__fill_1
XTAP_TAPCELL_ROW_13_330 VGND VPWR sky130_fd_sc_hd__tapvpwrvgnd_1
X_2791_ net758 net505 net275 net627 net285 VGND VGND VPWR VPWR _1028_ sky130_fd_sc_hd__a221o_1
X_4530_ clknet_leaf_38_clk _0061_ VGND VGND VPWR VPWR array\[8\]\[23\] sky130_fd_sc_hd__dfxtp_1
X_4461_ clknet_leaf_13_clk _0572_ VGND VGND VPWR VPWR array\[4\]\[18\] sky130_fd_sc_hd__dfxtp_1
XFILLER_7_383 VGND VGND VPWR VPWR sky130_fd_sc_hd__fill_1
Xhold317 array\[7\]\[31\] VGND VGND VPWR VPWR net1083 sky130_fd_sc_hd__dlygate4sd3_1
Xhold306 array\[1\]\[14\] VGND VGND VPWR VPWR net1072 sky130_fd_sc_hd__dlygate4sd3_1
Xhold339 array\[8\]\[26\] VGND VGND VPWR VPWR net1105 sky130_fd_sc_hd__dlygate4sd3_1
X_3412_ net1162 net259 _1458_ VGND VGND VPWR VPWR _0237_ sky130_fd_sc_hd__o21a_1
Xhold328 array\[1\]\[24\] VGND VGND VPWR VPWR net1094 sky130_fd_sc_hd__dlygate4sd3_1
X_4392_ clknet_leaf_11_clk _0503_ VGND VGND VPWR VPWR array\[2\]\[13\] sky130_fd_sc_hd__dfxtp_1
X_3343_ net603 net483 net368 net677 net178 VGND VGND VPWR VPWR _1410_ sky130_fd_sc_hd__a221o_1
X_3274_ net646 net374 VGND VGND VPWR VPWR _1362_ sky130_fd_sc_hd__and2_1
X_2225_ _0586_ _0627_ _0629_ VGND VGND VPWR VPWR _0631_ sky130_fd_sc_hd__and3_2
XFILLER_26_18 VGND VGND VPWR VPWR sky130_fd_sc_hd__decap_8
XFILLER_26_29 VGND VGND VPWR VPWR sky130_fd_sc_hd__decap_8
XFILLER_26_416 VGND VGND VPWR VPWR sky130_fd_sc_hd__decap_4
XFILLER_53_202 VGND VGND VPWR VPWR sky130_fd_sc_hd__decap_4
XFILLER_53_213 VGND VGND VPWR VPWR sky130_fd_sc_hd__fill_1
XFILLER_93_393 VPWR VGND VPWR VGND sky130_ef_sc_hd__decap_12
Xclkbuf_leaf_18_clk clknet_3_4__leaf_clk VGND VGND VPWR VPWR clknet_leaf_18_clk sky130_fd_sc_hd__clkbuf_8
XPHY_EDGE_ROW_5_Right_5 VGND VGND VPWR VPWR sky130_fd_sc_hd__decap_3
X_2989_ net845 _1165_ net167 VGND VGND VPWR VPWR _0107_ sky130_fd_sc_hd__mux2_1
X_4728_ clknet_leaf_52_clk _0259_ VGND VGND VPWR VPWR array\[11\]\[29\] sky130_fd_sc_hd__dfxtp_1
X_4659_ clknet_leaf_33_clk _0190_ VGND VGND VPWR VPWR array\[13\]\[24\] sky130_fd_sc_hd__dfxtp_1
XFILLER_88_121 VPWR VGND VPWR VGND sky130_ef_sc_hd__decap_12
XFILLER_1_559 VGND VGND VPWR VPWR sky130_fd_sc_hd__fill_1
XFILLER_88_165 VGND VGND VPWR VPWR sky130_fd_sc_hd__fill_2
XFILLER_76_305 VGND VGND VPWR VPWR sky130_fd_sc_hd__decap_3
XFILLER_29_221 VGND VGND VPWR VPWR sky130_fd_sc_hd__decap_3
XFILLER_83_57 VPWR VGND VPWR VGND sky130_ef_sc_hd__decap_12
XFILLER_72_533 VGND VGND VPWR VPWR sky130_fd_sc_hd__decap_3
XTAP_TAPCELL_ROW_55_753 VGND VPWR sky130_fd_sc_hd__tapvpwrvgnd_1
XTAP_TAPCELL_ROW_27_477 VGND VPWR sky130_fd_sc_hd__tapvpwrvgnd_1
XFILLER_16_95 VGND VGND VPWR VPWR sky130_fd_sc_hd__decap_8
XTAP_TAPCELL_ROW_10_300 VGND VPWR sky130_fd_sc_hd__tapvpwrvgnd_1
XFILLER_40_474 VGND VGND VPWR VPWR sky130_fd_sc_hd__fill_2
XFILLER_32_61 VGND VGND VPWR VPWR sky130_fd_sc_hd__fill_1
XFILLER_4_342 VGND VGND VPWR VPWR sky130_fd_sc_hd__fill_1
XFILLER_79_110 VGND VGND VPWR VPWR sky130_fd_sc_hd__fill_2
XFILLER_94_113 VPWR VGND VPWR VGND sky130_ef_sc_hd__decap_12
X_3961_ array\[9\]\[17\] net554 net538 array\[11\]\[17\] _1882_ VGND VGND VPWR VPWR
+ _1883_ sky130_fd_sc_hd__a221o_1
X_2912_ net1283 net201 _1108_ VGND VGND VPWR VPWR _0087_ sky130_fd_sc_hd__o21a_1
XFILLER_73_90 VGND VGND VPWR VPWR sky130_fd_sc_hd__decap_6
XFILLER_92_3 VPWR VGND VPWR VGND sky130_ef_sc_hd__decap_12
X_3892_ array\[1\]\[11\] net547 net537 array\[3\]\[11\] _1819_ VGND VGND VPWR VPWR
+ _1820_ sky130_fd_sc_hd__a221o_1
X_2843_ net829 net284 _1059_ _1060_ VGND VGND VPWR VPWR _0066_ sky130_fd_sc_hd__o22a_1
XFILLER_31_485 VPWR VGND VPWR VGND sky130_ef_sc_hd__decap_12
X_2774_ net712 net280 VGND VGND VPWR VPWR _1017_ sky130_fd_sc_hd__and2_1
X_4513_ clknet_leaf_4_clk _0044_ VGND VGND VPWR VPWR array\[8\]\[6\] sky130_fd_sc_hd__dfxtp_1
Xhold103 array\[2\]\[27\] VGND VGND VPWR VPWR net869 sky130_fd_sc_hd__dlygate4sd3_1
Xhold114 array\[13\]\[8\] VGND VGND VPWR VPWR net880 sky130_fd_sc_hd__dlygate4sd3_1
Xhold125 array\[11\]\[16\] VGND VGND VPWR VPWR net891 sky130_fd_sc_hd__dlygate4sd3_1
XTAP_TAPCELL_ROW_92_1129 VGND VPWR sky130_fd_sc_hd__tapvpwrvgnd_1
Xhold136 array\[1\]\[17\] VGND VGND VPWR VPWR net902 sky130_fd_sc_hd__dlygate4sd3_1
Xhold158 array\[3\]\[9\] VGND VGND VPWR VPWR net924 sky130_fd_sc_hd__dlygate4sd3_1
X_4444_ clknet_leaf_3_clk _0555_ VGND VGND VPWR VPWR array\[4\]\[1\] sky130_fd_sc_hd__dfxtp_1
Xclkbuf_leaf_7_clk clknet_3_4__leaf_clk VGND VGND VPWR VPWR clknet_leaf_7_clk sky130_fd_sc_hd__clkbuf_8
Xhold147 net132 VGND VGND VPWR VPWR net913 sky130_fd_sc_hd__dlygate4sd3_1
Xhold169 array\[15\]\[12\] VGND VGND VPWR VPWR net935 sky130_fd_sc_hd__dlygate4sd3_1
Xfanout605 net80 VGND VGND VPWR VPWR net605 sky130_fd_sc_hd__buf_2
X_4375_ clknet_leaf_54_clk _0486_ VGND VGND VPWR VPWR array\[1\]\[28\] sky130_fd_sc_hd__dfxtp_1
Xfanout638 net66 VGND VGND VPWR VPWR net638 sky130_fd_sc_hd__dlymetal6s2s_1
X_3326_ net754 net176 net370 net689 VGND VGND VPWR VPWR _1399_ sky130_fd_sc_hd__a22o_1
Xfanout627 net70 VGND VGND VPWR VPWR net627 sky130_fd_sc_hd__buf_2
Xfanout649 net60 VGND VGND VPWR VPWR net649 sky130_fd_sc_hd__buf_2
Xfanout616 net76 VGND VGND VPWR VPWR net616 sky130_fd_sc_hd__clkbuf_2
XFILLER_85_113 VGND VGND VPWR VPWR sky130_fd_sc_hd__decap_8
XFILLER_58_327 VGND VGND VPWR VPWR sky130_fd_sc_hd__decap_4
XFILLER_58_338 VGND VGND VPWR VPWR sky130_fd_sc_hd__decap_3
X_3257_ net592 net488 net184 net730 _1350_ VGND VGND VPWR VPWR _1351_ sky130_fd_sc_hd__a221o_1
X_2208_ net217 _0615_ VGND VGND VPWR VPWR _0616_ sky130_fd_sc_hd__nand2_1
X_3188_ net602 net485 net181 net740 _1304_ VGND VGND VPWR VPWR _1305_ sky130_fd_sc_hd__a221o_1
XFILLER_26_257 VGND VGND VPWR VPWR sky130_fd_sc_hd__fill_1
XFILLER_53_27 VGND VGND VPWR VPWR sky130_fd_sc_hd__fill_1
XFILLER_81_385 VGND VGND VPWR VPWR sky130_fd_sc_hd__decap_6
XTAP_TAPCELL_ROW_52_723 VGND VPWR sky130_fd_sc_hd__tapvpwrvgnd_1
XTAP_TAPCELL_ROW_24_447 VGND VPWR sky130_fd_sc_hd__tapvpwrvgnd_1
XFILLER_22_485 VGND VGND VPWR VPWR sky130_fd_sc_hd__decap_3
XFILLER_1_334 VGND VGND VPWR VPWR sky130_fd_sc_hd__fill_2
XFILLER_1_345 VPWR VGND VPWR VGND sky130_ef_sc_hd__decap_12
XFILLER_91_105 VGND VGND VPWR VPWR sky130_fd_sc_hd__decap_6
XFILLER_27_94 VPWR VGND VPWR VGND sky130_ef_sc_hd__decap_12
XTAP_TAPCELL_ROW_80_1000 VGND VPWR sky130_fd_sc_hd__tapvpwrvgnd_1
X_2490_ net687 net615 net514 VGND VGND VPWR VPWR _0818_ sky130_fd_sc_hd__mux2_1
XFILLER_4_54 VGND VGND VPWR VPWR sky130_fd_sc_hd__decap_3
X_4160_ net909 net225 _2056_ VGND VGND VPWR VPWR _0391_ sky130_fd_sc_hd__o21a_1
X_3111_ net877 net162 _1249_ _1250_ VGND VGND VPWR VPWR _0144_ sky130_fd_sc_hd__o22a_1
X_4091_ net215 _2000_ _2001_ VGND VGND VPWR VPWR _2002_ sky130_fd_sc_hd__or3_1
XFILLER_36_500 VGND VGND VPWR VPWR sky130_fd_sc_hd__decap_6
X_3042_ net732 net196 _1200_ net382 VGND VGND VPWR VPWR _1201_ sky130_fd_sc_hd__a22o_1
XTAP_TAPCELL_ROW_89_1091 VGND VPWR sky130_fd_sc_hd__tapvpwrvgnd_1
XFILLER_63_330 VGND VGND VPWR VPWR sky130_fd_sc_hd__decap_6
XFILLER_23_19 VGND VGND VPWR VPWR sky130_fd_sc_hd__fill_1
X_3944_ net418 _1862_ _1866_ net358 VGND VGND VPWR VPWR _1868_ sky130_fd_sc_hd__a22o_1
X_3875_ array\[13\]\[9\] net550 net529 array\[15\]\[9\] _1804_ VGND VGND VPWR VPWR
+ _1805_ sky130_fd_sc_hd__a221o_1
XTAP_TAPCELL_ROW_21_417 VGND VPWR sky130_fd_sc_hd__tapvpwrvgnd_1
X_2826_ net595 net502 net275 net669 net285 VGND VGND VPWR VPWR _1050_ sky130_fd_sc_hd__a221o_1
X_2757_ _0861_ net501 VGND VGND VPWR VPWR _1003_ sky130_fd_sc_hd__nand2_1
X_2688_ net822 _0956_ net295 VGND VGND VPWR VPWR _0015_ sky130_fd_sc_hd__mux2_1
X_4427_ clknet_leaf_26_clk _0538_ VGND VGND VPWR VPWR array\[3\]\[16\] sky130_fd_sc_hd__dfxtp_1
Xfanout402 net403 VGND VGND VPWR VPWR net402 sky130_fd_sc_hd__clkbuf_4
Xfanout413 net414 VGND VGND VPWR VPWR net413 sky130_fd_sc_hd__clkbuf_2
X_4358_ clknet_leaf_14_clk _0469_ VGND VGND VPWR VPWR array\[1\]\[11\] sky130_fd_sc_hd__dfxtp_1
Xfanout435 _1606_ VGND VGND VPWR VPWR net435 sky130_fd_sc_hd__buf_4
Xfanout446 _1594_ VGND VGND VPWR VPWR net446 sky130_fd_sc_hd__buf_2
Xfanout457 net458 VGND VGND VPWR VPWR net457 sky130_fd_sc_hd__buf_2
XFILLER_48_27 VGND VGND VPWR VPWR sky130_fd_sc_hd__fill_1
Xfanout424 _1635_ VGND VGND VPWR VPWR net424 sky130_fd_sc_hd__buf_2
XFILLER_58_102 VGND VGND VPWR VPWR sky130_fd_sc_hd__decap_3
X_3309_ net762 net481 net367 net633 net177 VGND VGND VPWR VPWR _1388_ sky130_fd_sc_hd__a221o_1
Xfanout479 _1435_ VGND VGND VPWR VPWR net479 sky130_fd_sc_hd__clkbuf_4
Xfanout468 net472 VGND VGND VPWR VPWR net468 sky130_fd_sc_hd__clkbuf_4
X_4289_ net614 net430 net334 net686 VGND VGND VPWR VPWR _2142_ sky130_fd_sc_hd__a22o_1
XTAP_TAPCELL_ROW_37_572 VGND VPWR sky130_fd_sc_hd__tapvpwrvgnd_1
XFILLER_80_69 VGND VGND VPWR VPWR sky130_fd_sc_hd__fill_1
XFILLER_10_433 VPWR VGND VPWR VGND sky130_ef_sc_hd__decap_12
XFILLER_10_477 VPWR VGND VPWR VGND sky130_ef_sc_hd__decap_12
XFILLER_89_271 VGND VGND VPWR VPWR sky130_fd_sc_hd__decap_8
XTAP_TAPCELL_ROW_9_297 VGND VPWR sky130_fd_sc_hd__tapvpwrvgnd_1
XFILLER_1_164 VGND VGND VPWR VPWR sky130_fd_sc_hd__decap_4
XFILLER_92_414 VGND VGND VPWR VPWR sky130_fd_sc_hd__decap_6
XFILLER_9_220 VGND VGND VPWR VPWR sky130_fd_sc_hd__decap_4
XFILLER_9_253 VGND VGND VPWR VPWR sky130_fd_sc_hd__decap_4
X_3660_ _0637_ _0638_ _1632_ net563 net411 VGND VGND VPWR VPWR _1633_ sky130_fd_sc_hd__a221o_1
X_2611_ net1233 net297 _0902_ _0903_ VGND VGND VPWR VPWR _0571_ sky130_fd_sc_hd__o22a_1
Xclkload34 clknet_leaf_10_clk VGND VGND VPWR VPWR clkload34/Y sky130_fd_sc_hd__inv_6
Xclkload12 clknet_leaf_63_clk VGND VGND VPWR VPWR clkload12/Y sky130_fd_sc_hd__inv_6
X_3591_ _0619_ _1578_ VGND VGND VPWR VPWR _1580_ sky130_fd_sc_hd__nand2_1
Xclkload23 clknet_leaf_42_clk VGND VGND VPWR VPWR clkload23/Y sky130_fd_sc_hd__inv_8
Xclkload56 clknet_leaf_31_clk VGND VGND VPWR VPWR clkload56/X sky130_fd_sc_hd__clkbuf_8
X_2542_ net713 net304 _0852_ net402 net308 VGND VGND VPWR VPWR _0853_ sky130_fd_sc_hd__a221o_1
Xclkload45 clknet_leaf_34_clk VGND VGND VPWR VPWR clkload45/Y sky130_fd_sc_hd__clkinvlp_4
X_2473_ net701 net306 _0806_ net405 net310 VGND VGND VPWR VPWR _0807_ sky130_fd_sc_hd__a221o_1
X_4212_ net1309 net225 _2090_ VGND VGND VPWR VPWR _0409_ sky130_fd_sc_hd__o21a_1
X_4143_ net766 _2040_ _2043_ full VGND VGND VPWR VPWR _2044_ sky130_fd_sc_hd__a211o_1
X_4074_ array\[14\]\[27\] net471 net454 array\[12\]\[27\] VGND VGND VPWR VPWR _1986_
+ sky130_fd_sc_hd__a22o_1
XTAP_TAPCELL_ROW_79_995 VGND VPWR sky130_fd_sc_hd__tapvpwrvgnd_1
XFILLER_68_477 VGND VGND VPWR VPWR sky130_fd_sc_hd__fill_2
X_3025_ net871 _1189_ net167 VGND VGND VPWR VPWR _0119_ sky130_fd_sc_hd__mux2_1
XFILLER_34_29 VPWR VGND VPWR VGND sky130_ef_sc_hd__decap_12
XTAP_TAPCELL_ROW_34_542 VGND VPWR sky130_fd_sc_hd__tapvpwrvgnd_1
X_3927_ array\[13\]\[14\] net545 net527 array\[15\]\[14\] _1851_ VGND VGND VPWR VPWR
+ _1852_ sky130_fd_sc_hd__a221o_1
Xclkload6 clknet_3_6__leaf_clk VGND VGND VPWR VPWR clkload6/X sky130_fd_sc_hd__clkbuf_8
X_3858_ array\[10\]\[8\] net470 net453 array\[8\]\[8\] VGND VGND VPWR VPWR _1789_
+ sky130_fd_sc_hd__a22o_1
X_3789_ array\[1\]\[2\] net554 net538 array\[3\]\[2\] _1725_ VGND VGND VPWR VPWR _1726_
+ sky130_fd_sc_hd__a221o_1
X_2809_ net882 _1008_ _1038_ _1039_ VGND VGND VPWR VPWR _0053_ sky130_fd_sc_hd__o22a_1
XFILLER_3_429 VPWR VGND VPWR VGND sky130_ef_sc_hd__decap_12
Xfanout232 _2047_ VGND VGND VPWR VPWR net232 sky130_fd_sc_hd__clkbuf_2
Xfanout221 _2111_ VGND VGND VPWR VPWR net221 sky130_fd_sc_hd__clkbuf_4
Xfanout210 _0716_ VGND VGND VPWR VPWR net210 sky130_fd_sc_hd__buf_2
Xfanout254 _1511_ VGND VGND VPWR VPWR net254 sky130_fd_sc_hd__clkbuf_4
XTAP_TAPCELL_ROW_6_267 VGND VPWR sky130_fd_sc_hd__tapvpwrvgnd_1
Xfanout243 _1639_ VGND VGND VPWR VPWR net243 sky130_fd_sc_hd__buf_4
Xfanout265 _1439_ VGND VGND VPWR VPWR net265 sky130_fd_sc_hd__clkbuf_4
Xfanout276 net277 VGND VGND VPWR VPWR net276 sky130_fd_sc_hd__clkbuf_4
Xfanout287 net288 VGND VGND VPWR VPWR net287 sky130_fd_sc_hd__buf_4
Xfanout298 net299 VGND VGND VPWR VPWR net298 sky130_fd_sc_hd__clkbuf_4
XFILLER_75_47 VGND VGND VPWR VPWR sky130_fd_sc_hd__fill_1
XFILLER_15_503 VGND VGND VPWR VPWR sky130_fd_sc_hd__fill_1
XFILLER_91_57 VPWR VGND VPWR VGND sky130_ef_sc_hd__decap_12
XFILLER_42_399 VGND VGND VPWR VPWR sky130_fd_sc_hd__fill_2
XFILLER_69_208 VGND VGND VPWR VPWR sky130_fd_sc_hd__fill_1
XFILLER_41_9 VGND VGND VPWR VPWR sky130_fd_sc_hd__decap_3
XFILLER_77_252 VGND VGND VPWR VPWR sky130_fd_sc_hd__fill_1
XFILLER_92_222 VGND VGND VPWR VPWR sky130_fd_sc_hd__fill_2
XTAP_TAPCELL_ROW_76_965 VGND VPWR sky130_fd_sc_hd__tapvpwrvgnd_1
XFILLER_1_66 VGND VGND VPWR VPWR sky130_fd_sc_hd__decap_4
XFILLER_92_288 VGND VGND VPWR VPWR sky130_fd_sc_hd__fill_1
XTAP_TAPCELL_ROW_86_1061 VGND VPWR sky130_fd_sc_hd__tapvpwrvgnd_1
XFILLER_18_363 VGND VGND VPWR VPWR sky130_fd_sc_hd__fill_1
XTAP_TAPCELL_ROW_48_689 VGND VPWR sky130_fd_sc_hd__tapvpwrvgnd_1
X_4830_ clknet_leaf_26_clk _0361_ VGND VGND VPWR VPWR net127 sky130_fd_sc_hd__dfxtp_1
XFILLER_33_333 VGND VGND VPWR VPWR sky130_fd_sc_hd__decap_3
XANTENNA_170 _2114_ VGND VGND VPWR VPWR sky130_fd_sc_hd__diode_2
XFILLER_60_130 VGND VGND VPWR VPWR sky130_fd_sc_hd__decap_4
XANTENNA_181 net376 VGND VGND VPWR VPWR sky130_fd_sc_hd__diode_2
XFILLER_60_141 VGND VGND VPWR VPWR sky130_fd_sc_hd__fill_1
XTAP_TAPCELL_ROW_31_512 VGND VPWR sky130_fd_sc_hd__tapvpwrvgnd_1
X_4761_ clknet_leaf_19_clk _0292_ VGND VGND VPWR VPWR array\[10\]\[30\] sky130_fd_sc_hd__dfxtp_1
X_3712_ net755 _1641_ _1669_ net242 VGND VGND VPWR VPWR _1670_ sky130_fd_sc_hd__a211o_1
X_4692_ clknet_leaf_45_clk _0223_ VGND VGND VPWR VPWR array\[12\]\[25\] sky130_fd_sc_hd__dfxtp_1
X_3643_ _1618_ net427 _1620_ VGND VGND VPWR VPWR _1621_ sky130_fd_sc_hd__or3_1
X_3574_ net583 net474 net361 net659 _1511_ VGND VGND VPWR VPWR _1569_ sky130_fd_sc_hd__a221o_1
X_2525_ net958 net204 _0841_ VGND VGND VPWR VPWR _0547_ sky130_fd_sc_hd__o21a_1
X_2456_ net1109 net203 _0795_ VGND VGND VPWR VPWR _0524_ sky130_fd_sc_hd__o21a_1
Xhold29 array\[13\]\[26\] VGND VGND VPWR VPWR net795 sky130_fd_sc_hd__dlygate4sd3_1
XFILLER_68_230 VPWR VGND VPWR VGND sky130_ef_sc_hd__decap_12
Xhold18 array\[13\]\[9\] VGND VGND VPWR VPWR net784 sky130_fd_sc_hd__dlygate4sd3_1
X_4126_ net215 _2032_ _2033_ VGND VGND VPWR VPWR _2034_ sky130_fd_sc_hd__or3_1
X_2387_ net613 net685 net518 VGND VGND VPWR VPWR _0746_ sky130_fd_sc_hd__mux2_1
XTAP_TAPCELL_ROW_3_237 VGND VPWR sky130_fd_sc_hd__tapvpwrvgnd_1
XFILLER_56_447 VGND VGND VPWR VPWR sky130_fd_sc_hd__fill_2
X_4057_ net357 _1965_ _1969_ net436 net215 VGND VGND VPWR VPWR _1971_ sky130_fd_sc_hd__a221o_1
X_3008_ net692 net620 net495 VGND VGND VPWR VPWR _1178_ sky130_fd_sc_hd__mux2_1
XTAP_TAPCELL_ROW_19_391 VGND VPWR sky130_fd_sc_hd__tapvpwrvgnd_1
XFILLER_3_237 VPWR VGND VPWR VGND sky130_ef_sc_hd__decap_12
XFILLER_79_517 VPWR VGND VPWR VGND sky130_ef_sc_hd__decap_12
XFILLER_10_75 VGND VGND VPWR VPWR sky130_fd_sc_hd__fill_1
XFILLER_87_561 VGND VGND VPWR VPWR sky130_fd_sc_hd__fill_1
XFILLER_19_95 VGND VGND VPWR VPWR sky130_fd_sc_hd__fill_1
XFILLER_62_406 VGND VGND VPWR VPWR sky130_fd_sc_hd__decap_3
XFILLER_74_277 VGND VGND VPWR VPWR sky130_fd_sc_hd__decap_8
XTAP_TAPCELL_ROW_73_935 VGND VPWR sky130_fd_sc_hd__tapvpwrvgnd_1
XFILLER_27_160 VGND VGND VPWR VPWR sky130_fd_sc_hd__fill_2
XFILLER_34_119 VGND VGND VPWR VPWR sky130_fd_sc_hd__fill_1
XFILLER_15_333 VGND VGND VPWR VPWR sky130_fd_sc_hd__decap_3
XTAP_TAPCELL_ROW_45_659 VGND VPWR sky130_fd_sc_hd__tapvpwrvgnd_1
XFILLER_30_325 VGND VGND VPWR VPWR sky130_fd_sc_hd__fill_2
XFILLER_11_561 VGND VGND VPWR VPWR sky130_fd_sc_hd__fill_1
X_3290_ net1281 net153 _1375_ VGND VGND VPWR VPWR _0198_ sky130_fd_sc_hd__o21a_1
X_2310_ net729 net322 _0691_ net413 net330 VGND VGND VPWR VPWR _0692_ sky130_fd_sc_hd__a221o_1
X_2241_ net739 net320 _0645_ net414 net328 VGND VGND VPWR VPWR _0646_ sky130_fd_sc_hd__a221o_1
XFILLER_78_561 VGND VGND VPWR VPWR sky130_fd_sc_hd__fill_1
XFILLER_18_3 VPWR VGND VPWR VGND sky130_ef_sc_hd__decap_12
XFILLER_38_425 VGND VGND VPWR VPWR sky130_fd_sc_hd__fill_1
XFILLER_93_553 VGND VGND VPWR VPWR sky130_fd_sc_hd__decap_6
XTAP_TAPCELL_ROW_0_207 VGND VPWR sky130_fd_sc_hd__tapvpwrvgnd_1
XFILLER_38_458 VGND VGND VPWR VPWR sky130_fd_sc_hd__decap_8
XTAP_TAPCELL_ROW_16_361 VGND VPWR sky130_fd_sc_hd__tapvpwrvgnd_1
X_4813_ clknet_leaf_49_clk _0344_ VGND VGND VPWR VPWR array\[9\]\[31\] sky130_fd_sc_hd__dfxtp_1
X_4744_ clknet_leaf_5_clk _0275_ VGND VGND VPWR VPWR array\[10\]\[13\] sky130_fd_sc_hd__dfxtp_1
X_4675_ clknet_leaf_31_clk _0206_ VGND VGND VPWR VPWR array\[12\]\[8\] sky130_fd_sc_hd__dfxtp_1
X_3626_ head\[3\] net559 VGND VGND VPWR VPWR _1607_ sky130_fd_sc_hd__or2_1
X_3557_ net1306 net250 _1557_ VGND VGND VPWR VPWR _0283_ sky130_fd_sc_hd__o21a_1
X_2508_ net673 net599 net515 VGND VGND VPWR VPWR _0830_ sky130_fd_sc_hd__mux2_1
X_3488_ net501 _1222_ net473 _1509_ VGND VGND VPWR VPWR _1510_ sky130_fd_sc_hd__a211o_1
Xinput108 write_location1[1] VGND VGND VPWR VPWR net108 sky130_fd_sc_hd__buf_1
XFILLER_69_561 VGND VGND VPWR VPWR sky130_fd_sc_hd__fill_1
X_2439_ net112 net111 VGND VGND VPWR VPWR _0781_ sky130_fd_sc_hd__nand2_1
XFILLER_56_27 VGND VGND VPWR VPWR sky130_fd_sc_hd__fill_1
X_4109_ array\[14\]\[30\] net469 net452 array\[12\]\[30\] VGND VGND VPWR VPWR _2018_
+ sky130_fd_sc_hd__a22o_1
XFILLER_44_417 VGND VGND VPWR VPWR sky130_fd_sc_hd__decap_3
XTAP_TAPCELL_ROW_70_905 VGND VPWR sky130_fd_sc_hd__tapvpwrvgnd_1
XFILLER_24_141 VGND VGND VPWR VPWR sky130_fd_sc_hd__fill_1
XFILLER_52_461 VGND VGND VPWR VPWR sky130_fd_sc_hd__fill_1
XTAP_TAPCELL_ROW_42_629 VGND VPWR sky130_fd_sc_hd__tapvpwrvgnd_1
XANTENNA_81 net279 VGND VGND VPWR VPWR sky130_fd_sc_hd__diode_2
XANTENNA_92 net351 VGND VGND VPWR VPWR sky130_fd_sc_hd__diode_2
XANTENNA_70 net180 VGND VGND VPWR VPWR sky130_fd_sc_hd__diode_2
XFILLER_4_513 VPWR VGND VPWR VGND sky130_ef_sc_hd__decap_12
XFILLER_4_557 VGND VGND VPWR VPWR sky130_fd_sc_hd__decap_4
XFILLER_94_317 VGND VGND VPWR VPWR sky130_fd_sc_hd__fill_1
XFILLER_87_391 VGND VGND VPWR VPWR sky130_fd_sc_hd__fill_1
XFILLER_90_501 VPWR VGND VPWR VGND sky130_ef_sc_hd__decap_12
XFILLER_35_428 VGND VGND VPWR VPWR sky130_fd_sc_hd__decap_3
XFILLER_47_288 VGND VGND VPWR VPWR sky130_fd_sc_hd__decap_8
XTAP_TAPCELL_ROW_58_784 VGND VPWR sky130_fd_sc_hd__tapvpwrvgnd_1
XFILLER_90_545 VPWR VGND VPWR VGND sky130_ef_sc_hd__decap_12
XFILLER_46_71 VGND VGND VPWR VPWR sky130_fd_sc_hd__decap_4
XTAP_TAPCELL_ROW_83_1031 VGND VPWR sky130_fd_sc_hd__tapvpwrvgnd_1
XFILLER_62_269 VPWR VGND VPWR VGND sky130_ef_sc_hd__decap_12
XTAP_TAPCELL_ROW_13_331 VGND VPWR sky130_fd_sc_hd__tapvpwrvgnd_1
X_2790_ net699 net279 VGND VGND VPWR VPWR _1027_ sky130_fd_sc_hd__and2_1
XFILLER_7_351 VGND VGND VPWR VPWR sky130_fd_sc_hd__decap_3
X_4460_ clknet_leaf_23_clk _0571_ VGND VGND VPWR VPWR array\[4\]\[17\] sky130_fd_sc_hd__dfxtp_1
XFILLER_7_87 VGND VGND VPWR VPWR sky130_fd_sc_hd__decap_6
Xhold307 array\[1\]\[25\] VGND VGND VPWR VPWR net1073 sky130_fd_sc_hd__dlygate4sd3_1
X_4391_ clknet_leaf_16_clk _0502_ VGND VGND VPWR VPWR array\[2\]\[12\] sky130_fd_sc_hd__dfxtp_1
Xhold318 array\[7\]\[8\] VGND VGND VPWR VPWR net1084 sky130_fd_sc_hd__dlygate4sd3_1
X_3411_ net704 net255 _1457_ net263 VGND VGND VPWR VPWR _1458_ sky130_fd_sc_hd__a211o_1
Xhold329 array\[0\]\[24\] VGND VGND VPWR VPWR net1095 sky130_fd_sc_hd__dlygate4sd3_1
X_3342_ net741 net174 VGND VGND VPWR VPWR _1409_ sky130_fd_sc_hd__and2_1
X_3273_ net911 _1361_ net158 VGND VGND VPWR VPWR _0195_ sky130_fd_sc_hd__mux2_1
XFILLER_66_520 VGND VGND VPWR VPWR sky130_fd_sc_hd__fill_2
X_2224_ net112 net111 VGND VGND VPWR VPWR _0630_ sky130_fd_sc_hd__nand2b_1
XFILLER_19_491 VGND VGND VPWR VPWR sky130_fd_sc_hd__fill_1
XFILLER_41_409 VPWR VGND VPWR VGND sky130_ef_sc_hd__decap_12
XFILLER_42_29 VGND VGND VPWR VPWR sky130_fd_sc_hd__fill_1
XFILLER_61_291 VGND VGND VPWR VPWR sky130_fd_sc_hd__decap_4
X_2988_ net708 net195 _1164_ net382 VGND VGND VPWR VPWR _1165_ sky130_fd_sc_hd__a22o_1
X_4727_ clknet_leaf_52_clk _0258_ VGND VGND VPWR VPWR array\[11\]\[28\] sky130_fd_sc_hd__dfxtp_1
X_4658_ clknet_leaf_33_clk _0189_ VGND VGND VPWR VPWR array\[13\]\[23\] sky130_fd_sc_hd__dfxtp_1
Xinput90 value2[27] VGND VGND VPWR VPWR net90 sky130_fd_sc_hd__buf_1
X_3609_ _1367_ _1592_ VGND VGND VPWR VPWR _1593_ sky130_fd_sc_hd__nor2_1
X_4589_ clknet_leaf_12_clk _0120_ VGND VGND VPWR VPWR array\[15\]\[18\] sky130_fd_sc_hd__dfxtp_1
XFILLER_1_505 VPWR VGND VPWR VGND sky130_ef_sc_hd__decap_12
XFILLER_88_133 VGND VGND VPWR VPWR sky130_fd_sc_hd__decap_6
XFILLER_67_15 VPWR VGND VPWR VGND sky130_ef_sc_hd__decap_12
XFILLER_83_69 VPWR VGND VPWR VGND sky130_ef_sc_hd__decap_12
XFILLER_17_439 VGND VGND VPWR VPWR sky130_fd_sc_hd__decap_4
XFILLER_44_269 VGND VGND VPWR VPWR sky130_fd_sc_hd__fill_2
XTAP_TAPCELL_ROW_55_754 VGND VPWR sky130_fd_sc_hd__tapvpwrvgnd_1
XFILLER_16_85 VGND VGND VPWR VPWR sky130_fd_sc_hd__fill_2
XPHY_EDGE_ROW_11_Right_11 VGND VGND VPWR VPWR sky130_fd_sc_hd__decap_3
XTAP_TAPCELL_ROW_27_478 VGND VPWR sky130_fd_sc_hd__tapvpwrvgnd_1
XTAP_TAPCELL_ROW_10_301 VGND VPWR sky130_fd_sc_hd__tapvpwrvgnd_1
XFILLER_4_365 VPWR VGND VPWR VGND sky130_ef_sc_hd__decap_12
XPHY_EDGE_ROW_20_Right_20 VGND VGND VPWR VPWR sky130_fd_sc_hd__decap_3
XFILLER_79_155 VPWR VGND VPWR VGND sky130_ef_sc_hd__decap_12
XFILLER_94_125 VGND VGND VPWR VPWR sky130_fd_sc_hd__fill_2
XFILLER_94_169 VGND VGND VPWR VPWR sky130_fd_sc_hd__decap_8
XFILLER_63_501 VGND VGND VPWR VPWR sky130_fd_sc_hd__decap_3
XFILLER_90_331 VGND VGND VPWR VPWR sky130_fd_sc_hd__fill_1
XFILLER_35_225 VPWR VGND VPWR VGND sky130_ef_sc_hd__decap_12
XFILLER_16_450 VGND VGND VPWR VPWR sky130_fd_sc_hd__decap_6
X_3960_ array\[10\]\[17\] net468 net451 array\[8\]\[17\] VGND VGND VPWR VPWR _1882_
+ sky130_fd_sc_hd__a22o_1
X_2911_ net745 net273 _1107_ net386 net270 VGND VGND VPWR VPWR _1108_ sky130_fd_sc_hd__a221o_1
XFILLER_16_472 VGND VGND VPWR VPWR sky130_fd_sc_hd__decap_4
X_3891_ array\[2\]\[11\] net462 net445 array\[0\]\[11\] VGND VGND VPWR VPWR _1819_
+ sky130_fd_sc_hd__a22o_1
XFILLER_85_3 VPWR VGND VPWR VGND sky130_ef_sc_hd__decap_12
X_2842_ net581 net505 net278 net657 net285 VGND VGND VPWR VPWR _1060_ sky130_fd_sc_hd__a221o_1
X_2773_ net903 net283 _1015_ _1016_ VGND VGND VPWR VPWR _0040_ sky130_fd_sc_hd__o22a_1
X_4512_ clknet_leaf_37_clk _0043_ VGND VGND VPWR VPWR array\[8\]\[5\] sky130_fd_sc_hd__dfxtp_1
Xhold104 array\[3\]\[5\] VGND VGND VPWR VPWR net870 sky130_fd_sc_hd__dlygate4sd3_1
Xhold126 array\[1\]\[12\] VGND VGND VPWR VPWR net892 sky130_fd_sc_hd__dlygate4sd3_1
Xhold115 array\[13\]\[15\] VGND VGND VPWR VPWR net881 sky130_fd_sc_hd__dlygate4sd3_1
Xhold148 array\[3\]\[11\] VGND VGND VPWR VPWR net914 sky130_fd_sc_hd__dlygate4sd3_1
Xhold159 array\[1\]\[9\] VGND VGND VPWR VPWR net925 sky130_fd_sc_hd__dlygate4sd3_1
X_4443_ clknet_leaf_55_clk _0554_ VGND VGND VPWR VPWR array\[4\]\[0\] sky130_fd_sc_hd__dfxtp_1
Xhold137 array\[8\]\[2\] VGND VGND VPWR VPWR net903 sky130_fd_sc_hd__dlygate4sd3_1
Xfanout606 net80 VGND VGND VPWR VPWR net606 sky130_fd_sc_hd__dlymetal6s2s_1
X_4374_ clknet_leaf_26_clk _0485_ VGND VGND VPWR VPWR array\[1\]\[27\] sky130_fd_sc_hd__dfxtp_1
X_3325_ net876 net153 _1397_ _1398_ VGND VGND VPWR VPWR _0210_ sky130_fd_sc_hd__o22a_1
Xfanout617 net75 VGND VGND VPWR VPWR net617 sky130_fd_sc_hd__buf_2
Xfanout628 net70 VGND VGND VPWR VPWR net628 sky130_fd_sc_hd__clkbuf_2
Xfanout639 net65 VGND VGND VPWR VPWR net639 sky130_fd_sc_hd__buf_2
X_3256_ net666 net374 VGND VGND VPWR VPWR _1350_ sky130_fd_sc_hd__and2_1
X_2207_ _0609_ _0614_ _0612_ VGND VGND VPWR VPWR _0615_ sky130_fd_sc_hd__o21ai_1
XFILLER_37_18 VGND VGND VPWR VPWR sky130_fd_sc_hd__decap_6
XFILLER_85_169 VGND VGND VPWR VPWR sky130_fd_sc_hd__decap_8
X_3187_ net676 net371 VGND VGND VPWR VPWR _1304_ sky130_fd_sc_hd__and2_1
XFILLER_53_39 VGND VGND VPWR VPWR sky130_fd_sc_hd__fill_2
XTAP_TAPCELL_ROW_52_724 VGND VPWR sky130_fd_sc_hd__tapvpwrvgnd_1
XTAP_TAPCELL_ROW_24_448 VGND VPWR sky130_fd_sc_hd__tapvpwrvgnd_1
XFILLER_1_357 VPWR VGND VPWR VGND sky130_ef_sc_hd__decap_12
XFILLER_94_57 VPWR VGND VPWR VGND sky130_ef_sc_hd__decap_12
XFILLER_64_309 VGND VGND VPWR VPWR sky130_fd_sc_hd__decap_4
XTAP_TAPCELL_ROW_80_1001 VGND VPWR sky130_fd_sc_hd__tapvpwrvgnd_1
XFILLER_4_173 VPWR VGND VPWR VGND sky130_ef_sc_hd__decap_12
X_3110_ net624 net491 net376 net696 net190 VGND VGND VPWR VPWR _1250_ sky130_fd_sc_hd__a221o_1
X_4090_ net417 _1995_ _1999_ net357 VGND VGND VPWR VPWR _2001_ sky130_fd_sc_hd__a22o_1
X_3041_ net668 net594 net496 VGND VGND VPWR VPWR _1200_ sky130_fd_sc_hd__mux2_1
XTAP_TAPCELL_ROW_89_1092 VGND VPWR sky130_fd_sc_hd__tapvpwrvgnd_1
X_3943_ net354 _1860_ _1864_ net438 VGND VGND VPWR VPWR _1867_ sky130_fd_sc_hd__a22o_1
X_3874_ array\[14\]\[9\] net464 net447 array\[12\]\[9\] VGND VGND VPWR VPWR _1804_
+ sky130_fd_sc_hd__a22o_1
XTAP_TAPCELL_ROW_21_418 VGND VPWR sky130_fd_sc_hd__tapvpwrvgnd_1
X_2825_ net733 net279 VGND VGND VPWR VPWR _1049_ sky130_fd_sc_hd__and2_1
Xclkbuf_3_2__f_clk clknet_0_clk VGND VGND VPWR VPWR clknet_3_2__leaf_clk sky130_fd_sc_hd__clkbuf_16
X_2756_ _0590_ _0632_ VGND VGND VPWR VPWR _1002_ sky130_fd_sc_hd__nor2_1
X_2687_ net700 net291 _0955_ net389 VGND VGND VPWR VPWR _0956_ sky130_fd_sc_hd__a22o_1
X_4426_ clknet_leaf_38_clk _0537_ VGND VGND VPWR VPWR array\[3\]\[15\] sky130_fd_sc_hd__dfxtp_1
Xfanout403 _0783_ VGND VGND VPWR VPWR net403 sky130_fd_sc_hd__clkbuf_4
Xfanout414 _0634_ VGND VGND VPWR VPWR net414 sky130_fd_sc_hd__clkbuf_4
Xfanout447 net455 VGND VGND VPWR VPWR net447 sky130_fd_sc_hd__clkbuf_4
Xfanout425 _1635_ VGND VGND VPWR VPWR net425 sky130_fd_sc_hd__clkbuf_4
X_4357_ clknet_leaf_49_clk _0468_ VGND VGND VPWR VPWR array\[1\]\[10\] sky130_fd_sc_hd__dfxtp_1
Xfanout436 _1606_ VGND VGND VPWR VPWR net436 sky130_fd_sc_hd__buf_2
Xfanout469 net472 VGND VGND VPWR VPWR net469 sky130_fd_sc_hd__buf_2
Xfanout458 net463 VGND VGND VPWR VPWR net458 sky130_fd_sc_hd__clkbuf_4
X_3308_ net703 net173 VGND VGND VPWR VPWR _1387_ sky130_fd_sc_hd__and2_1
X_4288_ net1255 net218 _2140_ _2141_ VGND VGND VPWR VPWR _0434_ sky130_fd_sc_hd__o22a_1
X_3239_ net606 net487 net183 net744 _1338_ VGND VGND VPWR VPWR _1339_ sky130_fd_sc_hd__a221o_1
XFILLER_46_309 VGND VGND VPWR VPWR sky130_fd_sc_hd__decap_8
XTAP_TAPCELL_ROW_37_573 VGND VPWR sky130_fd_sc_hd__tapvpwrvgnd_1
XFILLER_80_26 VGND VGND VPWR VPWR sky130_fd_sc_hd__fill_2
XFILLER_10_445 VPWR VGND VPWR VGND sky130_ef_sc_hd__decap_12
XFILLER_13_86 VGND VGND VPWR VPWR sky130_fd_sc_hd__fill_1
XFILLER_10_489 VPWR VGND VPWR VGND sky130_ef_sc_hd__decap_12
XFILLER_89_57 VPWR VGND VPWR VGND sky130_ef_sc_hd__decap_12
Xhold490 array\[4\]\[14\] VGND VGND VPWR VPWR net1256 sky130_fd_sc_hd__dlygate4sd3_1
XTAP_TAPCELL_ROW_9_298 VGND VPWR sky130_fd_sc_hd__tapvpwrvgnd_1
XFILLER_77_467 VGND VGND VPWR VPWR sky130_fd_sc_hd__fill_1
XFILLER_18_501 VGND VGND VPWR VPWR sky130_fd_sc_hd__decap_3
XFILLER_45_331 VGND VGND VPWR VPWR sky130_fd_sc_hd__decap_4
Xclkload35 clknet_leaf_11_clk VGND VGND VPWR VPWR clkload35/Y sky130_fd_sc_hd__clkinvlp_4
X_2610_ net609 net510 net395 net681 net301 VGND VGND VPWR VPWR _0903_ sky130_fd_sc_hd__a221o_1
X_3590_ net1317 _1578_ _1579_ VGND VGND VPWR VPWR _0294_ sky130_fd_sc_hd__a21oi_1
Xclkload13 clknet_leaf_64_clk VGND VGND VPWR VPWR clkload13/Y sky130_fd_sc_hd__inv_6
Xclkload24 clknet_leaf_43_clk VGND VGND VPWR VPWR clkload24/Y sky130_fd_sc_hd__bufinv_16
X_2541_ net643 net573 net513 VGND VGND VPWR VPWR _0852_ sky130_fd_sc_hd__mux2_1
Xclkload46 clknet_leaf_35_clk VGND VGND VPWR VPWR clkload46/Y sky130_fd_sc_hd__clkinv_2
X_2472_ net631 net760 net516 VGND VGND VPWR VPWR _0806_ sky130_fd_sc_hd__mux2_1
X_4211_ net736 net233 net229 _2089_ VGND VGND VPWR VPWR _2090_ sky130_fd_sc_hd__a211o_1
XFILLER_48_3 VPWR VGND VPWR VGND sky130_ef_sc_hd__decap_12
X_4142_ _0624_ _1585_ _2036_ _2039_ VGND VGND VPWR VPWR _2043_ sky130_fd_sc_hd__and4b_1
X_4073_ array\[9\]\[27\] net554 net538 array\[11\]\[27\] _1984_ VGND VGND VPWR VPWR
+ _1985_ sky130_fd_sc_hd__a221o_1
X_3024_ net746 net196 _1188_ net382 VGND VGND VPWR VPWR _1189_ sky130_fd_sc_hd__a22o_1
XTAP_TAPCELL_ROW_79_996 VGND VPWR sky130_fd_sc_hd__tapvpwrvgnd_1
XFILLER_24_515 VGND VGND VPWR VPWR sky130_fd_sc_hd__decap_8
XTAP_TAPCELL_ROW_34_543 VGND VPWR sky130_fd_sc_hd__tapvpwrvgnd_1
XFILLER_51_334 VGND VGND VPWR VPWR sky130_fd_sc_hd__fill_2
X_3926_ array\[14\]\[14\] net458 net441 array\[12\]\[14\] VGND VGND VPWR VPWR _1851_
+ sky130_fd_sc_hd__a22o_1
X_3857_ array\[1\]\[8\] net557 net541 array\[3\]\[8\] _1787_ VGND VGND VPWR VPWR _1788_
+ sky130_fd_sc_hd__a221o_1
Xclkload7 clknet_leaf_58_clk VGND VGND VPWR VPWR clkload7/Y sky130_fd_sc_hd__clkinv_2
X_3788_ array\[2\]\[2\] net468 net451 array\[0\]\[2\] VGND VGND VPWR VPWR _1725_ sky130_fd_sc_hd__a22o_1
X_2808_ net613 net503 net277 net685 net287 VGND VGND VPWR VPWR _1039_ sky130_fd_sc_hd__a221o_1
X_2739_ net826 _0990_ net294 VGND VGND VPWR VPWR _0032_ sky130_fd_sc_hd__mux2_1
X_4409_ clknet_leaf_23_clk _0520_ VGND VGND VPWR VPWR array\[2\]\[30\] sky130_fd_sc_hd__dfxtp_1
Xfanout211 net213 VGND VGND VPWR VPWR net211 sky130_fd_sc_hd__buf_2
Xfanout200 net201 VGND VGND VPWR VPWR net200 sky130_fd_sc_hd__clkbuf_4
Xfanout222 _2111_ VGND VGND VPWR VPWR net222 sky130_fd_sc_hd__clkbuf_2
XTAP_TAPCELL_ROW_6_268 VGND VPWR sky130_fd_sc_hd__tapvpwrvgnd_1
Xfanout255 _1441_ VGND VGND VPWR VPWR net255 sky130_fd_sc_hd__clkbuf_4
Xfanout233 _2045_ VGND VGND VPWR VPWR net233 sky130_fd_sc_hd__clkbuf_4
Xfanout244 _1639_ VGND VGND VPWR VPWR net244 sky130_fd_sc_hd__buf_2
XFILLER_75_15 VGND VGND VPWR VPWR sky130_fd_sc_hd__decap_8
Xfanout288 _1007_ VGND VGND VPWR VPWR net288 sky130_fd_sc_hd__clkbuf_4
Xfanout299 _0867_ VGND VGND VPWR VPWR net299 sky130_fd_sc_hd__buf_4
Xfanout277 net278 VGND VGND VPWR VPWR net277 sky130_fd_sc_hd__clkbuf_4
Xfanout266 _1439_ VGND VGND VPWR VPWR net266 sky130_fd_sc_hd__buf_2
XFILLER_74_459 VGND VGND VPWR VPWR sky130_fd_sc_hd__fill_1
XFILLER_39_180 VGND VGND VPWR VPWR sky130_fd_sc_hd__decap_4
XFILLER_82_470 VGND VGND VPWR VPWR sky130_fd_sc_hd__fill_1
XFILLER_27_364 VGND VGND VPWR VPWR sky130_fd_sc_hd__decap_3
XFILLER_27_397 VGND VGND VPWR VPWR sky130_fd_sc_hd__fill_1
XFILLER_91_69 VPWR VGND VPWR VGND sky130_ef_sc_hd__decap_12
XFILLER_42_378 VGND VGND VPWR VPWR sky130_fd_sc_hd__fill_1
XFILLER_24_85 VGND VGND VPWR VPWR sky130_fd_sc_hd__fill_2
XFILLER_24_96 VGND VGND VPWR VPWR sky130_fd_sc_hd__fill_1
XFILLER_49_71 VGND VGND VPWR VPWR sky130_fd_sc_hd__decap_8
XFILLER_77_264 VGND VGND VPWR VPWR sky130_fd_sc_hd__decap_6
XFILLER_65_415 VGND VGND VPWR VPWR sky130_fd_sc_hd__decap_6
XTAP_TAPCELL_ROW_76_966 VGND VPWR sky130_fd_sc_hd__tapvpwrvgnd_1
XTAP_TAPCELL_ROW_86_1062 VGND VPWR sky130_fd_sc_hd__tapvpwrvgnd_1
XANTENNA_160 net508 VGND VGND VPWR VPWR sky130_fd_sc_hd__diode_2
XANTENNA_171 net164 VGND VGND VPWR VPWR sky130_fd_sc_hd__diode_2
X_4760_ clknet_leaf_51_clk _0291_ VGND VGND VPWR VPWR array\[10\]\[29\] sky130_fd_sc_hd__dfxtp_1
XTAP_TAPCELL_ROW_31_513 VGND VPWR sky130_fd_sc_hd__tapvpwrvgnd_1
XFILLER_60_197 VGND VGND VPWR VPWR sky130_fd_sc_hd__fill_1
X_3711_ net618 net424 net345 net690 VGND VGND VPWR VPWR _1669_ sky130_fd_sc_hd__a22o_1
X_4691_ clknet_leaf_32_clk _0222_ VGND VGND VPWR VPWR array\[12\]\[24\] sky130_fd_sc_hd__dfxtp_1
X_3642_ _0590_ _0859_ _1222_ VGND VGND VPWR VPWR _1620_ sky130_fd_sc_hd__and3_1
X_3573_ net723 net248 VGND VGND VPWR VPWR _1568_ sky130_fd_sc_hd__and2_1
XPHY_EDGE_ROW_49_Right_49 VGND VGND VPWR VPWR sky130_fd_sc_hd__decap_3
X_2524_ net727 net304 _0840_ net402 net308 VGND VGND VPWR VPWR _0841_ sky130_fd_sc_hd__a221o_1
X_2455_ net717 net304 _0794_ net402 net308 VGND VGND VPWR VPWR _0795_ sky130_fd_sc_hd__a221o_1
X_2386_ net1064 net207 _0745_ VGND VGND VPWR VPWR _0504_ sky130_fd_sc_hd__o21a_1
Xhold19 array\[5\]\[3\] VGND VGND VPWR VPWR net785 sky130_fd_sc_hd__dlygate4sd3_1
XFILLER_68_253 VGND VGND VPWR VPWR sky130_fd_sc_hd__decap_6
XFILLER_68_242 VGND VGND VPWR VPWR sky130_fd_sc_hd__decap_3
X_4125_ net357 _2027_ _2031_ net417 VGND VGND VPWR VPWR _2033_ sky130_fd_sc_hd__a22o_1
XTAP_TAPCELL_ROW_3_238 VGND VPWR sky130_fd_sc_hd__tapvpwrvgnd_1
XFILLER_83_234 VGND VGND VPWR VPWR sky130_fd_sc_hd__fill_1
X_4056_ net417 _1963_ _1967_ net352 VGND VGND VPWR VPWR _1970_ sky130_fd_sc_hd__a22o_1
XPHY_EDGE_ROW_58_Right_58 VGND VGND VPWR VPWR sky130_fd_sc_hd__decap_3
X_3007_ net1050 _1177_ net167 VGND VGND VPWR VPWR _0113_ sky130_fd_sc_hd__mux2_1
XTAP_TAPCELL_ROW_19_392 VGND VPWR sky130_fd_sc_hd__tapvpwrvgnd_1
XFILLER_61_28 VGND VGND VPWR VPWR sky130_fd_sc_hd__decap_4
X_3909_ array\[5\]\[12\] net547 net537 array\[7\]\[12\] _1835_ VGND VGND VPWR VPWR
+ _1836_ sky130_fd_sc_hd__a221o_1
XFILLER_20_551 VGND VGND VPWR VPWR sky130_fd_sc_hd__decap_8
X_4889_ clknet_leaf_56_clk _0420_ VGND VGND VPWR VPWR array\[6\]\[0\] sky130_fd_sc_hd__dfxtp_1
XPHY_EDGE_ROW_67_Right_67 VGND VGND VPWR VPWR sky130_fd_sc_hd__decap_3
XFILLER_3_205 VPWR VGND VPWR VGND sky130_ef_sc_hd__decap_12
XFILLER_3_249 VPWR VGND VPWR VGND sky130_ef_sc_hd__decap_12
XFILLER_79_529 VPWR VGND VPWR VGND sky130_ef_sc_hd__decap_12
XPHY_EDGE_ROW_76_Right_76 VGND VGND VPWR VPWR sky130_fd_sc_hd__decap_3
XTAP_TAPCELL_ROW_73_936 VGND VPWR sky130_fd_sc_hd__tapvpwrvgnd_1
XFILLER_15_389 VGND VGND VPWR VPWR sky130_fd_sc_hd__decap_3
XFILLER_42_197 VGND VGND VPWR VPWR sky130_fd_sc_hd__decap_6
XFILLER_30_359 VGND VGND VPWR VPWR sky130_fd_sc_hd__decap_4
XPHY_EDGE_ROW_85_Right_85 VGND VGND VPWR VPWR sky130_fd_sc_hd__decap_3
XPHY_EDGE_ROW_29_Left_124 VGND VGND VPWR VPWR sky130_fd_sc_hd__decap_3
XFILLER_32_6 VPWR VGND VPWR VGND sky130_ef_sc_hd__decap_12
X_2240_ net675 net601 net522 VGND VGND VPWR VPWR _0645_ sky130_fd_sc_hd__mux2_1
XPHY_EDGE_ROW_94_Right_94 VGND VGND VPWR VPWR sky130_fd_sc_hd__decap_3
XFILLER_65_223 VGND VGND VPWR VPWR sky130_fd_sc_hd__fill_1
XTAP_TAPCELL_ROW_0_208 VGND VPWR sky130_fd_sc_hd__tapvpwrvgnd_1
XPHY_EDGE_ROW_38_Left_133 VGND VGND VPWR VPWR sky130_fd_sc_hd__decap_3
XTAP_TAPCELL_ROW_16_362 VGND VPWR sky130_fd_sc_hd__tapvpwrvgnd_1
X_4812_ clknet_leaf_20_clk _0343_ VGND VGND VPWR VPWR array\[9\]\[30\] sky130_fd_sc_hd__dfxtp_1
X_4743_ clknet_leaf_19_clk _0274_ VGND VGND VPWR VPWR array\[10\]\[12\] sky130_fd_sc_hd__dfxtp_1
X_4674_ clknet_leaf_60_clk _0205_ VGND VGND VPWR VPWR array\[12\]\[7\] sky130_fd_sc_hd__dfxtp_1
X_3625_ head\[3\] net559 VGND VGND VPWR VPWR _1606_ sky130_fd_sc_hd__nor2_4
X_3556_ net736 net246 _1556_ net252 VGND VGND VPWR VPWR _1557_ sky130_fd_sc_hd__a211o_1
X_2507_ net1298 net203 _0829_ VGND VGND VPWR VPWR _0541_ sky130_fd_sc_hd__o21a_1
XPHY_EDGE_ROW_47_Left_142 VGND VGND VPWR VPWR sky130_fd_sc_hd__decap_3
XFILLER_88_326 VGND VGND VPWR VPWR sky130_fd_sc_hd__fill_1
X_3487_ net103 net104 _0591_ _1004_ VGND VGND VPWR VPWR _1509_ sky130_fd_sc_hd__and4b_1
Xinput109 write_location1[2] VGND VGND VPWR VPWR net109 sky130_fd_sc_hd__clkbuf_1
X_2438_ net112 net111 VGND VGND VPWR VPWR _0780_ sky130_fd_sc_hd__and2_1
X_2369_ net758 net627 net518 VGND VGND VPWR VPWR _0734_ sky130_fd_sc_hd__mux2_1
X_4108_ array\[9\]\[30\] net554 net538 array\[11\]\[30\] _2016_ VGND VGND VPWR VPWR
+ _2017_ sky130_fd_sc_hd__a221o_1
XFILLER_44_429 VGND VGND VPWR VPWR sky130_fd_sc_hd__decap_8
X_4039_ array\[2\]\[24\] net468 net451 array\[0\]\[24\] VGND VGND VPWR VPWR _1954_
+ sky130_fd_sc_hd__a22o_1
XPHY_EDGE_ROW_56_Left_151 VGND VGND VPWR VPWR sky130_fd_sc_hd__decap_3
XFILLER_72_27 VGND VGND VPWR VPWR sky130_fd_sc_hd__fill_1
XTAP_TAPCELL_ROW_70_906 VGND VPWR sky130_fd_sc_hd__tapvpwrvgnd_1
XFILLER_24_197 VGND VGND VPWR VPWR sky130_fd_sc_hd__fill_1
XANTENNA_93 net368 VGND VGND VPWR VPWR sky130_fd_sc_hd__diode_2
XANTENNA_60 _2114_ VGND VGND VPWR VPWR sky130_fd_sc_hd__diode_2
XANTENNA_82 net279 VGND VGND VPWR VPWR sky130_fd_sc_hd__diode_2
XANTENNA_71 net186 VGND VGND VPWR VPWR sky130_fd_sc_hd__diode_2
XPHY_EDGE_ROW_65_Left_160 VGND VGND VPWR VPWR sky130_fd_sc_hd__decap_3
XFILLER_4_525 VGND VGND VPWR VPWR sky130_fd_sc_hd__decap_6
XFILLER_79_337 VGND VGND VPWR VPWR sky130_fd_sc_hd__decap_4
XFILLER_47_234 VPWR VGND VPWR VGND sky130_ef_sc_hd__decap_12
XFILLER_90_513 VPWR VGND VPWR VGND sky130_ef_sc_hd__decap_12
XFILLER_35_418 VGND VGND VPWR VPWR sky130_fd_sc_hd__decap_3
XFILLER_47_278 VGND VGND VPWR VPWR sky130_fd_sc_hd__fill_2
XTAP_TAPCELL_ROW_58_785 VGND VPWR sky130_fd_sc_hd__tapvpwrvgnd_1
XFILLER_90_557 VGND VGND VPWR VPWR sky130_fd_sc_hd__decap_4
XFILLER_46_94 VGND VGND VPWR VPWR sky130_fd_sc_hd__fill_1
XTAP_TAPCELL_ROW_83_1032 VGND VPWR sky130_fd_sc_hd__tapvpwrvgnd_1
XFILLER_30_101 VGND VGND VPWR VPWR sky130_fd_sc_hd__fill_2
XFILLER_15_197 VGND VGND VPWR VPWR sky130_fd_sc_hd__fill_1
XTAP_TAPCELL_ROW_13_332 VGND VPWR sky130_fd_sc_hd__tapvpwrvgnd_1
XFILLER_7_55 VGND VGND VPWR VPWR sky130_fd_sc_hd__fill_1
Xhold308 array\[11\]\[24\] VGND VGND VPWR VPWR net1074 sky130_fd_sc_hd__dlygate4sd3_1
X_4390_ clknet_leaf_13_clk _0501_ VGND VGND VPWR VPWR array\[2\]\[11\] sky130_fd_sc_hd__dfxtp_1
X_3410_ net763 net477 net363 net634 VGND VGND VPWR VPWR _1457_ sky130_fd_sc_hd__a22o_1
Xhold319 array\[5\]\[7\] VGND VGND VPWR VPWR net1085 sky130_fd_sc_hd__dlygate4sd3_1
XTAP_TAPCELL_ROW_94_1150 VGND VPWR sky130_fd_sc_hd__tapvpwrvgnd_1
X_3341_ net1211 net180 net176 net744 _1408_ VGND VGND VPWR VPWR _0216_ sky130_fd_sc_hd__a221o_1
X_3272_ net579 net486 net182 net719 _1360_ VGND VGND VPWR VPWR _1361_ sky130_fd_sc_hd__a221o_1
X_2223_ net112 net111 VGND VGND VPWR VPWR _0629_ sky130_fd_sc_hd__and2b_1
XFILLER_38_234 VGND VGND VPWR VPWR sky130_fd_sc_hd__fill_2
XFILLER_81_502 VGND VGND VPWR VPWR sky130_fd_sc_hd__fill_2
XFILLER_81_535 VPWR VGND VPWR VGND sky130_ef_sc_hd__decap_12
XFILLER_53_259 VGND VGND VPWR VPWR sky130_fd_sc_hd__fill_1
XFILLER_21_101 VGND VGND VPWR VPWR sky130_fd_sc_hd__decap_8
XFILLER_61_281 VGND VGND VPWR VPWR sky130_fd_sc_hd__fill_2
X_2987_ net638 net568 net495 VGND VGND VPWR VPWR _1164_ sky130_fd_sc_hd__mux2_1
XFILLER_21_167 VGND VGND VPWR VPWR sky130_fd_sc_hd__fill_1
X_4726_ clknet_leaf_21_clk _0257_ VGND VGND VPWR VPWR array\[11\]\[27\] sky130_fd_sc_hd__dfxtp_1
X_4657_ clknet_leaf_59_clk _0188_ VGND VGND VPWR VPWR array\[13\]\[22\] sky130_fd_sc_hd__dfxtp_1
Xinput80 value2[18] VGND VGND VPWR VPWR net80 sky130_fd_sc_hd__buf_1
Xinput91 value2[28] VGND VGND VPWR VPWR net91 sky130_fd_sc_hd__buf_1
X_3608_ _1145_ _1366_ net563 ready_check\[12\] VGND VGND VPWR VPWR _1592_ sky130_fd_sc_hd__o211a_1
X_4588_ clknet_leaf_25_clk _0119_ VGND VGND VPWR VPWR array\[15\]\[17\] sky130_fd_sc_hd__dfxtp_1
XFILLER_1_517 VPWR VGND VPWR VGND sky130_ef_sc_hd__decap_12
X_3539_ net979 net251 _1544_ _1545_ VGND VGND VPWR VPWR _0277_ sky130_fd_sc_hd__o22a_1
XFILLER_67_27 VPWR VGND VPWR VGND sky130_ef_sc_hd__decap_12
XFILLER_83_15 VPWR VGND VPWR VGND sky130_ef_sc_hd__decap_12
XFILLER_17_407 VGND VGND VPWR VPWR sky130_fd_sc_hd__fill_1
XFILLER_84_395 VGND VGND VPWR VPWR sky130_fd_sc_hd__fill_2
XTAP_TAPCELL_ROW_55_755 VGND VPWR sky130_fd_sc_hd__tapvpwrvgnd_1
XTAP_TAPCELL_ROW_27_479 VGND VPWR sky130_fd_sc_hd__tapvpwrvgnd_1
XTAP_TAPCELL_ROW_10_302 VGND VPWR sky130_fd_sc_hd__tapvpwrvgnd_1
XFILLER_32_41 VPWR VGND VPWR VGND sky130_ef_sc_hd__decap_12
XFILLER_32_96 VGND VGND VPWR VPWR sky130_fd_sc_hd__fill_1
XFILLER_4_377 VPWR VGND VPWR VGND sky130_ef_sc_hd__decap_12
XFILLER_79_167 VGND VGND VPWR VPWR sky130_fd_sc_hd__fill_1
XFILLER_0_561 VGND VGND VPWR VPWR sky130_fd_sc_hd__fill_1
XFILLER_35_237 VGND VGND VPWR VPWR sky130_fd_sc_hd__fill_2
XFILLER_90_365 VGND VGND VPWR VPWR sky130_fd_sc_hd__decap_4
X_2910_ net609 net681 net499 VGND VGND VPWR VPWR _1107_ sky130_fd_sc_hd__mux2_1
XFILLER_16_484 VGND VGND VPWR VPWR sky130_fd_sc_hd__decap_3
X_3890_ net821 net171 _1817_ _1818_ VGND VGND VPWR VPWR _0355_ sky130_fd_sc_hd__o22a_1
X_2841_ net721 net282 VGND VGND VPWR VPWR _1059_ sky130_fd_sc_hd__and2_1
XFILLER_78_3 VPWR VGND VPWR VGND sky130_ef_sc_hd__decap_12
X_2772_ net577 net503 net277 net647 net287 VGND VGND VPWR VPWR _1016_ sky130_fd_sc_hd__a221o_1
X_4511_ clknet_leaf_40_clk _0042_ VGND VGND VPWR VPWR array\[8\]\[4\] sky130_fd_sc_hd__dfxtp_1
Xhold105 array\[15\]\[17\] VGND VGND VPWR VPWR net871 sky130_fd_sc_hd__dlygate4sd3_1
XFILLER_7_182 VGND VGND VPWR VPWR sky130_fd_sc_hd__decap_4
X_4442_ clknet_leaf_46_clk _0553_ VGND VGND VPWR VPWR array\[3\]\[31\] sky130_fd_sc_hd__dfxtp_1
Xhold116 array\[8\]\[15\] VGND VGND VPWR VPWR net882 sky130_fd_sc_hd__dlygate4sd3_1
Xhold127 array\[14\]\[5\] VGND VGND VPWR VPWR net893 sky130_fd_sc_hd__dlygate4sd3_1
Xhold149 array\[9\]\[19\] VGND VGND VPWR VPWR net915 sky130_fd_sc_hd__dlygate4sd3_1
Xhold138 array\[8\]\[30\] VGND VGND VPWR VPWR net904 sky130_fd_sc_hd__dlygate4sd3_1
X_4373_ clknet_leaf_16_clk _0484_ VGND VGND VPWR VPWR array\[1\]\[26\] sky130_fd_sc_hd__dfxtp_1
X_3324_ net620 net482 net367 net692 net177 VGND VGND VPWR VPWR _1398_ sky130_fd_sc_hd__a221o_1
Xfanout618 net75 VGND VGND VPWR VPWR net618 sky130_fd_sc_hd__clkbuf_2
Xfanout629 net7 VGND VGND VPWR VPWR net629 sky130_fd_sc_hd__buf_2
Xfanout607 net8 VGND VGND VPWR VPWR net607 sky130_fd_sc_hd__buf_2
X_3255_ net897 _1349_ net160 VGND VGND VPWR VPWR _0189_ sky130_fd_sc_hd__mux2_1
X_2206_ head\[3\] net559 VGND VGND VPWR VPWR _0614_ sky130_fd_sc_hd__nand2_1
X_3186_ net852 _1303_ net157 VGND VGND VPWR VPWR _0166_ sky130_fd_sc_hd__mux2_1
XFILLER_54_502 VGND VGND VPWR VPWR sky130_fd_sc_hd__decap_6
XFILLER_81_376 VGND VGND VPWR VPWR sky130_fd_sc_hd__fill_1
XTAP_TAPCELL_ROW_52_725 VGND VPWR sky130_fd_sc_hd__tapvpwrvgnd_1
XTAP_TAPCELL_ROW_24_449 VGND VPWR sky130_fd_sc_hd__tapvpwrvgnd_1
X_4709_ clknet_leaf_46_clk _0240_ VGND VGND VPWR VPWR array\[11\]\[10\] sky130_fd_sc_hd__dfxtp_1
XFILLER_78_15 VPWR VGND VPWR VGND sky130_ef_sc_hd__decap_12
XFILLER_1_314 VPWR VGND VPWR VGND sky130_ef_sc_hd__decap_12
XFILLER_1_369 VGND VGND VPWR VPWR sky130_fd_sc_hd__decap_4
XFILLER_94_69 VPWR VGND VPWR VGND sky130_ef_sc_hd__decap_12
XTAP_TAPCELL_ROW_68_880 VGND VPWR sky130_fd_sc_hd__tapvpwrvgnd_1
XFILLER_27_30 VPWR VGND VPWR VGND sky130_ef_sc_hd__decap_12
XTAP_TAPCELL_ROW_80_1002 VGND VPWR sky130_fd_sc_hd__tapvpwrvgnd_1
XFILLER_32_218 VGND VGND VPWR VPWR sky130_fd_sc_hd__fill_1
XFILLER_25_281 VGND VGND VPWR VPWR sky130_fd_sc_hd__decap_3
XFILLER_40_251 VGND VGND VPWR VPWR sky130_fd_sc_hd__fill_1
XFILLER_4_141 VPWR VGND VPWR VGND sky130_ef_sc_hd__decap_12
XFILLER_4_185 VGND VGND VPWR VPWR sky130_fd_sc_hd__decap_6
X_3040_ net1103 _1199_ net165 VGND VGND VPWR VPWR _0124_ sky130_fd_sc_hd__mux2_1
XFILLER_48_340 VGND VGND VPWR VPWR sky130_fd_sc_hd__fill_2
XFILLER_36_524 VGND VGND VPWR VPWR sky130_fd_sc_hd__fill_1
XTAP_TAPCELL_ROW_89_1093 VGND VPWR sky130_fd_sc_hd__tapvpwrvgnd_1
X_3942_ array\[9\]\[15\] net554 net538 array\[11\]\[15\] _1865_ VGND VGND VPWR VPWR
+ _1866_ sky130_fd_sc_hd__a221o_1
XFILLER_31_251 VGND VGND VPWR VPWR sky130_fd_sc_hd__decap_3
X_3873_ array\[5\]\[9\] net551 net531 array\[7\]\[9\] _1802_ VGND VGND VPWR VPWR _1803_
+ sky130_fd_sc_hd__a221o_1
XTAP_TAPCELL_ROW_21_419 VGND VPWR sky130_fd_sc_hd__tapvpwrvgnd_1
X_2824_ net1305 net286 net280 net736 _1048_ VGND VGND VPWR VPWR _0059_ sky130_fd_sc_hd__a221o_1
X_2755_ net753 _0627_ _0857_ VGND VGND VPWR VPWR _1001_ sky130_fd_sc_hd__and3_1
X_2686_ net628 net759 net393 VGND VGND VPWR VPWR _0955_ sky130_fd_sc_hd__mux2_1
X_4425_ clknet_leaf_1_clk _0536_ VGND VGND VPWR VPWR array\[3\]\[14\] sky130_fd_sc_hd__dfxtp_1
Xfanout404 _0783_ VGND VGND VPWR VPWR net404 sky130_fd_sc_hd__clkbuf_4
X_4356_ clknet_leaf_52_clk _0467_ VGND VGND VPWR VPWR array\[1\]\[9\] sky130_fd_sc_hd__dfxtp_1
XFILLER_86_402 VGND VGND VPWR VPWR sky130_fd_sc_hd__fill_2
Xfanout415 _0613_ VGND VGND VPWR VPWR net415 sky130_fd_sc_hd__buf_4
Xfanout448 net455 VGND VGND VPWR VPWR net448 sky130_fd_sc_hd__clkbuf_2
XFILLER_48_29 VGND VGND VPWR VPWR sky130_fd_sc_hd__decap_6
X_3307_ net854 net153 _1385_ _1386_ VGND VGND VPWR VPWR _0204_ sky130_fd_sc_hd__o22a_1
Xfanout437 _1606_ VGND VGND VPWR VPWR net437 sky130_fd_sc_hd__buf_4
Xfanout426 _1635_ VGND VGND VPWR VPWR net426 sky130_fd_sc_hd__buf_2
X_4287_ net616 net427 net331 net688 net221 VGND VGND VPWR VPWR _2141_ sky130_fd_sc_hd__a221o_1
Xfanout459 net463 VGND VGND VPWR VPWR net459 sky130_fd_sc_hd__clkbuf_4
XFILLER_58_148 VGND VGND VPWR VPWR sky130_fd_sc_hd__decap_3
X_3238_ net680 net373 VGND VGND VPWR VPWR _1338_ sky130_fd_sc_hd__and2_1
XFILLER_86_468 VGND VGND VPWR VPWR sky130_fd_sc_hd__fill_1
XFILLER_58_159 VGND VGND VPWR VPWR sky130_fd_sc_hd__fill_1
X_3169_ net576 net492 net377 net646 VGND VGND VPWR VPWR _1289_ sky130_fd_sc_hd__a22o_1
XTAP_TAPCELL_ROW_65_850 VGND VPWR sky130_fd_sc_hd__tapvpwrvgnd_1
XTAP_TAPCELL_ROW_37_574 VGND VPWR sky130_fd_sc_hd__tapvpwrvgnd_1
XFILLER_10_457 VPWR VGND VPWR VGND sky130_ef_sc_hd__decap_12
XFILLER_89_69 VPWR VGND VPWR VGND sky130_ef_sc_hd__decap_12
Xhold480 array\[12\]\[1\] VGND VGND VPWR VPWR net1246 sky130_fd_sc_hd__dlygate4sd3_1
XFILLER_8_3 VPWR VGND VPWR VGND sky130_ef_sc_hd__decap_12
XFILLER_89_262 VGND VGND VPWR VPWR sky130_fd_sc_hd__fill_2
XTAP_TAPCELL_ROW_9_299 VGND VPWR sky130_fd_sc_hd__tapvpwrvgnd_1
Xhold491 array\[8\]\[9\] VGND VGND VPWR VPWR net1257 sky130_fd_sc_hd__dlygate4sd3_1
XFILLER_49_159 VGND VGND VPWR VPWR sky130_fd_sc_hd__fill_2
XFILLER_45_321 VGND VGND VPWR VPWR sky130_fd_sc_hd__fill_1
XFILLER_54_83 VGND VGND VPWR VPWR sky130_fd_sc_hd__fill_1
XFILLER_70_71 VPWR VGND VPWR VGND sky130_ef_sc_hd__decap_12
Xclkload25 clknet_leaf_44_clk VGND VGND VPWR VPWR clkload25/Y sky130_fd_sc_hd__inv_6
Xclkload14 clknet_leaf_0_clk VGND VGND VPWR VPWR clkload14/X sky130_fd_sc_hd__clkbuf_4
XFILLER_62_6 VGND VGND VPWR VPWR sky130_fd_sc_hd__decap_6
Xclkload36 clknet_leaf_12_clk VGND VGND VPWR VPWR clkload36/Y sky130_fd_sc_hd__inv_6
X_2540_ net946 net206 _0851_ VGND VGND VPWR VPWR _0552_ sky130_fd_sc_hd__o21a_1
Xclkload47 clknet_leaf_36_clk VGND VGND VPWR VPWR clkload47/Y sky130_fd_sc_hd__clkinv_2
XFILLER_5_461 VPWR VGND VPWR VGND sky130_ef_sc_hd__decap_12
X_2471_ net1310 net204 _0805_ VGND VGND VPWR VPWR _0529_ sky130_fd_sc_hd__o21a_1
XPHY_EDGE_ROW_10_Left_105 VGND VGND VPWR VPWR sky130_fd_sc_hd__decap_3
X_4210_ net598 net431 net340 net672 VGND VGND VPWR VPWR _2089_ sky130_fd_sc_hd__a22o_1
X_4141_ net656 net772 net169 VGND VGND VPWR VPWR _0386_ sky130_fd_sc_hd__a21o_1
XFILLER_83_405 VGND VGND VPWR VPWR sky130_fd_sc_hd__fill_1
X_4072_ array\[10\]\[27\] net468 net451 array\[8\]\[27\] VGND VGND VPWR VPWR _1984_
+ sky130_fd_sc_hd__a22o_1
X_3023_ net682 net610 net495 VGND VGND VPWR VPWR _1188_ sky130_fd_sc_hd__mux2_1
XFILLER_83_449 VGND VGND VPWR VPWR sky130_fd_sc_hd__decap_4
XTAP_TAPCELL_ROW_79_997 VGND VPWR sky130_fd_sc_hd__tapvpwrvgnd_1
XFILLER_48_192 VGND VGND VPWR VPWR sky130_fd_sc_hd__decap_4
XTAP_TAPCELL_ROW_62_820 VGND VPWR sky130_fd_sc_hd__tapvpwrvgnd_1
XTAP_TAPCELL_ROW_34_544 VGND VPWR sky130_fd_sc_hd__tapvpwrvgnd_1
X_3925_ array\[1\]\[14\] net545 net527 array\[3\]\[14\] _1849_ VGND VGND VPWR VPWR
+ _1850_ sky130_fd_sc_hd__a221o_1
X_3856_ array\[2\]\[8\] net470 net453 array\[0\]\[8\] VGND VGND VPWR VPWR _1787_ sky130_fd_sc_hd__a22o_1
Xclkload8 clknet_leaf_59_clk VGND VGND VPWR VPWR clkload8/Y sky130_fd_sc_hd__clkinvlp_4
X_3787_ net977 net171 _1724_ VGND VGND VPWR VPWR _0346_ sky130_fd_sc_hd__o21a_1
X_2807_ net749 net281 VGND VGND VPWR VPWR _1038_ sky130_fd_sc_hd__and2_1
X_2738_ net725 net290 _0989_ net388 VGND VGND VPWR VPWR _0990_ sky130_fd_sc_hd__a22o_1
X_4408_ clknet_leaf_54_clk _0519_ VGND VGND VPWR VPWR array\[2\]\[29\] sky130_fd_sc_hd__dfxtp_1
X_2669_ net711 net290 _0943_ net388 VGND VGND VPWR VPWR _0944_ sky130_fd_sc_hd__a22o_1
Xfanout212 net213 VGND VGND VPWR VPWR net212 sky130_fd_sc_hd__clkbuf_2
Xfanout201 net202 VGND VGND VPWR VPWR net201 sky130_fd_sc_hd__buf_4
Xfanout223 _2111_ VGND VGND VPWR VPWR net223 sky130_fd_sc_hd__clkbuf_4
XFILLER_86_210 VGND VGND VPWR VPWR sky130_fd_sc_hd__fill_1
Xfanout245 net248 VGND VGND VPWR VPWR net245 sky130_fd_sc_hd__clkbuf_4
X_4339_ net560 _0603_ net169 net545 VGND VGND VPWR VPWR _0378_ sky130_fd_sc_hd__a22o_1
Xfanout234 _2045_ VGND VGND VPWR VPWR net234 sky130_fd_sc_hd__clkbuf_2
Xfanout256 _1441_ VGND VGND VPWR VPWR net256 sky130_fd_sc_hd__clkbuf_2
Xfanout278 _1010_ VGND VGND VPWR VPWR net278 sky130_fd_sc_hd__clkbuf_4
XTAP_TAPCELL_ROW_6_269 VGND VPWR sky130_fd_sc_hd__tapvpwrvgnd_1
Xfanout267 _1144_ VGND VGND VPWR VPWR net267 sky130_fd_sc_hd__clkbuf_2
Xfanout289 net292 VGND VGND VPWR VPWR net289 sky130_fd_sc_hd__clkbuf_4
XFILLER_86_298 VGND VGND VPWR VPWR sky130_fd_sc_hd__decap_3
XFILLER_86_276 VGND VGND VPWR VPWR sky130_fd_sc_hd__decap_3
XFILLER_91_15 VPWR VGND VPWR VGND sky130_ef_sc_hd__decap_12
XFILLER_40_41 VGND VGND VPWR VPWR sky130_fd_sc_hd__decap_3
XFILLER_2_475 VGND VGND VPWR VPWR sky130_fd_sc_hd__fill_1
XTAP_TAPCELL_ROW_76_967 VGND VPWR sky130_fd_sc_hd__tapvpwrvgnd_1
XFILLER_1_79 VGND VGND VPWR VPWR sky130_fd_sc_hd__decap_4
Xclkbuf_leaf_57_clk clknet_3_0__leaf_clk VGND VGND VPWR VPWR clknet_leaf_57_clk sky130_fd_sc_hd__clkbuf_8
XTAP_TAPCELL_ROW_86_1063 VGND VPWR sky130_fd_sc_hd__tapvpwrvgnd_1
XFILLER_65_71 VGND VGND VPWR VPWR sky130_fd_sc_hd__fill_1
XFILLER_33_302 VGND VGND VPWR VPWR sky130_fd_sc_hd__fill_2
XFILLER_45_140 VGND VGND VPWR VPWR sky130_fd_sc_hd__fill_2
XFILLER_73_482 VGND VGND VPWR VPWR sky130_fd_sc_hd__decap_4
XANTENNA_161 net542 VGND VGND VPWR VPWR sky130_fd_sc_hd__diode_2
XANTENNA_150 net370 VGND VGND VPWR VPWR sky130_fd_sc_hd__diode_2
XANTENNA_172 net164 VGND VGND VPWR VPWR sky130_fd_sc_hd__diode_2
XTAP_TAPCELL_ROW_31_514 VGND VPWR sky130_fd_sc_hd__tapvpwrvgnd_1
X_3710_ net1043 net237 _1667_ _1668_ VGND VGND VPWR VPWR _0325_ sky130_fd_sc_hd__o22a_1
X_4690_ clknet_leaf_34_clk _0221_ VGND VGND VPWR VPWR array\[12\]\[23\] sky130_fd_sc_hd__dfxtp_1
X_3641_ _0586_ _0707_ _0854_ VGND VGND VPWR VPWR _1619_ sky130_fd_sc_hd__and3_2
X_3572_ net1017 net250 _1567_ VGND VGND VPWR VPWR _0288_ sky130_fd_sc_hd__o21a_1
X_2523_ net663 net589 net513 VGND VGND VPWR VPWR _0840_ sky130_fd_sc_hd__mux2_1
X_2454_ net647 net577 net513 VGND VGND VPWR VPWR _0794_ sky130_fd_sc_hd__mux2_1
X_2385_ net751 net315 _0744_ net406 net312 VGND VGND VPWR VPWR _0745_ sky130_fd_sc_hd__a221o_1
X_4124_ net436 _2025_ _2029_ net352 VGND VGND VPWR VPWR _2032_ sky130_fd_sc_hd__a22o_1
XTAP_TAPCELL_ROW_3_239 VGND VPWR sky130_fd_sc_hd__tapvpwrvgnd_1
Xinput1 control[0] VGND VGND VPWR VPWR net1 sky130_fd_sc_hd__buf_1
XFILLER_56_427 VPWR VGND VPWR VGND sky130_ef_sc_hd__decap_12
X_4055_ array\[1\]\[25\] net553 net531 array\[3\]\[25\] _1968_ VGND VGND VPWR VPWR
+ _1969_ sky130_fd_sc_hd__a221o_1
X_3006_ net586 net195 _1176_ net381 VGND VGND VPWR VPWR _1177_ sky130_fd_sc_hd__a22o_1
XFILLER_71_408 VPWR VGND VPWR VGND sky130_ef_sc_hd__decap_12
XFILLER_51_110 VGND VGND VPWR VPWR sky130_fd_sc_hd__fill_2
XTAP_TAPCELL_ROW_19_393 VGND VPWR sky130_fd_sc_hd__tapvpwrvgnd_1
XFILLER_61_18 VGND VGND VPWR VPWR sky130_fd_sc_hd__decap_6
X_3908_ array\[6\]\[12\] net461 net444 array\[4\]\[12\] VGND VGND VPWR VPWR _1835_
+ sky130_fd_sc_hd__a22o_1
X_4888_ clknet_leaf_45_clk _0419_ VGND VGND VPWR VPWR array\[7\]\[31\] sky130_fd_sc_hd__dfxtp_1
X_3839_ array\[14\]\[6\] net459 net442 array\[12\]\[6\] VGND VGND VPWR VPWR _1772_
+ sky130_fd_sc_hd__a22o_1
XFILLER_3_217 VGND VGND VPWR VPWR sky130_fd_sc_hd__decap_6
XFILLER_86_15 VPWR VGND VPWR VGND sky130_ef_sc_hd__decap_12
XFILLER_87_541 VPWR VGND VPWR VGND sky130_ef_sc_hd__decap_12
XFILLER_19_53 VGND VGND VPWR VPWR sky130_fd_sc_hd__decap_3
Xclkbuf_leaf_39_clk clknet_3_3__leaf_clk VGND VGND VPWR VPWR clknet_leaf_39_clk sky130_fd_sc_hd__clkbuf_8
XFILLER_47_449 VGND VGND VPWR VPWR sky130_fd_sc_hd__fill_2
XTAP_TAPCELL_ROW_73_937 VGND VPWR sky130_fd_sc_hd__tapvpwrvgnd_1
XFILLER_11_541 VPWR VGND VPWR VGND sky130_ef_sc_hd__decap_12
XFILLER_51_73 VGND VGND VPWR VPWR sky130_fd_sc_hd__decap_4
XTAP_TAPCELL_ROW_0_209 VGND VPWR sky130_fd_sc_hd__tapvpwrvgnd_1
XFILLER_80_205 VGND VGND VPWR VPWR sky130_fd_sc_hd__decap_8
XFILLER_46_460 VGND VGND VPWR VPWR sky130_fd_sc_hd__decap_6
X_4811_ clknet_leaf_52_clk _0342_ VGND VGND VPWR VPWR array\[9\]\[29\] sky130_fd_sc_hd__dfxtp_1
XTAP_TAPCELL_ROW_16_363 VGND VPWR sky130_fd_sc_hd__tapvpwrvgnd_1
X_4742_ clknet_leaf_18_clk _0273_ VGND VGND VPWR VPWR array\[10\]\[11\] sky130_fd_sc_hd__dfxtp_1
X_4673_ clknet_leaf_8_clk _0204_ VGND VGND VPWR VPWR array\[12\]\[6\] sky130_fd_sc_hd__dfxtp_1
X_3624_ _1142_ _1143_ _1366_ net1321 net563 VGND VGND VPWR VPWR _1605_ sky130_fd_sc_hd__o311a_1
X_3555_ net598 net475 net360 net672 VGND VGND VPWR VPWR _1556_ sky130_fd_sc_hd__a22o_1
X_2506_ net741 net304 _0828_ net402 net308 VGND VGND VPWR VPWR _0829_ sky130_fd_sc_hd__a221o_1
X_3486_ net501 _1222_ net473 VGND VGND VPWR VPWR _1508_ sky130_fd_sc_hd__a21oi_1
X_2437_ net1121 net208 _0779_ VGND VGND VPWR VPWR _0521_ sky130_fd_sc_hd__o21a_1
X_2368_ net814 net209 _0733_ VGND VGND VPWR VPWR _0498_ sky130_fd_sc_hd__o21a_1
XFILLER_29_405 VGND VGND VPWR VPWR sky130_fd_sc_hd__decap_6
XFILLER_56_29 VGND VGND VPWR VPWR sky130_fd_sc_hd__decap_3
XFILLER_84_533 VPWR VGND VPWR VGND sky130_ef_sc_hd__decap_12
X_2299_ net1005 net325 _0684_ VGND VGND VPWR VPWR _0478_ sky130_fd_sc_hd__o21a_1
X_4107_ array\[10\]\[30\] net468 net451 array\[8\]\[30\] VGND VGND VPWR VPWR _2016_
+ sky130_fd_sc_hd__a22o_1
X_4038_ array\[13\]\[24\] net556 net539 array\[15\]\[24\] _1952_ VGND VGND VPWR VPWR
+ _1953_ sky130_fd_sc_hd__a221o_1
XFILLER_71_249 VGND VGND VPWR VPWR sky130_fd_sc_hd__decap_4
XFILLER_37_471 VGND VGND VPWR VPWR sky130_fd_sc_hd__fill_2
XTAP_TAPCELL_ROW_70_907 VGND VPWR sky130_fd_sc_hd__tapvpwrvgnd_1
XFILLER_24_187 VGND VGND VPWR VPWR sky130_fd_sc_hd__fill_1
XFILLER_20_360 VGND VGND VPWR VPWR sky130_fd_sc_hd__decap_4
XANTENNA_50 _1639_ VGND VGND VPWR VPWR sky130_fd_sc_hd__diode_2
XANTENNA_72 net188 VGND VGND VPWR VPWR sky130_fd_sc_hd__diode_2
XANTENNA_61 net164 VGND VGND VPWR VPWR sky130_fd_sc_hd__diode_2
XANTENNA_83 net292 VGND VGND VPWR VPWR sky130_fd_sc_hd__diode_2
XANTENNA_94 net370 VGND VGND VPWR VPWR sky130_fd_sc_hd__diode_2
XFILLER_47_246 VPWR VGND VPWR VGND sky130_ef_sc_hd__decap_12
XFILLER_90_525 VGND VGND VPWR VPWR sky130_fd_sc_hd__decap_6
XTAP_TAPCELL_ROW_58_786 VGND VPWR sky130_fd_sc_hd__tapvpwrvgnd_1
XTAP_TAPCELL_ROW_83_1033 VGND VPWR sky130_fd_sc_hd__tapvpwrvgnd_1
XFILLER_15_121 VGND VGND VPWR VPWR sky130_fd_sc_hd__fill_2
XFILLER_70_282 VGND VGND VPWR VPWR sky130_fd_sc_hd__decap_6
XTAP_TAPCELL_ROW_13_333 VGND VPWR sky130_fd_sc_hd__tapvpwrvgnd_1
XFILLER_62_83 VGND VGND VPWR VPWR sky130_fd_sc_hd__fill_1
XFILLER_7_67 VPWR VGND VPWR VGND sky130_ef_sc_hd__decap_12
XTAP_TAPCELL_ROW_94_1140 VGND VPWR sky130_fd_sc_hd__tapvpwrvgnd_1
Xhold309 array\[4\]\[16\] VGND VGND VPWR VPWR net1075 sky130_fd_sc_hd__dlygate4sd3_1
XTAP_TAPCELL_ROW_94_1151 VGND VPWR sky130_fd_sc_hd__tapvpwrvgnd_1
X_3340_ net606 net482 net370 net680 VGND VGND VPWR VPWR _1408_ sky130_fd_sc_hd__a22o_1
X_3271_ net649 net372 VGND VGND VPWR VPWR _1360_ sky130_fd_sc_hd__and2_1
XFILLER_23_3 VPWR VGND VPWR VGND sky130_ef_sc_hd__decap_12
X_2222_ net113 net656 net766 net5 VGND VGND VPWR VPWR _0628_ sky130_fd_sc_hd__or4bb_1
XFILLER_78_393 VGND VGND VPWR VPWR sky130_fd_sc_hd__fill_1
XFILLER_66_533 VGND VGND VPWR VPWR sky130_fd_sc_hd__decap_3
XFILLER_81_547 VPWR VGND VPWR VGND sky130_ef_sc_hd__decap_12
XFILLER_34_474 VGND VGND VPWR VPWR sky130_fd_sc_hd__fill_2
XFILLER_21_113 VPWR VGND VPWR VGND sky130_ef_sc_hd__decap_12
XFILLER_21_179 VGND VGND VPWR VPWR sky130_fd_sc_hd__decap_3
X_2986_ net1245 _1163_ net165 VGND VGND VPWR VPWR _0106_ sky130_fd_sc_hd__mux2_1
X_4725_ clknet_leaf_20_clk _0256_ VGND VGND VPWR VPWR array\[11\]\[26\] sky130_fd_sc_hd__dfxtp_1
X_4656_ clknet_leaf_0_clk _0187_ VGND VGND VPWR VPWR array\[13\]\[21\] sky130_fd_sc_hd__dfxtp_1
X_4587_ clknet_leaf_26_clk _0118_ VGND VGND VPWR VPWR array\[15\]\[16\] sky130_fd_sc_hd__dfxtp_1
Xinput81 value2[19] VGND VGND VPWR VPWR net81 sky130_fd_sc_hd__buf_1
Xinput70 value1[9] VGND VGND VPWR VPWR net70 sky130_fd_sc_hd__buf_1
X_3607_ net211 _0607_ _0614_ _1298_ _1591_ VGND VGND VPWR VPWR _0299_ sky130_fd_sc_hd__o32a_1
Xinput92 value2[29] VGND VGND VPWR VPWR net92 sky130_fd_sc_hd__buf_1
X_3538_ net613 net474 net361 net685 net253 VGND VGND VPWR VPWR _1545_ sky130_fd_sc_hd__a221o_1
XFILLER_1_529 VPWR VGND VPWR VGND sky130_ef_sc_hd__decap_12
XFILLER_88_157 VGND VGND VPWR VPWR sky130_fd_sc_hd__decap_8
XFILLER_67_39 VGND VGND VPWR VPWR sky130_fd_sc_hd__fill_1
X_3469_ net1300 net260 _1495_ _1496_ VGND VGND VPWR VPWR _0256_ sky130_fd_sc_hd__o22a_1
XFILLER_69_371 VGND VGND VPWR VPWR sky130_fd_sc_hd__decap_6
XFILLER_69_393 VGND VGND VPWR VPWR sky130_fd_sc_hd__decap_4
XFILLER_83_27 VPWR VGND VPWR VGND sky130_ef_sc_hd__decap_12
XTAP_TAPCELL_ROW_55_756 VGND VPWR sky130_fd_sc_hd__tapvpwrvgnd_1
XFILLER_40_444 VGND VGND VPWR VPWR sky130_fd_sc_hd__decap_4
XFILLER_40_455 VGND VGND VPWR VPWR sky130_fd_sc_hd__fill_2
XFILLER_40_477 VGND VGND VPWR VPWR sky130_fd_sc_hd__decap_4
XTAP_TAPCELL_ROW_10_303 VGND VPWR sky130_fd_sc_hd__tapvpwrvgnd_1
XFILLER_8_139 VGND VGND VPWR VPWR sky130_fd_sc_hd__fill_1
XFILLER_32_53 VGND VGND VPWR VPWR sky130_fd_sc_hd__decap_8
XFILLER_79_113 VPWR VGND VPWR VGND sky130_ef_sc_hd__decap_12
XFILLER_4_389 VGND VGND VPWR VPWR sky130_fd_sc_hd__fill_2
X_2840_ net1290 net288 net282 net723 _1058_ VGND VGND VPWR VPWR _0065_ sky130_fd_sc_hd__a221o_1
XFILLER_31_444 VGND VGND VPWR VPWR sky130_fd_sc_hd__decap_4
X_2771_ net717 net281 VGND VGND VPWR VPWR _1015_ sky130_fd_sc_hd__and2_1
X_4510_ clknet_leaf_4_clk _0041_ VGND VGND VPWR VPWR array\[8\]\[3\] sky130_fd_sc_hd__dfxtp_1
Xhold117 array\[12\]\[27\] VGND VGND VPWR VPWR net883 sky130_fd_sc_hd__dlygate4sd3_1
X_4441_ clknet_leaf_24_clk _0552_ VGND VGND VPWR VPWR array\[3\]\[30\] sky130_fd_sc_hd__dfxtp_1
Xhold106 array\[10\]\[24\] VGND VGND VPWR VPWR net872 sky130_fd_sc_hd__dlygate4sd3_1
Xhold139 net122 VGND VGND VPWR VPWR net905 sky130_fd_sc_hd__dlygate4sd3_1
Xhold128 array\[3\]\[17\] VGND VGND VPWR VPWR net894 sky130_fd_sc_hd__dlygate4sd3_1
XPHY_EDGE_ROW_9_Right_9 VGND VGND VPWR VPWR sky130_fd_sc_hd__decap_3
X_4372_ clknet_leaf_41_clk _0483_ VGND VGND VPWR VPWR array\[1\]\[25\] sky130_fd_sc_hd__dfxtp_1
X_3323_ net765 net173 VGND VGND VPWR VPWR _1397_ sky130_fd_sc_hd__and2_1
Xfanout619 net74 VGND VGND VPWR VPWR net619 sky130_fd_sc_hd__buf_2
Xfanout608 net8 VGND VGND VPWR VPWR net608 sky130_fd_sc_hd__dlymetal6s2s_1
XFILLER_85_105 VGND VGND VPWR VPWR sky130_fd_sc_hd__decap_6
XPHY_EDGE_ROW_84_Left_179 VGND VGND VPWR VPWR sky130_fd_sc_hd__decap_3
X_3254_ net594 net488 net184 net732 _1348_ VGND VGND VPWR VPWR _1349_ sky130_fd_sc_hd__a221o_1
X_2205_ _0584_ _0585_ VGND VGND VPWR VPWR _0613_ sky130_fd_sc_hd__nor2_4
X_3185_ net629 net181 _1302_ VGND VGND VPWR VPWR _1303_ sky130_fd_sc_hd__a21o_1
XFILLER_54_514 VGND VGND VPWR VPWR sky130_fd_sc_hd__fill_1
XTAP_TAPCELL_ROW_52_726 VGND VPWR sky130_fd_sc_hd__tapvpwrvgnd_1
XPHY_EDGE_ROW_93_Left_188 VGND VGND VPWR VPWR sky130_fd_sc_hd__decap_3
X_2969_ net756 net757 _1150_ _1148_ _0780_ VGND VGND VPWR VPWR _1151_ sky130_fd_sc_hd__a32o_4
X_4708_ clknet_leaf_52_clk _0239_ VGND VGND VPWR VPWR array\[11\]\[9\] sky130_fd_sc_hd__dfxtp_1
X_4639_ clknet_leaf_43_clk _0170_ VGND VGND VPWR VPWR array\[13\]\[4\] sky130_fd_sc_hd__dfxtp_1
XFILLER_78_27 VGND VGND VPWR VPWR sky130_fd_sc_hd__fill_1
XFILLER_1_326 VGND VGND VPWR VPWR sky130_fd_sc_hd__decap_8
XFILLER_76_116 VGND VGND VPWR VPWR sky130_fd_sc_hd__fill_1
XFILLER_76_105 VGND VGND VPWR VPWR sky130_fd_sc_hd__decap_3
XFILLER_94_15 VPWR VGND VPWR VGND sky130_ef_sc_hd__decap_12
XFILLER_76_149 VGND VGND VPWR VPWR sky130_fd_sc_hd__fill_1
XTAP_TAPCELL_ROW_68_881 VGND VPWR sky130_fd_sc_hd__tapvpwrvgnd_1
XFILLER_27_42 VPWR VGND VPWR VGND sky130_ef_sc_hd__decap_12
XFILLER_57_385 VGND VGND VPWR VPWR sky130_fd_sc_hd__fill_1
XTAP_TAPCELL_ROW_80_1003 VGND VPWR sky130_fd_sc_hd__tapvpwrvgnd_1
XFILLER_13_411 VGND VGND VPWR VPWR sky130_fd_sc_hd__fill_1
XFILLER_13_444 VGND VGND VPWR VPWR sky130_fd_sc_hd__decap_4
XFILLER_40_241 VGND VGND VPWR VPWR sky130_fd_sc_hd__fill_2
XFILLER_40_296 VPWR VGND VPWR VGND sky130_ef_sc_hd__decap_12
XTAP_TAPCELL_ROW_91_1110 VGND VPWR sky130_fd_sc_hd__tapvpwrvgnd_1
XFILLER_4_153 VGND VGND VPWR VPWR sky130_fd_sc_hd__decap_3
XFILLER_4_68 VGND VGND VPWR VPWR sky130_fd_sc_hd__fill_1
XFILLER_68_93 VGND VGND VPWR VPWR sky130_fd_sc_hd__decap_3
XFILLER_0_370 VPWR VGND VPWR VGND sky130_ef_sc_hd__decap_12
XFILLER_48_385 VGND VGND VPWR VPWR sky130_fd_sc_hd__decap_8
XFILLER_90_141 VGND VGND VPWR VPWR sky130_fd_sc_hd__decap_4
XTAP_TAPCELL_ROW_89_1094 VGND VPWR sky130_fd_sc_hd__tapvpwrvgnd_1
X_3941_ array\[10\]\[15\] net468 net451 array\[8\]\[15\] VGND VGND VPWR VPWR _1865_
+ sky130_fd_sc_hd__a22o_1
XFILLER_90_3 VPWR VGND VPWR VGND sky130_ef_sc_hd__decap_12
X_3872_ array\[6\]\[9\] net465 net448 array\[4\]\[9\] VGND VGND VPWR VPWR _1802_ sky130_fd_sc_hd__a22o_1
X_2823_ net598 net504 net276 net672 VGND VGND VPWR VPWR _1048_ sky130_fd_sc_hd__a22o_1
X_2754_ net1040 _1000_ net295 VGND VGND VPWR VPWR _0037_ sky130_fd_sc_hd__mux2_1
X_2685_ net901 _0954_ net296 VGND VGND VPWR VPWR _0014_ sky130_fd_sc_hd__mux2_1
X_4424_ clknet_leaf_10_clk _0535_ VGND VGND VPWR VPWR array\[3\]\[13\] sky130_fd_sc_hd__dfxtp_1
X_4355_ clknet_leaf_27_clk _0466_ VGND VGND VPWR VPWR array\[1\]\[8\] sky130_fd_sc_hd__dfxtp_1
Xfanout405 _0783_ VGND VGND VPWR VPWR net405 sky130_fd_sc_hd__clkbuf_2
Xfanout438 _1606_ VGND VGND VPWR VPWR net438 sky130_fd_sc_hd__buf_2
Xfanout416 _0613_ VGND VGND VPWR VPWR net416 sky130_fd_sc_hd__buf_2
Xfanout427 net428 VGND VGND VPWR VPWR net427 sky130_fd_sc_hd__clkbuf_4
X_3306_ net565 net481 net367 net635 net177 VGND VGND VPWR VPWR _1386_ sky130_fd_sc_hd__a221o_1
Xfanout449 net450 VGND VGND VPWR VPWR net449 sky130_fd_sc_hd__clkbuf_4
X_4286_ net752 net335 VGND VGND VPWR VPWR _2140_ sky130_fd_sc_hd__and2_1
X_3237_ net780 _1337_ net159 VGND VGND VPWR VPWR _0183_ sky130_fd_sc_hd__mux2_1
X_3168_ net1011 net162 _1288_ VGND VGND VPWR VPWR _0163_ sky130_fd_sc_hd__o21a_1
XTAP_TAPCELL_ROW_65_851 VGND VPWR sky130_fd_sc_hd__tapvpwrvgnd_1
XFILLER_64_29 VGND VGND VPWR VPWR sky130_fd_sc_hd__decap_4
XFILLER_27_558 VGND VGND VPWR VPWR sky130_fd_sc_hd__fill_2
XTAP_TAPCELL_ROW_37_575 VGND VPWR sky130_fd_sc_hd__tapvpwrvgnd_1
X_3099_ net952 net161 _1242_ VGND VGND VPWR VPWR _0140_ sky130_fd_sc_hd__o21a_1
XFILLER_13_55 VGND VGND VPWR VPWR sky130_fd_sc_hd__fill_1
XFILLER_10_469 VGND VGND VPWR VPWR sky130_fd_sc_hd__decap_6
XFILLER_89_15 VPWR VGND VPWR VGND sky130_ef_sc_hd__decap_12
Xhold481 array\[7\]\[13\] VGND VGND VPWR VPWR net1247 sky130_fd_sc_hd__dlygate4sd3_1
Xhold470 array\[0\]\[6\] VGND VGND VPWR VPWR net1236 sky130_fd_sc_hd__dlygate4sd3_1
Xhold492 array\[4\]\[23\] VGND VGND VPWR VPWR net1258 sky130_fd_sc_hd__dlygate4sd3_1
XFILLER_77_447 VGND VGND VPWR VPWR sky130_fd_sc_hd__fill_1
XFILLER_38_85 VGND VGND VPWR VPWR sky130_fd_sc_hd__decap_4
XFILLER_72_141 VGND VGND VPWR VPWR sky130_fd_sc_hd__fill_1
XFILLER_45_366 VGND VGND VPWR VPWR sky130_fd_sc_hd__fill_2
XFILLER_41_561 VGND VGND VPWR VPWR sky130_fd_sc_hd__fill_1
XFILLER_60_358 VGND VGND VPWR VPWR sky130_fd_sc_hd__decap_6
XFILLER_70_61 VGND VGND VPWR VPWR sky130_fd_sc_hd__fill_2
XFILLER_70_83 VGND VGND VPWR VPWR sky130_fd_sc_hd__fill_1
Xclkload26 clknet_leaf_45_clk VGND VGND VPWR VPWR clkload26/Y sky130_fd_sc_hd__clkinvlp_4
Xclkload15 clknet_leaf_1_clk VGND VGND VPWR VPWR clkload15/Y sky130_fd_sc_hd__inv_8
Xclkload37 clknet_leaf_13_clk VGND VGND VPWR VPWR clkload37/X sky130_fd_sc_hd__clkbuf_8
Xclkload48 clknet_leaf_37_clk VGND VGND VPWR VPWR clkload48/Y sky130_fd_sc_hd__clkinvlp_4
XFILLER_5_473 VPWR VGND VPWR VGND sky130_ef_sc_hd__decap_12
X_2470_ net703 net305 _0804_ net403 net309 VGND VGND VPWR VPWR _0805_ sky130_fd_sc_hd__a221o_1
XFILLER_55_6 VPWR VGND VPWR VGND sky130_ef_sc_hd__decap_12
X_4140_ _2040_ _2041_ _2042_ _2035_ VGND VGND VPWR VPWR _0385_ sky130_fd_sc_hd__o211ai_1
X_4071_ array\[1\]\[27\] net557 net541 array\[3\]\[27\] _1982_ VGND VGND VPWR VPWR
+ _1983_ sky130_fd_sc_hd__a221o_1
X_3022_ net920 _1187_ net168 VGND VGND VPWR VPWR _0118_ sky130_fd_sc_hd__mux2_1
XTAP_TAPCELL_ROW_79_998 VGND VPWR sky130_fd_sc_hd__tapvpwrvgnd_1
XFILLER_63_141 VGND VGND VPWR VPWR sky130_fd_sc_hd__fill_2
XTAP_TAPCELL_ROW_62_821 VGND VPWR sky130_fd_sc_hd__tapvpwrvgnd_1
XTAP_TAPCELL_ROW_34_545 VGND VPWR sky130_fd_sc_hd__tapvpwrvgnd_1
X_3924_ array\[2\]\[14\] net458 net441 array\[0\]\[14\] VGND VGND VPWR VPWR _1849_
+ sky130_fd_sc_hd__a22o_1
Xclkload9 clknet_leaf_60_clk VGND VGND VPWR VPWR clkload9/X sky130_fd_sc_hd__clkbuf_8
X_3855_ net973 net169 _1786_ VGND VGND VPWR VPWR _0352_ sky130_fd_sc_hd__o21a_1
X_3786_ net215 _1722_ _1723_ VGND VGND VPWR VPWR _1724_ sky130_fd_sc_hd__or3_2
X_2806_ net980 net283 _1036_ _1037_ VGND VGND VPWR VPWR _0052_ sky130_fd_sc_hd__o22a_1
X_2737_ net661 net587 net392 VGND VGND VPWR VPWR _0989_ sky130_fd_sc_hd__mux2_1
X_2668_ net641 net571 net391 VGND VGND VPWR VPWR _0943_ sky130_fd_sc_hd__mux2_1
X_4407_ clknet_leaf_54_clk _0518_ VGND VGND VPWR VPWR array\[2\]\[28\] sky130_fd_sc_hd__dfxtp_1
XFILLER_59_18 VPWR VGND VPWR VGND sky130_ef_sc_hd__decap_12
X_2599_ net1049 net298 _0894_ _0895_ VGND VGND VPWR VPWR _0567_ sky130_fd_sc_hd__o22a_1
Xfanout213 net214 VGND VGND VPWR VPWR net213 sky130_fd_sc_hd__buf_2
Xfanout202 _1073_ VGND VGND VPWR VPWR net202 sky130_fd_sc_hd__buf_2
Xfanout224 _2111_ VGND VGND VPWR VPWR net224 sky130_fd_sc_hd__clkbuf_2
X_4338_ net561 net217 _0603_ VGND VGND VPWR VPWR _0377_ sky130_fd_sc_hd__o21a_1
Xfanout235 _2045_ VGND VGND VPWR VPWR net235 sky130_fd_sc_hd__clkbuf_4
Xfanout246 net247 VGND VGND VPWR VPWR net246 sky130_fd_sc_hd__clkbuf_4
X_4269_ net701 net338 VGND VGND VPWR VPWR _2129_ sky130_fd_sc_hd__and2_1
Xfanout279 net282 VGND VGND VPWR VPWR net279 sky130_fd_sc_hd__clkbuf_4
Xfanout257 _1441_ VGND VGND VPWR VPWR net257 sky130_fd_sc_hd__buf_4
Xfanout268 _1072_ VGND VGND VPWR VPWR net268 sky130_fd_sc_hd__buf_4
XFILLER_54_163 VGND VGND VPWR VPWR sky130_fd_sc_hd__fill_1
XFILLER_91_27 VPWR VGND VPWR VGND sky130_ef_sc_hd__decap_12
XFILLER_42_358 VGND VGND VPWR VPWR sky130_fd_sc_hd__decap_6
XFILLER_23_561 VGND VGND VPWR VPWR sky130_fd_sc_hd__fill_1
XFILLER_10_211 VGND VGND VPWR VPWR sky130_fd_sc_hd__fill_2
XFILLER_40_20 VGND VGND VPWR VPWR sky130_fd_sc_hd__fill_1
XFILLER_77_222 VGND VGND VPWR VPWR sky130_fd_sc_hd__fill_2
XTAP_TAPCELL_ROW_76_968 VGND VPWR sky130_fd_sc_hd__tapvpwrvgnd_1
XFILLER_58_491 VGND VGND VPWR VPWR sky130_fd_sc_hd__fill_1
XTAP_TAPCELL_ROW_86_1064 VGND VPWR sky130_fd_sc_hd__tapvpwrvgnd_1
XFILLER_73_494 VGND VGND VPWR VPWR sky130_fd_sc_hd__decap_8
XFILLER_18_399 VGND VGND VPWR VPWR sky130_fd_sc_hd__fill_2
XANTENNA_151 net435 VGND VGND VPWR VPWR sky130_fd_sc_hd__diode_2
XANTENNA_140 net282 VGND VGND VPWR VPWR sky130_fd_sc_hd__diode_2
XANTENNA_173 net164 VGND VGND VPWR VPWR sky130_fd_sc_hd__diode_2
XANTENNA_162 net542 VGND VGND VPWR VPWR sky130_fd_sc_hd__diode_2
XTAP_TAPCELL_ROW_31_515 VGND VPWR sky130_fd_sc_hd__tapvpwrvgnd_1
X_3640_ net103 net104 net105 _0636_ VGND VGND VPWR VPWR _1618_ sky130_fd_sc_hd__and4b_1
X_3571_ net725 net246 _1566_ net253 VGND VGND VPWR VPWR _1567_ sky130_fd_sc_hd__a211o_1
XFILLER_53_3 VPWR VGND VPWR VGND sky130_ef_sc_hd__decap_12
X_2522_ net989 net205 _0839_ VGND VGND VPWR VPWR _0546_ sky130_fd_sc_hd__o21a_1
XFILLER_5_281 VGND VGND VPWR VPWR sky130_fd_sc_hd__decap_4
X_2453_ net943 net203 _0793_ VGND VGND VPWR VPWR _0523_ sky130_fd_sc_hd__o21a_1
XFILLER_68_211 VPWR VGND VPWR VGND sky130_ef_sc_hd__decap_12
X_2384_ net615 net687 net517 VGND VGND VPWR VPWR _0744_ sky130_fd_sc_hd__mux2_1
X_4123_ array\[13\]\[31\] net552 net530 array\[15\]\[31\] _2030_ VGND VGND VPWR VPWR
+ _2031_ sky130_fd_sc_hd__a221o_1
Xinput2 control[1] VGND VGND VPWR VPWR net2 sky130_fd_sc_hd__buf_1
X_4054_ array\[2\]\[25\] net466 net449 array\[0\]\[25\] VGND VGND VPWR VPWR _1968_
+ sky130_fd_sc_hd__a22o_1
XFILLER_56_439 VGND VGND VPWR VPWR sky130_fd_sc_hd__decap_8
X_3005_ net694 net622 net495 VGND VGND VPWR VPWR _1176_ sky130_fd_sc_hd__mux2_1
XFILLER_36_141 VGND VGND VPWR VPWR sky130_fd_sc_hd__decap_4
XTAP_TAPCELL_ROW_47_670 VGND VPWR sky130_fd_sc_hd__tapvpwrvgnd_1
XTAP_TAPCELL_ROW_19_394 VGND VPWR sky130_fd_sc_hd__tapvpwrvgnd_1
XFILLER_51_155 VPWR VGND VPWR VGND sky130_ef_sc_hd__decap_12
XFILLER_20_531 VGND VGND VPWR VPWR sky130_fd_sc_hd__fill_1
X_4887_ clknet_leaf_20_clk _0418_ VGND VGND VPWR VPWR array\[7\]\[30\] sky130_fd_sc_hd__dfxtp_1
X_3907_ array\[9\]\[12\] net548 net535 array\[11\]\[12\] _1833_ VGND VGND VPWR VPWR
+ _1834_ sky130_fd_sc_hd__a221o_1
X_3838_ array\[1\]\[6\] net546 net534 array\[3\]\[6\] _1770_ VGND VGND VPWR VPWR _1771_
+ sky130_fd_sc_hd__a221o_1
X_3769_ array\[6\]\[0\] net457 net440 array\[4\]\[0\] VGND VGND VPWR VPWR _1708_ sky130_fd_sc_hd__a22o_1
XFILLER_86_27 VGND VGND VPWR VPWR sky130_fd_sc_hd__fill_1
XFILLER_87_553 VGND VGND VPWR VPWR sky130_fd_sc_hd__decap_6
XFILLER_19_43 VGND VGND VPWR VPWR sky130_fd_sc_hd__fill_2
XFILLER_59_277 VGND VGND VPWR VPWR sky130_fd_sc_hd__decap_3
XFILLER_27_141 VGND VGND VPWR VPWR sky130_fd_sc_hd__fill_1
XTAP_TAPCELL_ROW_73_938 VGND VPWR sky130_fd_sc_hd__tapvpwrvgnd_1
XFILLER_27_185 VGND VGND VPWR VPWR sky130_fd_sc_hd__decap_4
XFILLER_70_431 VGND VGND VPWR VPWR sky130_fd_sc_hd__fill_1
XFILLER_30_306 VGND VGND VPWR VPWR sky130_fd_sc_hd__fill_2
XFILLER_11_553 VGND VGND VPWR VPWR sky130_fd_sc_hd__decap_6
XFILLER_65_236 VGND VGND VPWR VPWR sky130_fd_sc_hd__decap_4
XFILLER_33_111 VGND VGND VPWR VPWR sky130_fd_sc_hd__fill_1
X_4810_ clknet_leaf_52_clk _0341_ VGND VGND VPWR VPWR array\[9\]\[28\] sky130_fd_sc_hd__dfxtp_1
XTAP_TAPCELL_ROW_44_640 VGND VPWR sky130_fd_sc_hd__tapvpwrvgnd_1
XTAP_TAPCELL_ROW_16_364 VGND VPWR sky130_fd_sc_hd__tapvpwrvgnd_1
XFILLER_61_475 VGND VGND VPWR VPWR sky130_fd_sc_hd__fill_2
X_4741_ clknet_leaf_49_clk _0272_ VGND VGND VPWR VPWR array\[10\]\[10\] sky130_fd_sc_hd__dfxtp_1
XFILLER_33_199 VGND VGND VPWR VPWR sky130_fd_sc_hd__fill_2
X_4672_ clknet_leaf_28_clk _0203_ VGND VGND VPWR VPWR array\[12\]\[5\] sky130_fd_sc_hd__dfxtp_1
X_3623_ _1142_ _1143_ VGND VGND VPWR VPWR _1604_ sky130_fd_sc_hd__nor2_1
X_3554_ net1027 net250 _1555_ VGND VGND VPWR VPWR _0282_ sky130_fd_sc_hd__o21a_1
X_2505_ net677 net603 net513 VGND VGND VPWR VPWR _0828_ sky130_fd_sc_hd__mux2_1
X_3485_ net753 _0627_ _0707_ VGND VGND VPWR VPWR _1507_ sky130_fd_sc_hd__and3_1
X_2436_ net713 net316 _0778_ net408 net314 VGND VGND VPWR VPWR _0779_ sky130_fd_sc_hd__a221o_1
XFILLER_69_542 VGND VGND VPWR VPWR sky130_fd_sc_hd__decap_4
X_2367_ net701 net317 _0732_ net409 net314 VGND VGND VPWR VPWR _0733_ sky130_fd_sc_hd__a221o_1
XFILLER_84_545 VPWR VGND VPWR VGND sky130_ef_sc_hd__decap_12
X_4106_ array\[1\]\[30\] net555 net540 array\[3\]\[30\] _2014_ VGND VGND VPWR VPWR
+ _2015_ sky130_fd_sc_hd__a221o_1
X_2298_ net737 net321 _0683_ net412 net329 VGND VGND VPWR VPWR _0684_ sky130_fd_sc_hd__a221o_1
X_4037_ array\[14\]\[24\] net470 net453 array\[12\]\[24\] VGND VGND VPWR VPWR _1952_
+ sky130_fd_sc_hd__a22o_1
XFILLER_72_29 VGND VGND VPWR VPWR sky130_fd_sc_hd__decap_3
XTAP_TAPCELL_ROW_70_908 VGND VPWR sky130_fd_sc_hd__tapvpwrvgnd_1
XFILLER_52_475 VGND VGND VPWR VPWR sky130_fd_sc_hd__fill_1
XANTENNA_40 _1606_ VGND VGND VPWR VPWR sky130_fd_sc_hd__diode_2
XFILLER_20_372 VPWR VGND VPWR VGND sky130_ef_sc_hd__decap_12
XANTENNA_84 net292 VGND VGND VPWR VPWR sky130_fd_sc_hd__diode_2
XANTENNA_62 net164 VGND VGND VPWR VPWR sky130_fd_sc_hd__diode_2
XANTENNA_73 net188 VGND VGND VPWR VPWR sky130_fd_sc_hd__diode_2
XANTENNA_51 _1639_ VGND VGND VPWR VPWR sky130_fd_sc_hd__diode_2
XANTENNA_95 net373 VGND VGND VPWR VPWR sky130_fd_sc_hd__diode_2
XFILLER_47_225 VGND VGND VPWR VPWR sky130_fd_sc_hd__fill_1
XFILLER_47_258 VPWR VGND VPWR VGND sky130_ef_sc_hd__decap_12
XFILLER_46_85 VGND VGND VPWR VPWR sky130_fd_sc_hd__decap_3
XTAP_TAPCELL_ROW_58_787 VGND VPWR sky130_fd_sc_hd__tapvpwrvgnd_1
XTAP_TAPCELL_ROW_83_1034 VGND VPWR sky130_fd_sc_hd__tapvpwrvgnd_1
XTAP_TAPCELL_ROW_41_610 VGND VPWR sky130_fd_sc_hd__tapvpwrvgnd_1
XTAP_TAPCELL_ROW_13_334 VGND VPWR sky130_fd_sc_hd__tapvpwrvgnd_1
XFILLER_11_372 VGND VGND VPWR VPWR sky130_fd_sc_hd__decap_4
XFILLER_7_79 VGND VGND VPWR VPWR sky130_fd_sc_hd__decap_4
XFILLER_7_57 VGND VGND VPWR VPWR sky130_fd_sc_hd__decap_3
XTAP_TAPCELL_ROW_94_1152 VGND VPWR sky130_fd_sc_hd__tapvpwrvgnd_1
XTAP_TAPCELL_ROW_94_1141 VGND VPWR sky130_fd_sc_hd__tapvpwrvgnd_1
X_3270_ net787 _1359_ net158 VGND VGND VPWR VPWR _0194_ sky130_fd_sc_hd__mux2_1
X_2221_ net113 net653 net766 net5 VGND VGND VPWR VPWR _0627_ sky130_fd_sc_hd__and4bb_1
XFILLER_87_81 VPWR VGND VPWR VGND sky130_ef_sc_hd__decap_12
XFILLER_78_350 VGND VGND VPWR VPWR sky130_fd_sc_hd__fill_2
XFILLER_66_512 VGND VGND VPWR VPWR sky130_fd_sc_hd__fill_2
XFILLER_16_3 VGND VGND VPWR VPWR sky130_fd_sc_hd__decap_8
XFILLER_81_559 VGND VGND VPWR VPWR sky130_fd_sc_hd__fill_1
XFILLER_61_261 VPWR VGND VPWR VGND sky130_ef_sc_hd__decap_12
XFILLER_21_125 VGND VGND VPWR VPWR sky130_fd_sc_hd__decap_6
XFILLER_21_147 VGND VGND VPWR VPWR sky130_fd_sc_hd__decap_4
X_4724_ clknet_leaf_41_clk _0255_ VGND VGND VPWR VPWR array\[11\]\[25\] sky130_fd_sc_hd__dfxtp_1
X_2985_ net710 net193 _1162_ net380 VGND VGND VPWR VPWR _1163_ sky130_fd_sc_hd__a22o_1
X_4655_ clknet_leaf_9_clk _0186_ VGND VGND VPWR VPWR array\[13\]\[20\] sky130_fd_sc_hd__dfxtp_1
Xinput71 value2[0] VGND VGND VPWR VPWR net71 sky130_fd_sc_hd__buf_1
Xinput82 value2[1] VGND VGND VPWR VPWR net82 sky130_fd_sc_hd__clkbuf_1
Xinput60 value1[29] VGND VGND VPWR VPWR net60 sky130_fd_sc_hd__buf_1
X_3606_ net563 ready_check\[13\] _1294_ _1295_ VGND VGND VPWR VPWR _1591_ sky130_fd_sc_hd__a31o_1
X_4586_ clknet_leaf_33_clk _0117_ VGND VGND VPWR VPWR array\[15\]\[15\] sky130_fd_sc_hd__dfxtp_1
Xinput93 value2[2] VGND VGND VPWR VPWR net93 sky130_fd_sc_hd__clkbuf_1
X_3537_ net749 net247 VGND VGND VPWR VPWR _1544_ sky130_fd_sc_hd__and2_1
X_3468_ net587 net478 net364 net661 net264 VGND VGND VPWR VPWR _1496_ sky130_fd_sc_hd__a221o_1
XFILLER_76_309 VGND VGND VPWR VPWR sky130_fd_sc_hd__decap_3
X_2419_ net1270 net209 _0767_ VGND VGND VPWR VPWR _0515_ sky130_fd_sc_hd__o21a_1
X_3399_ net572 net478 net363 net642 net263 VGND VGND VPWR VPWR _1450_ sky130_fd_sc_hd__a221o_1
XFILLER_29_225 VGND VGND VPWR VPWR sky130_fd_sc_hd__decap_4
XFILLER_83_39 VPWR VGND VPWR VGND sky130_ef_sc_hd__decap_12
XFILLER_16_11 VGND VGND VPWR VPWR sky130_fd_sc_hd__fill_1
XFILLER_25_442 VGND VGND VPWR VPWR sky130_fd_sc_hd__decap_6
XTAP_TAPCELL_ROW_55_757 VGND VPWR sky130_fd_sc_hd__tapvpwrvgnd_1
XTAP_TAPCELL_ROW_10_304 VGND VPWR sky130_fd_sc_hd__tapvpwrvgnd_1
XFILLER_79_125 VGND VGND VPWR VPWR sky130_fd_sc_hd__fill_1
XFILLER_79_169 VGND VGND VPWR VPWR sky130_fd_sc_hd__decap_4
XFILLER_48_501 VGND VGND VPWR VPWR sky130_fd_sc_hd__fill_2
XFILLER_31_412 VGND VGND VPWR VPWR sky130_fd_sc_hd__fill_1
X_2770_ net1259 net284 _1013_ _1014_ VGND VGND VPWR VPWR _0039_ sky130_fd_sc_hd__o22a_1
X_4440_ clknet_leaf_54_clk _0551_ VGND VGND VPWR VPWR array\[3\]\[29\] sky130_fd_sc_hd__dfxtp_1
Xhold107 array\[4\]\[24\] VGND VGND VPWR VPWR net873 sky130_fd_sc_hd__dlygate4sd3_1
Xhold129 array\[13\]\[12\] VGND VGND VPWR VPWR net895 sky130_fd_sc_hd__dlygate4sd3_1
Xhold118 array\[0\]\[8\] VGND VGND VPWR VPWR net884 sky130_fd_sc_hd__dlygate4sd3_1
X_4371_ clknet_leaf_36_clk _0482_ VGND VGND VPWR VPWR array\[1\]\[24\] sky130_fd_sc_hd__dfxtp_1
X_3322_ net1007 net153 _1395_ _1396_ VGND VGND VPWR VPWR _0209_ sky130_fd_sc_hd__o22a_1
Xfanout609 net79 VGND VGND VPWR VPWR net609 sky130_fd_sc_hd__buf_2
X_3253_ net668 net374 VGND VGND VPWR VPWR _1348_ sky130_fd_sc_hd__and2_1
XFILLER_58_309 VGND VGND VPWR VPWR sky130_fd_sc_hd__fill_2
X_2204_ net559 net560 net561 head\[3\] VGND VGND VPWR VPWR _0612_ sky130_fd_sc_hd__a31o_1
X_3184_ net625 net485 net371 net697 VGND VGND VPWR VPWR _1302_ sky130_fd_sc_hd__a22o_1
XFILLER_26_217 VGND VGND VPWR VPWR sky130_fd_sc_hd__decap_4
XFILLER_34_283 VGND VGND VPWR VPWR sky130_fd_sc_hd__decap_3
XFILLER_34_294 VGND VGND VPWR VPWR sky130_fd_sc_hd__decap_6
XTAP_TAPCELL_ROW_52_727 VGND VPWR sky130_fd_sc_hd__tapvpwrvgnd_1
X_2968_ net110 _0859_ VGND VGND VPWR VPWR _1150_ sky130_fd_sc_hd__and2_2
X_4707_ clknet_leaf_32_clk _0238_ VGND VGND VPWR VPWR array\[11\]\[8\] sky130_fd_sc_hd__dfxtp_1
X_2899_ net754 net274 _1099_ net384 net268 VGND VGND VPWR VPWR _1100_ sky130_fd_sc_hd__a221o_1
X_4638_ clknet_leaf_9_clk _0169_ VGND VGND VPWR VPWR array\[13\]\[3\] sky130_fd_sc_hd__dfxtp_1
X_4569_ clknet_leaf_23_clk _0100_ VGND VGND VPWR VPWR array\[0\]\[30\] sky130_fd_sc_hd__dfxtp_1
XFILLER_94_27 VGND VGND VPWR VPWR sky130_fd_sc_hd__fill_1
XTAP_TAPCELL_ROW_68_882 VGND VPWR sky130_fd_sc_hd__tapvpwrvgnd_1
XFILLER_27_54 VGND VGND VPWR VPWR sky130_fd_sc_hd__fill_2
XFILLER_72_345 VGND VGND VPWR VPWR sky130_fd_sc_hd__fill_1
XFILLER_27_65 VGND VGND VPWR VPWR sky130_fd_sc_hd__decap_3
XTAP_TAPCELL_ROW_80_1004 VGND VPWR sky130_fd_sc_hd__tapvpwrvgnd_1
XFILLER_25_272 VGND VGND VPWR VPWR sky130_fd_sc_hd__fill_1
XFILLER_40_220 VGND VGND VPWR VPWR sky130_fd_sc_hd__decap_4
XFILLER_40_253 VGND VGND VPWR VPWR sky130_fd_sc_hd__decap_4
XFILLER_9_449 VPWR VGND VPWR VGND sky130_ef_sc_hd__decap_12
XTAP_TAPCELL_ROW_91_1111 VGND VPWR sky130_fd_sc_hd__tapvpwrvgnd_1
XFILLER_4_165 VGND VGND VPWR VPWR sky130_fd_sc_hd__decap_4
XFILLER_0_382 VGND VGND VPWR VPWR sky130_fd_sc_hd__decap_6
XFILLER_0_393 VGND VGND VPWR VPWR sky130_fd_sc_hd__fill_2
XFILLER_82_109 VPWR VGND VPWR VGND sky130_ef_sc_hd__decap_12
XTAP_TAPCELL_ROW_89_1095 VGND VPWR sky130_fd_sc_hd__tapvpwrvgnd_1
X_3940_ array\[1\]\[15\] net554 net538 array\[3\]\[15\] _1863_ VGND VGND VPWR VPWR
+ _1864_ sky130_fd_sc_hd__a221o_1
X_3871_ array\[9\]\[9\] net551 net529 array\[11\]\[9\] _1800_ VGND VGND VPWR VPWR
+ _1801_ sky130_fd_sc_hd__a221o_1
XFILLER_31_220 VGND VGND VPWR VPWR sky130_fd_sc_hd__decap_4
XFILLER_83_3 VPWR VGND VPWR VGND sky130_ef_sc_hd__decap_12
X_2822_ net1303 net286 net280 net738 _1047_ VGND VGND VPWR VPWR _0058_ sky130_fd_sc_hd__a221o_1
X_2753_ net714 net291 _0999_ net389 VGND VGND VPWR VPWR _1000_ sky130_fd_sc_hd__a22o_1
X_2684_ net702 net291 _0953_ net390 VGND VGND VPWR VPWR _0954_ sky130_fd_sc_hd__a22o_1
X_4423_ clknet_leaf_16_clk _0534_ VGND VGND VPWR VPWR array\[3\]\[12\] sky130_fd_sc_hd__dfxtp_1
X_4354_ clknet_leaf_57_clk _0465_ VGND VGND VPWR VPWR array\[1\]\[7\] sky130_fd_sc_hd__dfxtp_1
Xfanout417 _0613_ VGND VGND VPWR VPWR net417 sky130_fd_sc_hd__buf_4
Xfanout439 net441 VGND VGND VPWR VPWR net439 sky130_fd_sc_hd__clkbuf_4
Xfanout406 _0710_ VGND VGND VPWR VPWR net406 sky130_fd_sc_hd__clkbuf_4
Xfanout428 _1619_ VGND VGND VPWR VPWR net428 sky130_fd_sc_hd__buf_4
X_3305_ net705 net173 VGND VGND VPWR VPWR _1385_ sky130_fd_sc_hd__and2_1
X_4285_ net1168 net219 _2138_ _2139_ VGND VGND VPWR VPWR _0433_ sky130_fd_sc_hd__o22a_1
X_3236_ net610 net487 net183 net746 _1336_ VGND VGND VPWR VPWR _1337_ sky130_fd_sc_hd__a221o_1
X_3167_ net719 net186 _1287_ net190 VGND VGND VPWR VPWR _1288_ sky130_fd_sc_hd__a211o_1
XFILLER_39_364 VGND VGND VPWR VPWR sky130_fd_sc_hd__decap_6
XFILLER_66_194 VGND VGND VPWR VPWR sky130_fd_sc_hd__fill_2
X_3098_ net705 net185 _1241_ net189 VGND VGND VPWR VPWR _1242_ sky130_fd_sc_hd__a211o_1
XFILLER_54_334 VGND VGND VPWR VPWR sky130_fd_sc_hd__decap_4
XFILLER_81_164 VGND VGND VPWR VPWR sky130_fd_sc_hd__decap_4
XTAP_TAPCELL_ROW_65_852 VGND VPWR sky130_fd_sc_hd__tapvpwrvgnd_1
XTAP_TAPCELL_ROW_37_576 VGND VPWR sky130_fd_sc_hd__tapvpwrvgnd_1
XFILLER_80_29 VPWR VGND VPWR VGND sky130_ef_sc_hd__decap_12
XFILLER_80_18 VGND VGND VPWR VPWR sky130_fd_sc_hd__decap_8
XFILLER_13_78 VGND VGND VPWR VPWR sky130_fd_sc_hd__decap_8
XFILLER_6_419 VGND VGND VPWR VPWR sky130_fd_sc_hd__fill_1
XFILLER_89_27 VPWR VGND VPWR VGND sky130_ef_sc_hd__decap_12
Xhold460 array\[8\]\[8\] VGND VGND VPWR VPWR net1226 sky130_fd_sc_hd__dlygate4sd3_1
Xhold471 array\[14\]\[22\] VGND VGND VPWR VPWR net1237 sky130_fd_sc_hd__dlygate4sd3_1
XFILLER_1_113 VGND VGND VPWR VPWR sky130_fd_sc_hd__decap_6
Xhold493 array\[8\]\[1\] VGND VGND VPWR VPWR net1259 sky130_fd_sc_hd__dlygate4sd3_1
Xhold482 array\[4\]\[20\] VGND VGND VPWR VPWR net1248 sky130_fd_sc_hd__dlygate4sd3_1
XFILLER_64_109 VGND VGND VPWR VPWR sky130_fd_sc_hd__decap_4
XTAP_TAPCELL_ROW_0_190 VGND VPWR sky130_fd_sc_hd__tapvpwrvgnd_1
XFILLER_54_96 VGND VGND VPWR VPWR sky130_fd_sc_hd__fill_1
Xclkload16 clknet_leaf_55_clk VGND VGND VPWR VPWR clkload16/Y sky130_fd_sc_hd__clkinv_4
Xclkload38 clknet_leaf_14_clk VGND VGND VPWR VPWR clkload38/Y sky130_fd_sc_hd__clkinv_2
Xclkload49 clknet_leaf_22_clk VGND VGND VPWR VPWR clkload49/Y sky130_fd_sc_hd__bufinv_16
Xclkload27 clknet_leaf_53_clk VGND VGND VPWR VPWR clkload27/Y sky130_fd_sc_hd__inv_6
XFILLER_5_485 VPWR VGND VPWR VGND sky130_ef_sc_hd__decap_12
X_4070_ array\[2\]\[27\] net471 net454 array\[0\]\[27\] VGND VGND VPWR VPWR _1982_
+ sky130_fd_sc_hd__a22o_1
X_3021_ net748 net196 _1186_ net381 VGND VGND VPWR VPWR _1187_ sky130_fd_sc_hd__a22o_1
XTAP_TAPCELL_ROW_79_999 VGND VPWR sky130_fd_sc_hd__tapvpwrvgnd_1
XFILLER_55_109 VGND VGND VPWR VPWR sky130_fd_sc_hd__decap_3
XFILLER_51_304 VGND VGND VPWR VPWR sky130_fd_sc_hd__decap_4
XFILLER_63_131 VGND VGND VPWR VPWR sky130_fd_sc_hd__decap_4
XTAP_TAPCELL_ROW_62_822 VGND VPWR sky130_fd_sc_hd__tapvpwrvgnd_1
X_3923_ net797 net170 _1847_ _1848_ VGND VGND VPWR VPWR _0358_ sky130_fd_sc_hd__o22a_1
XTAP_TAPCELL_ROW_34_546 VGND VPWR sky130_fd_sc_hd__tapvpwrvgnd_1
X_3854_ net213 _1784_ _1785_ VGND VGND VPWR VPWR _1786_ sky130_fd_sc_hd__or3_1
X_2805_ net616 net504 net276 net688 net286 VGND VGND VPWR VPWR _1037_ sky130_fd_sc_hd__a221o_1
X_3785_ net415 _1717_ _1721_ net355 VGND VGND VPWR VPWR _1723_ sky130_fd_sc_hd__a22o_1
X_2736_ net868 _0988_ net295 VGND VGND VPWR VPWR _0031_ sky130_fd_sc_hd__mux2_1
X_2667_ net1147 _0942_ net295 VGND VGND VPWR VPWR _0008_ sky130_fd_sc_hd__mux2_1
X_4406_ clknet_leaf_26_clk _0517_ VGND VGND VPWR VPWR array\[2\]\[27\] sky130_fd_sc_hd__dfxtp_1
X_2598_ net617 net510 net396 net689 net301 VGND VGND VPWR VPWR _0895_ sky130_fd_sc_hd__a221o_1
Xfanout214 _0605_ VGND VGND VPWR VPWR net214 sky130_fd_sc_hd__buf_4
Xfanout203 net204 VGND VGND VPWR VPWR net203 sky130_fd_sc_hd__clkbuf_4
Xfanout236 _2045_ VGND VGND VPWR VPWR net236 sky130_fd_sc_hd__clkbuf_2
X_4337_ net212 _0607_ _1601_ _2172_ VGND VGND VPWR VPWR _0452_ sky130_fd_sc_hd__o31a_1
Xfanout225 net228 VGND VGND VPWR VPWR net225 sky130_fd_sc_hd__buf_4
Xfanout247 net248 VGND VGND VPWR VPWR net247 sky130_fd_sc_hd__clkbuf_4
XFILLER_86_234 VGND VGND VPWR VPWR sky130_fd_sc_hd__decap_6
Xfanout269 net270 VGND VGND VPWR VPWR net269 sky130_fd_sc_hd__clkbuf_4
X_4268_ net1154 net218 _2127_ _2128_ VGND VGND VPWR VPWR _0427_ sky130_fd_sc_hd__o22a_1
Xfanout258 _1441_ VGND VGND VPWR VPWR net258 sky130_fd_sc_hd__clkbuf_2
X_3219_ net777 _1325_ net159 VGND VGND VPWR VPWR _0177_ sky130_fd_sc_hd__mux2_1
XFILLER_27_301 VGND VGND VPWR VPWR sky130_fd_sc_hd__fill_2
X_4199_ net609 net431 net341 net681 net230 VGND VGND VPWR VPWR _2082_ sky130_fd_sc_hd__a221o_1
XFILLER_91_39 VPWR VGND VPWR VGND sky130_ef_sc_hd__decap_12
XFILLER_54_197 VGND VGND VPWR VPWR sky130_fd_sc_hd__decap_3
XFILLER_10_289 VGND VGND VPWR VPWR sky130_fd_sc_hd__decap_4
XFILLER_2_477 VPWR VGND VPWR VGND sky130_ef_sc_hd__decap_12
XFILLER_49_52 VGND VGND VPWR VPWR sky130_fd_sc_hd__decap_4
Xhold290 array\[1\]\[23\] VGND VGND VPWR VPWR net1056 sky130_fd_sc_hd__dlygate4sd3_1
XFILLER_77_234 VPWR VGND VPWR VGND sky130_ef_sc_hd__decap_12
XFILLER_49_96 VPWR VGND VPWR VGND sky130_ef_sc_hd__decap_12
XFILLER_1_15 VPWR VGND VPWR VGND sky130_ef_sc_hd__decap_12
XFILLER_58_470 VGND VGND VPWR VPWR sky130_fd_sc_hd__fill_1
XTAP_TAPCELL_ROW_76_969 VGND VPWR sky130_fd_sc_hd__tapvpwrvgnd_1
XFILLER_18_323 VGND VGND VPWR VPWR sky130_fd_sc_hd__decap_3
XFILLER_18_334 VGND VGND VPWR VPWR sky130_fd_sc_hd__decap_6
XTAP_TAPCELL_ROW_86_1065 VGND VPWR sky130_fd_sc_hd__tapvpwrvgnd_1
XANTENNA_152 net455 VGND VGND VPWR VPWR sky130_fd_sc_hd__diode_2
XANTENNA_130 _1442_ VGND VGND VPWR VPWR sky130_fd_sc_hd__diode_2
XANTENNA_141 net288 VGND VGND VPWR VPWR sky130_fd_sc_hd__diode_2
XANTENNA_163 net542 VGND VGND VPWR VPWR sky130_fd_sc_hd__diode_2
XANTENNA_174 net180 VGND VGND VPWR VPWR sky130_fd_sc_hd__diode_2
XTAP_TAPCELL_ROW_31_516 VGND VPWR sky130_fd_sc_hd__tapvpwrvgnd_1
XFILLER_41_370 VGND VGND VPWR VPWR sky130_fd_sc_hd__fill_1
X_3570_ net587 net475 net360 net661 VGND VGND VPWR VPWR _1566_ sky130_fd_sc_hd__a22o_1
X_2521_ net729 net307 _0838_ net405 net311 VGND VGND VPWR VPWR _0839_ sky130_fd_sc_hd__a221o_1
XFILLER_5_271 VGND VGND VPWR VPWR sky130_fd_sc_hd__fill_1
X_2452_ net739 net305 _0792_ net402 net309 VGND VGND VPWR VPWR _0793_ sky130_fd_sc_hd__a221o_1
X_2383_ net896 net210 _0743_ VGND VGND VPWR VPWR _0503_ sky130_fd_sc_hd__o21a_1
XPHY_EDGE_ROW_18_Right_18 VGND VGND VPWR VPWR sky130_fd_sc_hd__decap_3
XFILLER_68_223 VGND VGND VPWR VPWR sky130_fd_sc_hd__fill_2
X_4122_ array\[14\]\[31\] net467 net450 array\[12\]\[31\] VGND VGND VPWR VPWR _2030_
+ sky130_fd_sc_hd__a22o_1
XFILLER_68_267 VGND VGND VPWR VPWR sky130_fd_sc_hd__fill_2
XFILLER_28_109 VGND VGND VPWR VPWR sky130_fd_sc_hd__fill_1
X_4053_ array\[5\]\[25\] net553 net531 array\[7\]\[25\] _1966_ VGND VGND VPWR VPWR
+ _1967_ sky130_fd_sc_hd__a221o_1
Xinput3 enable_write[0] VGND VGND VPWR VPWR net3 sky130_fd_sc_hd__clkbuf_1
X_3004_ net992 _1175_ net166 VGND VGND VPWR VPWR _0112_ sky130_fd_sc_hd__mux2_1
XTAP_TAPCELL_ROW_47_671 VGND VPWR sky130_fd_sc_hd__tapvpwrvgnd_1
XTAP_TAPCELL_ROW_19_395 VGND VPWR sky130_fd_sc_hd__tapvpwrvgnd_1
XPHY_EDGE_ROW_27_Right_27 VGND VGND VPWR VPWR sky130_fd_sc_hd__decap_3
XFILLER_36_197 VGND VGND VPWR VPWR sky130_fd_sc_hd__fill_2
XFILLER_51_167 VGND VGND VPWR VPWR sky130_fd_sc_hd__fill_1
X_3906_ array\[10\]\[12\] net461 net444 array\[8\]\[12\] VGND VGND VPWR VPWR _1833_
+ sky130_fd_sc_hd__a22o_1
X_4886_ clknet_leaf_54_clk _0417_ VGND VGND VPWR VPWR array\[7\]\[29\] sky130_fd_sc_hd__dfxtp_1
X_3837_ array\[2\]\[6\] net459 net442 array\[0\]\[6\] VGND VGND VPWR VPWR _1770_ sky130_fd_sc_hd__a22o_1
X_3768_ array\[13\]\[0\] net543 net526 array\[15\]\[0\] _1706_ VGND VGND VPWR VPWR
+ _1707_ sky130_fd_sc_hd__a221o_1
X_2719_ net673 net599 net392 VGND VGND VPWR VPWR _0977_ sky130_fd_sc_hd__mux2_1
X_3699_ net700 net349 net421 VGND VGND VPWR VPWR _1661_ sky130_fd_sc_hd__and3_1
XPHY_EDGE_ROW_36_Right_36 VGND VGND VPWR VPWR sky130_fd_sc_hd__decap_3
XFILLER_74_248 VGND VGND VPWR VPWR sky130_fd_sc_hd__decap_4
XFILLER_19_88 VGND VGND VPWR VPWR sky130_fd_sc_hd__decap_3
XTAP_TAPCELL_ROW_73_939 VGND VPWR sky130_fd_sc_hd__tapvpwrvgnd_1
XFILLER_70_421 VGND VGND VPWR VPWR sky130_fd_sc_hd__fill_1
XPHY_EDGE_ROW_45_Right_45 VGND VGND VPWR VPWR sky130_fd_sc_hd__decap_3
XFILLER_15_337 VGND VGND VPWR VPWR sky130_fd_sc_hd__fill_1
XFILLER_42_178 VGND VGND VPWR VPWR sky130_fd_sc_hd__decap_3
XFILLER_51_20 VGND VGND VPWR VPWR sky130_fd_sc_hd__decap_4
XFILLER_7_503 VGND VGND VPWR VPWR sky130_fd_sc_hd__fill_1
XPHY_EDGE_ROW_2_Left_97 VGND VGND VPWR VPWR sky130_fd_sc_hd__decap_3
XPHY_EDGE_ROW_54_Right_54 VGND VGND VPWR VPWR sky130_fd_sc_hd__decap_3
XFILLER_93_502 VGND VGND VPWR VPWR sky130_fd_sc_hd__fill_2
XFILLER_76_83 VGND VGND VPWR VPWR sky130_fd_sc_hd__fill_1
XFILLER_46_440 VGND VGND VPWR VPWR sky130_fd_sc_hd__fill_1
XPHY_EDGE_ROW_63_Right_63 VGND VGND VPWR VPWR sky130_fd_sc_hd__decap_3
XFILLER_46_484 VGND VGND VPWR VPWR sky130_fd_sc_hd__decap_4
XTAP_TAPCELL_ROW_44_641 VGND VPWR sky130_fd_sc_hd__tapvpwrvgnd_1
XFILLER_61_421 VGND VGND VPWR VPWR sky130_fd_sc_hd__fill_1
XFILLER_61_443 VGND VGND VPWR VPWR sky130_fd_sc_hd__fill_1
XTAP_TAPCELL_ROW_16_365 VGND VPWR sky130_fd_sc_hd__tapvpwrvgnd_1
X_4740_ clknet_leaf_49_clk _0271_ VGND VGND VPWR VPWR array\[10\]\[9\] sky130_fd_sc_hd__dfxtp_1
X_4671_ clknet_leaf_43_clk _0202_ VGND VGND VPWR VPWR array\[12\]\[4\] sky130_fd_sc_hd__dfxtp_1
X_3622_ net211 _1589_ _1601_ _1603_ VGND VGND VPWR VPWR _0302_ sky130_fd_sc_hd__o31a_1
XPHY_EDGE_ROW_72_Right_72 VGND VGND VPWR VPWR sky130_fd_sc_hd__decap_3
X_3553_ net738 net246 _1554_ net252 VGND VGND VPWR VPWR _1555_ sky130_fd_sc_hd__a211o_1
X_2504_ net1038 net205 _0827_ VGND VGND VPWR VPWR _0540_ sky130_fd_sc_hd__o21a_1
X_3484_ net836 net261 _1505_ _1506_ VGND VGND VPWR VPWR _0261_ sky130_fd_sc_hd__o22a_1
X_2435_ net573 net643 net518 VGND VGND VPWR VPWR _0778_ sky130_fd_sc_hd__mux2_1
X_4105_ array\[2\]\[30\] net469 net452 array\[0\]\[30\] VGND VGND VPWR VPWR _2014_
+ sky130_fd_sc_hd__a22o_1
X_2366_ net760 net631 net519 VGND VGND VPWR VPWR _0732_ sky130_fd_sc_hd__mux2_1
XPHY_EDGE_ROW_16_Left_111 VGND VGND VPWR VPWR sky130_fd_sc_hd__decap_3
XPHY_EDGE_ROW_81_Right_81 VGND VGND VPWR VPWR sky130_fd_sc_hd__decap_3
XFILLER_56_215 VGND VGND VPWR VPWR sky130_fd_sc_hd__decap_8
X_2297_ net673 net599 net523 VGND VGND VPWR VPWR _0683_ sky130_fd_sc_hd__mux2_1
XFILLER_84_557 VGND VGND VPWR VPWR sky130_fd_sc_hd__decap_4
X_4036_ net779 net172 _1950_ _1951_ VGND VGND VPWR VPWR _0368_ sky130_fd_sc_hd__o22a_1
XFILLER_37_462 VGND VGND VPWR VPWR sky130_fd_sc_hd__fill_1
XFILLER_72_19 VGND VGND VPWR VPWR sky130_fd_sc_hd__decap_8
XTAP_TAPCELL_ROW_70_909 VGND VPWR sky130_fd_sc_hd__tapvpwrvgnd_1
XPHY_EDGE_ROW_25_Left_120 VGND VGND VPWR VPWR sky130_fd_sc_hd__decap_3
X_4869_ clknet_leaf_17_clk _0400_ VGND VGND VPWR VPWR array\[7\]\[12\] sky130_fd_sc_hd__dfxtp_1
XANTENNA_30 _1301_ VGND VGND VPWR VPWR sky130_fd_sc_hd__diode_2
XANTENNA_41 _1611_ VGND VGND VPWR VPWR sky130_fd_sc_hd__diode_2
XPHY_EDGE_ROW_90_Right_90 VGND VGND VPWR VPWR sky130_fd_sc_hd__decap_3
XANTENNA_63 net174 VGND VGND VPWR VPWR sky130_fd_sc_hd__diode_2
XFILLER_20_384 VGND VGND VPWR VPWR sky130_fd_sc_hd__fill_1
XANTENNA_52 _1717_ VGND VGND VPWR VPWR sky130_fd_sc_hd__diode_2
XANTENNA_74 net188 VGND VGND VPWR VPWR sky130_fd_sc_hd__diode_2
XANTENNA_85 net322 VGND VGND VPWR VPWR sky130_fd_sc_hd__diode_2
XANTENNA_96 net378 VGND VGND VPWR VPWR sky130_fd_sc_hd__diode_2
XFILLER_21_89 VPWR VGND VPWR VGND sky130_ef_sc_hd__decap_12
XFILLER_75_502 VGND VGND VPWR VPWR sky130_fd_sc_hd__fill_2
XFILLER_75_524 VGND VGND VPWR VPWR sky130_fd_sc_hd__decap_6
XFILLER_28_473 VGND VGND VPWR VPWR sky130_fd_sc_hd__decap_3
XTAP_TAPCELL_ROW_58_788 VGND VPWR sky130_fd_sc_hd__tapvpwrvgnd_1
XTAP_TAPCELL_ROW_83_1035 VGND VPWR sky130_fd_sc_hd__tapvpwrvgnd_1
XTAP_TAPCELL_ROW_41_611 VGND VPWR sky130_fd_sc_hd__tapvpwrvgnd_1
XTAP_TAPCELL_ROW_13_335 VGND VPWR sky130_fd_sc_hd__tapvpwrvgnd_1
XFILLER_62_85 VGND VGND VPWR VPWR sky130_fd_sc_hd__fill_1
XTAP_TAPCELL_ROW_94_1153 VGND VPWR sky130_fd_sc_hd__tapvpwrvgnd_1
XTAP_TAPCELL_ROW_94_1142 VGND VPWR sky130_fd_sc_hd__tapvpwrvgnd_1
XFILLER_3_561 VGND VGND VPWR VPWR sky130_fd_sc_hd__fill_1
X_2220_ net217 _0623_ _0624_ net1314 net651 VGND VGND VPWR VPWR _0457_ sky130_fd_sc_hd__a221o_1
XFILLER_30_6 VPWR VGND VPWR VGND sky130_ef_sc_hd__decap_12
XFILLER_87_93 VPWR VGND VPWR VGND sky130_ef_sc_hd__decap_12
XFILLER_81_505 VGND VGND VPWR VPWR sky130_fd_sc_hd__decap_6
XTAP_TAPCELL_ROW_29_490 VGND VPWR sky130_fd_sc_hd__tapvpwrvgnd_1
XFILLER_34_421 VGND VGND VPWR VPWR sky130_fd_sc_hd__fill_2
XFILLER_61_251 VGND VGND VPWR VPWR sky130_fd_sc_hd__fill_2
XFILLER_34_487 VGND VGND VPWR VPWR sky130_fd_sc_hd__decap_4
X_2984_ net640 net570 net493 VGND VGND VPWR VPWR _1162_ sky130_fd_sc_hd__mux2_1
XFILLER_61_273 VGND VGND VPWR VPWR sky130_fd_sc_hd__decap_6
XFILLER_61_295 VGND VGND VPWR VPWR sky130_fd_sc_hd__fill_1
X_4723_ clknet_leaf_36_clk _0254_ VGND VGND VPWR VPWR array\[11\]\[24\] sky130_fd_sc_hd__dfxtp_1
X_4654_ clknet_leaf_51_clk _0185_ VGND VGND VPWR VPWR array\[13\]\[19\] sky130_fd_sc_hd__dfxtp_1
Xinput50 value1[1] VGND VGND VPWR VPWR net50 sky130_fd_sc_hd__clkbuf_1
Xinput72 value2[10] VGND VGND VPWR VPWR net72 sky130_fd_sc_hd__buf_1
X_3605_ net211 _0614_ _1589_ _1590_ _1224_ VGND VGND VPWR VPWR _0298_ sky130_fd_sc_hd__o32a_1
Xinput61 value1[2] VGND VGND VPWR VPWR net61 sky130_fd_sc_hd__clkbuf_1
X_4585_ clknet_leaf_0_clk _0116_ VGND VGND VPWR VPWR array\[15\]\[14\] sky130_fd_sc_hd__dfxtp_1
Xinput94 value2[30] VGND VGND VPWR VPWR net94 sky130_fd_sc_hd__clkbuf_1
X_3536_ net848 net250 _1543_ VGND VGND VPWR VPWR _0276_ sky130_fd_sc_hd__o21a_1
Xinput83 value2[20] VGND VGND VPWR VPWR net83 sky130_fd_sc_hd__buf_1
X_3467_ net725 net256 VGND VGND VPWR VPWR _1495_ sky130_fd_sc_hd__and2_1
X_2418_ net727 net316 _0766_ net408 net313 VGND VGND VPWR VPWR _0767_ sky130_fd_sc_hd__a221o_1
X_3398_ net712 net255 VGND VGND VPWR VPWR _1449_ sky130_fd_sc_hd__and2_1
XFILLER_69_384 VGND VGND VPWR VPWR sky130_fd_sc_hd__decap_8
X_2349_ net717 net316 _0720_ net408 net313 VGND VGND VPWR VPWR _0721_ sky130_fd_sc_hd__a221o_1
XFILLER_84_354 VGND VGND VPWR VPWR sky130_fd_sc_hd__fill_2
XFILLER_84_376 VGND VGND VPWR VPWR sky130_fd_sc_hd__decap_4
XFILLER_84_365 VGND VGND VPWR VPWR sky130_fd_sc_hd__fill_2
X_4019_ array\[14\]\[22\] net456 net439 array\[12\]\[22\] VGND VGND VPWR VPWR _1936_
+ sky130_fd_sc_hd__a22o_1
XTAP_TAPCELL_ROW_55_758 VGND VPWR sky130_fd_sc_hd__tapvpwrvgnd_1
XPHY_EDGE_ROW_0_Right_0 VGND VGND VPWR VPWR sky130_fd_sc_hd__decap_3
XFILLER_25_465 VGND VGND VPWR VPWR sky130_fd_sc_hd__fill_1
XFILLER_40_413 VGND VGND VPWR VPWR sky130_fd_sc_hd__decap_6
XFILLER_52_273 VGND VGND VPWR VPWR sky130_fd_sc_hd__decap_3
XTAP_TAPCELL_ROW_10_305 VGND VPWR sky130_fd_sc_hd__tapvpwrvgnd_1
XFILLER_8_119 VPWR VGND VPWR VGND sky130_ef_sc_hd__decap_12
XFILLER_79_148 VGND VGND VPWR VPWR sky130_fd_sc_hd__fill_1
XFILLER_31_402 VGND VGND VPWR VPWR sky130_fd_sc_hd__fill_2
XTAP_TAPCELL_ROW_26_460 VGND VPWR sky130_fd_sc_hd__tapvpwrvgnd_1
XFILLER_7_141 VGND VGND VPWR VPWR sky130_fd_sc_hd__decap_6
Xhold108 array\[10\]\[30\] VGND VGND VPWR VPWR net874 sky130_fd_sc_hd__dlygate4sd3_1
Xhold119 array\[2\]\[26\] VGND VGND VPWR VPWR net885 sky130_fd_sc_hd__dlygate4sd3_1
X_4370_ clknet_leaf_35_clk _0481_ VGND VGND VPWR VPWR array\[1\]\[23\] sky130_fd_sc_hd__dfxtp_1
X_3321_ net622 net482 net367 net694 net177 VGND VGND VPWR VPWR _1396_ sky130_fd_sc_hd__a221o_1
X_3252_ net968 _1347_ net157 VGND VGND VPWR VPWR _0188_ sky130_fd_sc_hd__mux2_1
XFILLER_3_391 VGND VGND VPWR VPWR sky130_fd_sc_hd__fill_1
X_2203_ net1316 net217 _0611_ net562 VGND VGND VPWR VPWR _0455_ sky130_fd_sc_hd__o211a_1
X_3183_ net485 _1150_ _0931_ VGND VGND VPWR VPWR _1301_ sky130_fd_sc_hd__and3b_4
XFILLER_93_162 VGND VGND VPWR VPWR sky130_fd_sc_hd__decap_6
XFILLER_22_402 VGND VGND VPWR VPWR sky130_fd_sc_hd__fill_2
XTAP_TAPCELL_ROW_52_728 VGND VPWR sky130_fd_sc_hd__tapvpwrvgnd_1
XFILLER_22_468 VGND VGND VPWR VPWR sky130_fd_sc_hd__decap_8
X_2967_ net753 _0780_ _0854_ VGND VGND VPWR VPWR _1149_ sky130_fd_sc_hd__and3_4
X_2898_ net617 net689 net500 VGND VGND VPWR VPWR _1099_ sky130_fd_sc_hd__mux2_1
X_4706_ clknet_leaf_60_clk _0237_ VGND VGND VPWR VPWR array\[11\]\[7\] sky130_fd_sc_hd__dfxtp_1
X_4637_ clknet_leaf_43_clk _0168_ VGND VGND VPWR VPWR array\[13\]\[2\] sky130_fd_sc_hd__dfxtp_1
XFILLER_78_29 VPWR VGND VPWR VGND sky130_ef_sc_hd__decap_12
X_4568_ clknet_leaf_54_clk _0099_ VGND VGND VPWR VPWR array\[0\]\[29\] sky130_fd_sc_hd__dfxtp_1
X_3519_ net862 net251 _1531_ _1532_ VGND VGND VPWR VPWR _0270_ sky130_fd_sc_hd__o22a_1
X_4499_ clknet_leaf_32_clk _0030_ VGND VGND VPWR VPWR array\[5\]\[24\] sky130_fd_sc_hd__dfxtp_1
XFILLER_89_468 VPWR VGND VPWR VGND sky130_ef_sc_hd__decap_12
XFILLER_57_310 VGND VGND VPWR VPWR sky130_fd_sc_hd__fill_1
XTAP_TAPCELL_ROW_68_883 VGND VPWR sky130_fd_sc_hd__tapvpwrvgnd_1
XTAP_TAPCELL_ROW_80_1005 VGND VPWR sky130_fd_sc_hd__tapvpwrvgnd_1
XFILLER_13_402 VGND VGND VPWR VPWR sky130_fd_sc_hd__fill_2
XFILLER_9_406 VPWR VGND VPWR VGND sky130_ef_sc_hd__decap_12
XTAP_TAPCELL_ROW_23_430 VGND VPWR sky130_fd_sc_hd__tapvpwrvgnd_1
XFILLER_40_265 VGND VGND VPWR VPWR sky130_fd_sc_hd__fill_1
Xclkbuf_leaf_20_clk clknet_3_6__leaf_clk VGND VGND VPWR VPWR clknet_leaf_20_clk sky130_fd_sc_hd__clkbuf_8
XTAP_TAPCELL_ROW_91_1112 VGND VPWR sky130_fd_sc_hd__tapvpwrvgnd_1
XFILLER_4_15 VPWR VGND VPWR VGND sky130_ef_sc_hd__decap_12
XFILLER_0_350 VGND VGND VPWR VPWR sky130_fd_sc_hd__decap_3
XFILLER_36_516 VGND VGND VPWR VPWR sky130_fd_sc_hd__decap_8
XFILLER_63_302 VGND VGND VPWR VPWR sky130_fd_sc_hd__fill_1
XFILLER_90_121 VPWR VGND VPWR VGND sky130_ef_sc_hd__decap_12
XTAP_TAPCELL_ROW_89_1096 VGND VPWR sky130_fd_sc_hd__tapvpwrvgnd_1
XFILLER_84_83 VGND VGND VPWR VPWR sky130_fd_sc_hd__fill_1
XFILLER_75_173 VGND VGND VPWR VPWR sky130_fd_sc_hd__fill_1
XFILLER_63_346 VGND VGND VPWR VPWR sky130_fd_sc_hd__decap_3
XFILLER_63_357 VGND VGND VPWR VPWR sky130_fd_sc_hd__fill_2
X_3870_ array\[10\]\[9\] net464 net447 array\[8\]\[9\] VGND VGND VPWR VPWR _1800_
+ sky130_fd_sc_hd__a22o_1
X_2821_ net600 net504 net276 net674 VGND VGND VPWR VPWR _1047_ sky130_fd_sc_hd__a22o_1
XFILLER_76_3 VPWR VGND VPWR VGND sky130_ef_sc_hd__decap_12
Xclkbuf_leaf_11_clk clknet_3_5__leaf_clk VGND VGND VPWR VPWR clknet_leaf_11_clk sky130_fd_sc_hd__clkbuf_8
X_2752_ net644 net574 net393 VGND VGND VPWR VPWR _0999_ sky130_fd_sc_hd__mux2_1
XFILLER_31_287 VGND VGND VPWR VPWR sky130_fd_sc_hd__fill_1
X_4422_ clknet_leaf_14_clk _0533_ VGND VGND VPWR VPWR array\[3\]\[11\] sky130_fd_sc_hd__dfxtp_1
X_2683_ net632 net761 net393 VGND VGND VPWR VPWR _0953_ sky130_fd_sc_hd__mux2_1
X_4353_ clknet_leaf_6_clk _0464_ VGND VGND VPWR VPWR array\[1\]\[6\] sky130_fd_sc_hd__dfxtp_1
Xfanout418 _0613_ VGND VGND VPWR VPWR net418 sky130_fd_sc_hd__buf_2
X_3304_ net942 net155 _1383_ _1384_ VGND VGND VPWR VPWR _0203_ sky130_fd_sc_hd__o22a_1
X_4284_ net618 net428 net332 net690 net222 VGND VGND VPWR VPWR _2139_ sky130_fd_sc_hd__a221o_1
Xfanout429 _1619_ VGND VGND VPWR VPWR net429 sky130_fd_sc_hd__clkbuf_4
Xfanout407 _0710_ VGND VGND VPWR VPWR net407 sky130_fd_sc_hd__clkbuf_2
X_3235_ net682 net373 VGND VGND VPWR VPWR _1336_ sky130_fd_sc_hd__and2_1
X_3166_ net579 net491 net376 net649 VGND VGND VPWR VPWR _1287_ sky130_fd_sc_hd__a22o_1
XFILLER_39_387 VGND VGND VPWR VPWR sky130_fd_sc_hd__decap_4
X_3097_ net565 net490 net375 net635 VGND VGND VPWR VPWR _1241_ sky130_fd_sc_hd__a22o_1
XTAP_TAPCELL_ROW_65_853 VGND VPWR sky130_fd_sc_hd__tapvpwrvgnd_1
XTAP_TAPCELL_ROW_37_577 VGND VPWR sky130_fd_sc_hd__tapvpwrvgnd_1
XFILLER_10_405 VPWR VGND VPWR VGND sky130_ef_sc_hd__decap_12
X_3999_ array\[1\]\[20\] net546 net534 array\[3\]\[20\] _1917_ VGND VGND VPWR VPWR
+ _1918_ sky130_fd_sc_hd__a221o_1
XTAP_TAPCELL_ROW_20_400 VGND VPWR sky130_fd_sc_hd__tapvpwrvgnd_1
XFILLER_89_39 VPWR VGND VPWR VGND sky130_ef_sc_hd__decap_12
Xhold450 array\[3\]\[8\] VGND VGND VPWR VPWR net1216 sky130_fd_sc_hd__dlygate4sd3_1
Xhold461 array\[7\]\[26\] VGND VGND VPWR VPWR net1227 sky130_fd_sc_hd__dlygate4sd3_1
XPHY_EDGE_ROW_8_Left_103 VGND VGND VPWR VPWR sky130_fd_sc_hd__decap_3
Xhold472 array\[3\]\[14\] VGND VGND VPWR VPWR net1238 sky130_fd_sc_hd__dlygate4sd3_1
XFILLER_89_254 VGND VGND VPWR VPWR sky130_fd_sc_hd__decap_8
Xhold483 array\[7\]\[9\] VGND VGND VPWR VPWR net1249 sky130_fd_sc_hd__dlygate4sd3_1
Xhold494 array\[3\]\[23\] VGND VGND VPWR VPWR net1260 sky130_fd_sc_hd__dlygate4sd3_1
XFILLER_1_169 VPWR VGND VPWR VGND sky130_ef_sc_hd__decap_12
XFILLER_77_449 VGND VGND VPWR VPWR sky130_fd_sc_hd__decap_4
XFILLER_45_335 VGND VGND VPWR VPWR sky130_fd_sc_hd__fill_1
XTAP_TAPCELL_ROW_0_191 VGND VPWR sky130_fd_sc_hd__tapvpwrvgnd_1
XFILLER_70_41 VPWR VGND VPWR VGND sky130_ef_sc_hd__decap_12
XFILLER_70_85 VGND VGND VPWR VPWR sky130_fd_sc_hd__fill_2
Xclkload17 clknet_leaf_56_clk VGND VGND VPWR VPWR clkload17/Y sky130_fd_sc_hd__clkinv_4
Xclkload39 clknet_leaf_16_clk VGND VGND VPWR VPWR clkload39/X sky130_fd_sc_hd__clkbuf_8
Xclkload28 clknet_leaf_54_clk VGND VGND VPWR VPWR clkload28/X sky130_fd_sc_hd__clkbuf_8
XFILLER_5_497 VGND VGND VPWR VPWR sky130_fd_sc_hd__decap_6
XTAP_TAPCELL_ROW_8_280 VGND VPWR sky130_fd_sc_hd__tapvpwrvgnd_1
X_3020_ net684 net612 net496 VGND VGND VPWR VPWR _1186_ sky130_fd_sc_hd__mux2_1
Xclkbuf_leaf_0_clk clknet_3_1__leaf_clk VGND VGND VPWR VPWR clknet_leaf_0_clk sky130_fd_sc_hd__clkbuf_8
XFILLER_48_184 VGND VGND VPWR VPWR sky130_fd_sc_hd__fill_1
XFILLER_63_110 VGND VGND VPWR VPWR sky130_fd_sc_hd__fill_2
XTAP_TAPCELL_ROW_62_823 VGND VPWR sky130_fd_sc_hd__tapvpwrvgnd_1
X_3922_ net437 _1842_ _1846_ net356 net214 VGND VGND VPWR VPWR _1848_ sky130_fd_sc_hd__a221o_1
XTAP_TAPCELL_ROW_34_547 VGND VPWR sky130_fd_sc_hd__tapvpwrvgnd_1
X_3853_ net355 _1779_ _1783_ net415 VGND VGND VPWR VPWR _1785_ sky130_fd_sc_hd__a22o_1
X_2804_ net752 net280 VGND VGND VPWR VPWR _1036_ sky130_fd_sc_hd__and2_1
X_3784_ net351 _1715_ _1719_ net435 VGND VGND VPWR VPWR _1722_ sky130_fd_sc_hd__a22o_1
XFILLER_8_291 VGND VGND VPWR VPWR sky130_fd_sc_hd__decap_3
X_2735_ net728 net291 _0987_ net389 VGND VGND VPWR VPWR _0988_ sky130_fd_sc_hd__a22o_1
X_2666_ net717 net291 _0941_ net389 VGND VGND VPWR VPWR _0942_ sky130_fd_sc_hd__a22o_1
X_4405_ clknet_leaf_16_clk _0516_ VGND VGND VPWR VPWR array\[2\]\[26\] sky130_fd_sc_hd__dfxtp_1
X_2597_ net754 net400 net507 VGND VGND VPWR VPWR _0894_ sky130_fd_sc_hd__and3_1
X_4336_ net562 ready_check\[9\] _2171_ _1638_ VGND VGND VPWR VPWR _2172_ sky130_fd_sc_hd__a31o_1
Xfanout204 net206 VGND VGND VPWR VPWR net204 sky130_fd_sc_hd__buf_4
XFILLER_86_202 VGND VGND VPWR VPWR sky130_fd_sc_hd__decap_8
Xfanout215 _0605_ VGND VGND VPWR VPWR net215 sky130_fd_sc_hd__clkbuf_4
Xfanout237 net240 VGND VGND VPWR VPWR net237 sky130_fd_sc_hd__buf_4
Xfanout226 net228 VGND VGND VPWR VPWR net226 sky130_fd_sc_hd__clkbuf_4
XFILLER_86_246 VGND VGND VPWR VPWR sky130_fd_sc_hd__decap_6
Xfanout248 _1513_ VGND VGND VPWR VPWR net248 sky130_fd_sc_hd__clkbuf_4
Xfanout259 _1440_ VGND VGND VPWR VPWR net259 sky130_fd_sc_hd__buf_4
X_4267_ net763 net427 net331 net634 net221 VGND VGND VPWR VPWR _2128_ sky130_fd_sc_hd__a221o_1
X_3218_ net622 net487 net183 net586 _1324_ VGND VGND VPWR VPWR _1325_ sky130_fd_sc_hd__a221o_1
XFILLER_74_419 VGND VGND VPWR VPWR sky130_fd_sc_hd__fill_1
X_4198_ net745 net233 VGND VGND VPWR VPWR _2081_ sky130_fd_sc_hd__and2_1
XFILLER_67_482 VGND VGND VPWR VPWR sky130_fd_sc_hd__fill_1
XFILLER_39_184 VGND VGND VPWR VPWR sky130_fd_sc_hd__fill_1
X_3149_ net732 net187 _1275_ net191 VGND VGND VPWR VPWR _1276_ sky130_fd_sc_hd__a211o_1
XFILLER_82_485 VGND VGND VPWR VPWR sky130_fd_sc_hd__decap_3
XFILLER_24_67 VPWR VGND VPWR VGND sky130_ef_sc_hd__decap_12
XFILLER_50_360 VGND VGND VPWR VPWR sky130_fd_sc_hd__decap_4
XFILLER_6_3 VPWR VGND VPWR VGND sky130_ef_sc_hd__decap_12
XFILLER_2_445 VPWR VGND VPWR VGND sky130_ef_sc_hd__decap_12
Xhold280 array\[0\]\[31\] VGND VGND VPWR VPWR net1046 sky130_fd_sc_hd__dlygate4sd3_1
XFILLER_77_213 VGND VGND VPWR VPWR sky130_fd_sc_hd__fill_1
XFILLER_2_489 VPWR VGND VPWR VGND sky130_ef_sc_hd__decap_12
XFILLER_49_42 VGND VGND VPWR VPWR sky130_fd_sc_hd__decap_3
Xhold291 array\[6\]\[30\] VGND VGND VPWR VPWR net1057 sky130_fd_sc_hd__dlygate4sd3_1
XFILLER_77_246 VGND VGND VPWR VPWR sky130_fd_sc_hd__decap_6
Xfanout760 net101 VGND VGND VPWR VPWR net760 sky130_fd_sc_hd__buf_2
XFILLER_77_279 VGND VGND VPWR VPWR sky130_fd_sc_hd__fill_1
XTAP_TAPCELL_ROW_5_250 VGND VPWR sky130_fd_sc_hd__tapvpwrvgnd_1
XFILLER_1_27 VPWR VGND VPWR VGND sky130_ef_sc_hd__decap_12
XFILLER_45_110 VGND VGND VPWR VPWR sky130_fd_sc_hd__fill_2
XANTENNA_120 net491 VGND VGND VPWR VPWR sky130_fd_sc_hd__diode_2
XTAP_TAPCELL_ROW_86_1066 VGND VPWR sky130_fd_sc_hd__tapvpwrvgnd_1
XANTENNA_142 net288 VGND VGND VPWR VPWR sky130_fd_sc_hd__diode_2
XFILLER_33_316 VGND VGND VPWR VPWR sky130_fd_sc_hd__decap_4
XANTENNA_131 _1635_ VGND VGND VPWR VPWR sky130_fd_sc_hd__diode_2
XFILLER_33_349 VPWR VGND VPWR VGND sky130_ef_sc_hd__decap_12
XANTENNA_164 net542 VGND VGND VPWR VPWR sky130_fd_sc_hd__diode_2
XANTENNA_153 net463 VGND VGND VPWR VPWR sky130_fd_sc_hd__diode_2
XANTENNA_175 net188 VGND VGND VPWR VPWR sky130_fd_sc_hd__diode_2
XFILLER_81_51 VGND VGND VPWR VPWR sky130_fd_sc_hd__decap_4
XTAP_TAPCELL_ROW_31_517 VGND VPWR sky130_fd_sc_hd__tapvpwrvgnd_1
XFILLER_60_6 VPWR VGND VPWR VGND sky130_ef_sc_hd__decap_12
X_2520_ net665 net591 net516 VGND VGND VPWR VPWR _0838_ sky130_fd_sc_hd__mux2_1
X_2451_ net675 net601 net514 VGND VGND VPWR VPWR _0792_ sky130_fd_sc_hd__mux2_1
X_2382_ net754 net318 _0742_ net407 net312 VGND VGND VPWR VPWR _0743_ sky130_fd_sc_hd__a221o_1
XFILLER_39_3 VGND VGND VPWR VPWR sky130_fd_sc_hd__fill_1
X_4121_ array\[5\]\[31\] net552 net530 array\[7\]\[31\] _2028_ VGND VGND VPWR VPWR
+ _2029_ sky130_fd_sc_hd__a221o_1
X_4052_ array\[6\]\[25\] net466 net449 array\[4\]\[25\] VGND VGND VPWR VPWR _1966_
+ sky130_fd_sc_hd__a22o_1
XFILLER_49_460 VGND VGND VPWR VPWR sky130_fd_sc_hd__decap_6
XFILLER_56_419 VGND VGND VPWR VPWR sky130_fd_sc_hd__fill_1
X_3003_ net608 net194 _1174_ net380 VGND VGND VPWR VPWR _1175_ sky130_fd_sc_hd__a22o_1
Xinput4 enable_write[1] VGND VGND VPWR VPWR net4 sky130_fd_sc_hd__clkbuf_1
XTAP_TAPCELL_ROW_47_672 VGND VPWR sky130_fd_sc_hd__tapvpwrvgnd_1
XTAP_TAPCELL_ROW_19_396 VGND VPWR sky130_fd_sc_hd__tapvpwrvgnd_1
X_3905_ array\[13\]\[12\] net547 net537 array\[15\]\[12\] _1831_ VGND VGND VPWR VPWR
+ _1832_ sky130_fd_sc_hd__a221o_1
X_4885_ clknet_leaf_39_clk _0416_ VGND VGND VPWR VPWR array\[7\]\[28\] sky130_fd_sc_hd__dfxtp_1
X_3836_ array\[9\]\[6\] net548 net535 array\[11\]\[6\] _1768_ VGND VGND VPWR VPWR
+ _1769_ sky130_fd_sc_hd__a221o_1
X_3767_ array\[14\]\[0\] net456 net439 array\[12\]\[0\] VGND VGND VPWR VPWR _1706_
+ sky130_fd_sc_hd__a22o_1
X_2718_ net966 _0976_ net293 VGND VGND VPWR VPWR _0025_ sky130_fd_sc_hd__mux2_1
X_3698_ net1125 net238 _1659_ _1660_ VGND VGND VPWR VPWR _0321_ sky130_fd_sc_hd__o22a_1
X_2649_ net713 net401 net508 VGND VGND VPWR VPWR _0928_ sky130_fd_sc_hd__and3_1
XFILLER_86_29 VPWR VGND VPWR VGND sky130_ef_sc_hd__decap_12
X_4319_ net587 net428 net332 net661 net222 VGND VGND VPWR VPWR _2161_ sky130_fd_sc_hd__a221o_1
XTAP_TAPCELL_ROW_2_220 VGND VPWR sky130_fd_sc_hd__tapvpwrvgnd_1
XFILLER_82_260 VGND VGND VPWR VPWR sky130_fd_sc_hd__decap_4
XFILLER_55_463 VGND VGND VPWR VPWR sky130_fd_sc_hd__decap_4
XFILLER_7_559 VGND VGND VPWR VPWR sky130_fd_sc_hd__fill_1
XFILLER_78_533 VPWR VGND VPWR VGND sky130_ef_sc_hd__decap_12
XFILLER_2_297 VGND VGND VPWR VPWR sky130_fd_sc_hd__fill_2
XFILLER_76_62 VGND VGND VPWR VPWR sky130_fd_sc_hd__decap_3
Xfanout590 net88 VGND VGND VPWR VPWR net590 sky130_fd_sc_hd__dlymetal6s2s_1
XFILLER_58_290 VGND VGND VPWR VPWR sky130_fd_sc_hd__decap_8
XFILLER_46_474 VGND VGND VPWR VPWR sky130_fd_sc_hd__fill_2
XFILLER_92_83 VGND VGND VPWR VPWR sky130_fd_sc_hd__fill_1
XTAP_TAPCELL_ROW_16_366 VGND VPWR sky130_fd_sc_hd__tapvpwrvgnd_1
XFILLER_33_157 VGND VGND VPWR VPWR sky130_fd_sc_hd__decap_3
XTAP_TAPCELL_ROW_44_642 VGND VPWR sky130_fd_sc_hd__tapvpwrvgnd_1
XFILLER_41_190 VPWR VGND VPWR VGND sky130_ef_sc_hd__decap_12
X_4670_ clknet_leaf_8_clk _0201_ VGND VGND VPWR VPWR array\[12\]\[3\] sky130_fd_sc_hd__dfxtp_1
X_3621_ net562 ready_check\[10\] _1602_ _1510_ VGND VGND VPWR VPWR _1603_ sky130_fd_sc_hd__a31o_1
X_3552_ net600 net475 net360 net674 VGND VGND VPWR VPWR _1554_ sky130_fd_sc_hd__a22o_1
X_2503_ net744 net306 _0826_ net404 net310 VGND VGND VPWR VPWR _0827_ sky130_fd_sc_hd__a221o_1
X_3483_ net573 net479 net365 net643 net265 VGND VGND VPWR VPWR _1506_ sky130_fd_sc_hd__a221o_1
X_2434_ net847 net209 _0777_ VGND VGND VPWR VPWR _0520_ sky130_fd_sc_hd__o21a_1
X_2365_ net1302 net207 _0731_ VGND VGND VPWR VPWR _0497_ sky130_fd_sc_hd__o21a_1
X_4104_ net811 net171 _2013_ VGND VGND VPWR VPWR _0374_ sky130_fd_sc_hd__o21a_1
X_2296_ net1156 net323 _0682_ VGND VGND VPWR VPWR _0477_ sky130_fd_sc_hd__o21a_1
XFILLER_49_290 VGND VGND VPWR VPWR sky130_fd_sc_hd__decap_4
X_4035_ net358 _1945_ _1949_ net418 net216 VGND VGND VPWR VPWR _1951_ sky130_fd_sc_hd__a221o_1
X_4868_ clknet_leaf_17_clk _0399_ VGND VGND VPWR VPWR array\[7\]\[11\] sky130_fd_sc_hd__dfxtp_1
XANTENNA_20 _1153_ VGND VGND VPWR VPWR sky130_fd_sc_hd__diode_2
XANTENNA_31 _1301_ VGND VGND VPWR VPWR sky130_fd_sc_hd__diode_2
XANTENNA_42 _1611_ VGND VGND VPWR VPWR sky130_fd_sc_hd__diode_2
XANTENNA_64 net176 VGND VGND VPWR VPWR sky130_fd_sc_hd__diode_2
X_3819_ net417 _1747_ _1751_ net357 VGND VGND VPWR VPWR _1754_ sky130_fd_sc_hd__a22o_1
XANTENNA_75 net190 VGND VGND VPWR VPWR sky130_fd_sc_hd__diode_2
XANTENNA_53 _2045_ VGND VGND VPWR VPWR sky130_fd_sc_hd__diode_2
X_4799_ clknet_leaf_21_clk _0330_ VGND VGND VPWR VPWR array\[9\]\[17\] sky130_fd_sc_hd__dfxtp_1
XANTENNA_86 net330 VGND VGND VPWR VPWR sky130_fd_sc_hd__diode_2
XANTENNA_97 net378 VGND VGND VPWR VPWR sky130_fd_sc_hd__diode_2
XFILLER_21_57 VGND VGND VPWR VPWR sky130_fd_sc_hd__decap_6
XFILLER_28_463 VGND VGND VPWR VPWR sky130_fd_sc_hd__fill_2
XTAP_TAPCELL_ROW_58_789 VGND VPWR sky130_fd_sc_hd__tapvpwrvgnd_1
XTAP_TAPCELL_ROW_83_1036 VGND VPWR sky130_fd_sc_hd__tapvpwrvgnd_1
XFILLER_15_113 VGND VGND VPWR VPWR sky130_fd_sc_hd__fill_1
XFILLER_62_20 VGND VGND VPWR VPWR sky130_fd_sc_hd__fill_1
XTAP_TAPCELL_ROW_41_612 VGND VPWR sky130_fd_sc_hd__tapvpwrvgnd_1
XFILLER_62_53 VGND VGND VPWR VPWR sky130_fd_sc_hd__fill_1
XTAP_TAPCELL_ROW_13_336 VGND VPWR sky130_fd_sc_hd__tapvpwrvgnd_1
XFILLER_7_15 VPWR VGND VPWR VGND sky130_ef_sc_hd__decap_12
XTAP_TAPCELL_ROW_94_1154 VGND VPWR sky130_fd_sc_hd__tapvpwrvgnd_1
XTAP_TAPCELL_ROW_94_1143 VGND VPWR sky130_fd_sc_hd__tapvpwrvgnd_1
XFILLER_93_322 VGND VGND VPWR VPWR sky130_fd_sc_hd__fill_1
XFILLER_19_485 VGND VGND VPWR VPWR sky130_fd_sc_hd__decap_6
XFILLER_46_271 VGND VGND VPWR VPWR sky130_fd_sc_hd__fill_2
XTAP_TAPCELL_ROW_29_491 VGND VPWR sky130_fd_sc_hd__tapvpwrvgnd_1
XFILLER_34_477 VGND VGND VPWR VPWR sky130_fd_sc_hd__fill_2
X_2983_ net1183 _1161_ net167 VGND VGND VPWR VPWR _0105_ sky130_fd_sc_hd__mux2_1
X_4722_ clknet_leaf_35_clk _0253_ VGND VGND VPWR VPWR array\[11\]\[23\] sky130_fd_sc_hd__dfxtp_1
X_4653_ clknet_leaf_14_clk _0184_ VGND VGND VPWR VPWR array\[13\]\[18\] sky130_fd_sc_hd__dfxtp_1
Xinput40 value1[10] VGND VGND VPWR VPWR net40 sky130_fd_sc_hd__buf_1
Xinput62 value1[30] VGND VGND VPWR VPWR net62 sky130_fd_sc_hd__clkbuf_1
Xinput73 value2[11] VGND VGND VPWR VPWR net73 sky130_fd_sc_hd__clkbuf_1
X_4584_ clknet_leaf_11_clk _0115_ VGND VGND VPWR VPWR array\[15\]\[13\] sky130_fd_sc_hd__dfxtp_1
X_3604_ net563 ready_check\[14\] _1219_ _1220_ VGND VGND VPWR VPWR _1590_ sky130_fd_sc_hd__a31o_1
Xinput51 value1[20] VGND VGND VPWR VPWR net51 sky130_fd_sc_hd__buf_1
Xinput95 value2[31] VGND VGND VPWR VPWR net95 sky130_fd_sc_hd__buf_1
Xinput84 value2[21] VGND VGND VPWR VPWR net84 sky130_fd_sc_hd__buf_1
X_3535_ net752 net246 _1542_ net252 VGND VGND VPWR VPWR _1543_ sky130_fd_sc_hd__a211o_1
X_3466_ net1013 net261 _1493_ _1494_ VGND VGND VPWR VPWR _0255_ sky130_fd_sc_hd__o22a_1
X_2417_ net589 net663 net518 VGND VGND VPWR VPWR _0766_ sky130_fd_sc_hd__mux2_1
X_3397_ net1155 net261 _1447_ _1448_ VGND VGND VPWR VPWR _0232_ sky130_fd_sc_hd__o22a_1
X_2348_ net577 net647 net518 VGND VGND VPWR VPWR _0720_ sky130_fd_sc_hd__mux2_1
X_2279_ net687 net615 net522 VGND VGND VPWR VPWR _0671_ sky130_fd_sc_hd__mux2_1
XFILLER_72_506 VGND VGND VPWR VPWR sky130_fd_sc_hd__fill_2
X_4018_ array\[9\]\[22\] net543 net526 array\[11\]\[22\] _1934_ VGND VGND VPWR VPWR
+ _1935_ sky130_fd_sc_hd__a221o_1
XFILLER_25_400 VGND VGND VPWR VPWR sky130_fd_sc_hd__decap_6
XFILLER_37_260 VGND VGND VPWR VPWR sky130_fd_sc_hd__decap_3
XTAP_TAPCELL_ROW_55_759 VGND VPWR sky130_fd_sc_hd__tapvpwrvgnd_1
XFILLER_80_561 VGND VGND VPWR VPWR sky130_fd_sc_hd__fill_1
XTAP_TAPCELL_ROW_10_306 VGND VPWR sky130_fd_sc_hd__tapvpwrvgnd_1
XFILLER_20_193 VGND VGND VPWR VPWR sky130_fd_sc_hd__decap_3
XFILLER_57_64 VGND VGND VPWR VPWR sky130_fd_sc_hd__decap_4
XFILLER_71_561 VGND VGND VPWR VPWR sky130_fd_sc_hd__fill_1
XFILLER_16_477 VGND VGND VPWR VPWR sky130_fd_sc_hd__fill_1
XTAP_TAPCELL_ROW_26_461 VGND VPWR sky130_fd_sc_hd__tapvpwrvgnd_1
XFILLER_31_436 VGND VGND VPWR VPWR sky130_fd_sc_hd__fill_2
XPHY_EDGE_ROW_44_Left_139 VGND VGND VPWR VPWR sky130_fd_sc_hd__decap_3
Xhold109 array\[2\]\[23\] VGND VGND VPWR VPWR net875 sky130_fd_sc_hd__dlygate4sd3_1
X_3320_ net586 net173 VGND VGND VPWR VPWR _1395_ sky130_fd_sc_hd__and2_1
X_3251_ net595 net485 net181 net733 _1346_ VGND VGND VPWR VPWR _1347_ sky130_fd_sc_hd__a221o_1
X_2202_ net217 _0610_ VGND VGND VPWR VPWR _0611_ sky130_fd_sc_hd__nand2_1
X_3182_ _0626_ _1144_ _1293_ _1297_ VGND VGND VPWR VPWR _1300_ sky130_fd_sc_hd__and4_4
XFILLER_66_344 VGND VGND VPWR VPWR sky130_fd_sc_hd__decap_4
XFILLER_66_333 VGND VGND VPWR VPWR sky130_fd_sc_hd__decap_3
XPHY_EDGE_ROW_53_Left_148 VGND VGND VPWR VPWR sky130_fd_sc_hd__decap_3
XFILLER_19_271 VGND VGND VPWR VPWR sky130_fd_sc_hd__decap_3
XTAP_TAPCELL_ROW_52_729 VGND VPWR sky130_fd_sc_hd__tapvpwrvgnd_1
X_2966_ _0586_ _0855_ VGND VGND VPWR VPWR _1148_ sky130_fd_sc_hd__nor2_1
X_2897_ net1177 net199 _1098_ VGND VGND VPWR VPWR _0082_ sky130_fd_sc_hd__o21a_1
X_4705_ clknet_leaf_4_clk _0236_ VGND VGND VPWR VPWR array\[11\]\[6\] sky130_fd_sc_hd__dfxtp_1
XPHY_EDGE_ROW_62_Left_157 VGND VGND VPWR VPWR sky130_fd_sc_hd__decap_3
X_4636_ clknet_leaf_58_clk _0167_ VGND VGND VPWR VPWR array\[13\]\[1\] sky130_fd_sc_hd__dfxtp_1
X_4567_ clknet_leaf_54_clk _0098_ VGND VGND VPWR VPWR array\[0\]\[28\] sky130_fd_sc_hd__dfxtp_1
X_3518_ net760 net474 net361 net631 net253 VGND VGND VPWR VPWR _1532_ sky130_fd_sc_hd__a221o_1
X_4498_ clknet_leaf_35_clk _0029_ VGND VGND VPWR VPWR array\[5\]\[23\] sky130_fd_sc_hd__dfxtp_1
X_3449_ net600 net478 net363 net674 VGND VGND VPWR VPWR _1483_ sky130_fd_sc_hd__a22o_1
XFILLER_94_29 VPWR VGND VPWR VGND sky130_ef_sc_hd__decap_12
XPHY_EDGE_ROW_71_Left_166 VGND VGND VPWR VPWR sky130_fd_sc_hd__decap_3
XTAP_TAPCELL_ROW_68_884 VGND VPWR sky130_fd_sc_hd__tapvpwrvgnd_1
XFILLER_72_325 VGND VGND VPWR VPWR sky130_fd_sc_hd__decap_6
XTAP_TAPCELL_ROW_80_1006 VGND VPWR sky130_fd_sc_hd__tapvpwrvgnd_1
XFILLER_13_425 VGND VGND VPWR VPWR sky130_fd_sc_hd__decap_3
XFILLER_53_561 VGND VGND VPWR VPWR sky130_fd_sc_hd__fill_1
XFILLER_13_458 VPWR VGND VPWR VGND sky130_ef_sc_hd__decap_12
XTAP_TAPCELL_ROW_23_431 VGND VPWR sky130_fd_sc_hd__tapvpwrvgnd_1
XFILLER_40_233 VGND VGND VPWR VPWR sky130_fd_sc_hd__decap_8
XPHY_EDGE_ROW_80_Left_175 VGND VGND VPWR VPWR sky130_fd_sc_hd__decap_3
XFILLER_9_418 VPWR VGND VPWR VGND sky130_ef_sc_hd__decap_12
XFILLER_40_277 VGND VGND VPWR VPWR sky130_fd_sc_hd__decap_6
XTAP_TAPCELL_ROW_91_1113 VGND VPWR sky130_fd_sc_hd__tapvpwrvgnd_1
XFILLER_4_27 VGND VGND VPWR VPWR sky130_fd_sc_hd__fill_1
XFILLER_75_163 VGND VGND VPWR VPWR sky130_fd_sc_hd__decap_4
XFILLER_36_506 VGND VGND VPWR VPWR sky130_fd_sc_hd__fill_1
XTAP_TAPCELL_ROW_89_1097 VGND VPWR sky130_fd_sc_hd__tapvpwrvgnd_1
XFILLER_90_133 VGND VGND VPWR VPWR sky130_fd_sc_hd__decap_6
X_2820_ net1200 net284 _1045_ _1046_ VGND VGND VPWR VPWR _0057_ sky130_fd_sc_hd__o22a_1
X_2751_ net816 _0998_ net293 VGND VGND VPWR VPWR _0036_ sky130_fd_sc_hd__mux2_1
X_2682_ net1085 _0952_ net293 VGND VGND VPWR VPWR _0013_ sky130_fd_sc_hd__mux2_1
XFILLER_69_3 VPWR VGND VPWR VGND sky130_ef_sc_hd__decap_12
X_4421_ clknet_leaf_53_clk _0532_ VGND VGND VPWR VPWR array\[3\]\[10\] sky130_fd_sc_hd__dfxtp_1
X_4352_ clknet_leaf_28_clk _0463_ VGND VGND VPWR VPWR array\[1\]\[5\] sky130_fd_sc_hd__dfxtp_1
X_3303_ net568 net484 net369 net638 net179 VGND VGND VPWR VPWR _1384_ sky130_fd_sc_hd__a221o_1
X_4283_ net755 net336 VGND VGND VPWR VPWR _2138_ sky130_fd_sc_hd__and2_1
Xfanout419 net422 VGND VGND VPWR VPWR net419 sky130_fd_sc_hd__clkbuf_4
Xfanout408 net409 VGND VGND VPWR VPWR net408 sky130_fd_sc_hd__clkbuf_4
X_3234_ net776 _1335_ net160 VGND VGND VPWR VPWR _0182_ sky130_fd_sc_hd__mux2_1
XFILLER_94_461 VGND VGND VPWR VPWR sky130_fd_sc_hd__decap_4
XFILLER_66_141 VGND VGND VPWR VPWR sky130_fd_sc_hd__decap_6
X_3165_ net955 net162 _1286_ VGND VGND VPWR VPWR _0162_ sky130_fd_sc_hd__o21a_1
XFILLER_81_111 VGND VGND VPWR VPWR sky130_fd_sc_hd__fill_1
X_3096_ net893 net163 _1240_ VGND VGND VPWR VPWR _0139_ sky130_fd_sc_hd__o21a_1
XFILLER_54_325 VGND VGND VPWR VPWR sky130_fd_sc_hd__fill_1
XTAP_TAPCELL_ROW_65_854 VGND VPWR sky130_fd_sc_hd__tapvpwrvgnd_1
XFILLER_35_561 VGND VGND VPWR VPWR sky130_fd_sc_hd__fill_1
XTAP_TAPCELL_ROW_37_578 VGND VPWR sky130_fd_sc_hd__tapvpwrvgnd_1
XFILLER_50_542 VGND VGND VPWR VPWR sky130_fd_sc_hd__fill_1
XFILLER_10_417 VGND VGND VPWR VPWR sky130_fd_sc_hd__decap_3
X_3998_ array\[2\]\[20\] net459 net442 array\[0\]\[20\] VGND VGND VPWR VPWR _1917_
+ sky130_fd_sc_hd__a22o_1
X_2949_ net576 net646 net499 VGND VGND VPWR VPWR _1133_ sky130_fd_sc_hd__mux2_1
XTAP_TAPCELL_ROW_20_401 VGND VPWR sky130_fd_sc_hd__tapvpwrvgnd_1
X_4619_ clknet_leaf_26_clk _0150_ VGND VGND VPWR VPWR array\[14\]\[16\] sky130_fd_sc_hd__dfxtp_1
XFILLER_89_222 VGND VGND VPWR VPWR sky130_fd_sc_hd__fill_2
Xhold451 array\[14\]\[21\] VGND VGND VPWR VPWR net1217 sky130_fd_sc_hd__dlygate4sd3_1
Xhold462 array\[7\]\[14\] VGND VGND VPWR VPWR net1228 sky130_fd_sc_hd__dlygate4sd3_1
Xhold440 array\[0\]\[1\] VGND VGND VPWR VPWR net1206 sky130_fd_sc_hd__dlygate4sd3_1
Xhold495 array\[9\]\[10\] VGND VGND VPWR VPWR net1261 sky130_fd_sc_hd__dlygate4sd3_1
Xhold473 array\[7\]\[22\] VGND VGND VPWR VPWR net1239 sky130_fd_sc_hd__dlygate4sd3_1
Xhold484 array\[6\]\[28\] VGND VGND VPWR VPWR net1250 sky130_fd_sc_hd__dlygate4sd3_1
XFILLER_77_417 VGND VGND VPWR VPWR sky130_fd_sc_hd__decap_4
XFILLER_49_108 VGND VGND VPWR VPWR sky130_fd_sc_hd__decap_4
XFILLER_49_119 VPWR VGND VPWR VGND sky130_ef_sc_hd__decap_12
XFILLER_57_152 VGND VGND VPWR VPWR sky130_fd_sc_hd__fill_2
XFILLER_72_177 VGND VGND VPWR VPWR sky130_fd_sc_hd__decap_6
XFILLER_13_211 VPWR VGND VPWR VGND sky130_ef_sc_hd__decap_12
XTAP_TAPCELL_ROW_0_192 VGND VPWR sky130_fd_sc_hd__tapvpwrvgnd_1
XFILLER_70_53 VGND VGND VPWR VPWR sky130_fd_sc_hd__decap_8
XFILLER_5_410 VPWR VGND VPWR VGND sky130_ef_sc_hd__decap_12
Xclkload18 clknet_leaf_46_clk VGND VGND VPWR VPWR clkload18/Y sky130_fd_sc_hd__clkinv_2
Xclkload29 clknet_leaf_5_clk VGND VGND VPWR VPWR clkload29/Y sky130_fd_sc_hd__clkinvlp_4
XTAP_TAPCELL_ROW_8_281 VGND VPWR sky130_fd_sc_hd__tapvpwrvgnd_1
XFILLER_91_420 VPWR VGND VPWR VGND sky130_ef_sc_hd__decap_12
XFILLER_36_347 VGND VGND VPWR VPWR sky130_fd_sc_hd__decap_3
XFILLER_17_561 VGND VGND VPWR VPWR sky130_fd_sc_hd__fill_1
XTAP_TAPCELL_ROW_62_824 VGND VPWR sky130_fd_sc_hd__tapvpwrvgnd_1
X_3921_ net353 _1840_ _1844_ net416 VGND VGND VPWR VPWR _1847_ sky130_fd_sc_hd__a22o_1
XFILLER_32_531 VGND VGND VPWR VPWR sky130_fd_sc_hd__fill_1
XTAP_TAPCELL_ROW_34_548 VGND VPWR sky130_fd_sc_hd__tapvpwrvgnd_1
X_3852_ net351 _1777_ _1781_ net435 VGND VGND VPWR VPWR _1784_ sky130_fd_sc_hd__a22o_1
X_2803_ net998 net283 _1034_ _1035_ VGND VGND VPWR VPWR _0051_ sky130_fd_sc_hd__o22a_1
X_3783_ array\[9\]\[1\] net544 net528 array\[11\]\[1\] _1720_ VGND VGND VPWR VPWR
+ _1721_ sky130_fd_sc_hd__a221o_1
X_2734_ net664 net590 net393 VGND VGND VPWR VPWR _0987_ sky130_fd_sc_hd__mux2_1
X_2665_ net647 net577 net393 VGND VGND VPWR VPWR _0941_ sky130_fd_sc_hd__mux2_1
X_2596_ net1134 net298 _0892_ _0893_ VGND VGND VPWR VPWR _0566_ sky130_fd_sc_hd__o22a_1
X_4404_ clknet_leaf_40_clk _0515_ VGND VGND VPWR VPWR array\[2\]\[25\] sky130_fd_sc_hd__dfxtp_1
X_4335_ _1293_ _1597_ VGND VGND VPWR VPWR _2171_ sky130_fd_sc_hd__nand2_1
Xfanout205 net206 VGND VGND VPWR VPWR net205 sky130_fd_sc_hd__buf_4
Xfanout227 net228 VGND VGND VPWR VPWR net227 sky130_fd_sc_hd__clkbuf_2
Xfanout238 net240 VGND VGND VPWR VPWR net238 sky130_fd_sc_hd__buf_4
Xfanout216 _0605_ VGND VGND VPWR VPWR net216 sky130_fd_sc_hd__clkbuf_4
Xfanout249 _1512_ VGND VGND VPWR VPWR net249 sky130_fd_sc_hd__clkbuf_4
X_4266_ net704 net335 VGND VGND VPWR VPWR _2127_ sky130_fd_sc_hd__and2_1
X_3217_ net694 net373 VGND VGND VPWR VPWR _1324_ sky130_fd_sc_hd__and2_1
X_4197_ net921 net227 _2080_ VGND VGND VPWR VPWR _0404_ sky130_fd_sc_hd__o21a_1
XFILLER_39_152 VGND VGND VPWR VPWR sky130_fd_sc_hd__decap_3
XFILLER_67_494 VGND VGND VPWR VPWR sky130_fd_sc_hd__fill_2
X_3148_ net594 net492 net377 net668 VGND VGND VPWR VPWR _1275_ sky130_fd_sc_hd__a22o_1
X_3079_ net625 net489 net375 net697 VGND VGND VPWR VPWR _1229_ sky130_fd_sc_hd__a22o_1
XFILLER_35_391 VGND VGND VPWR VPWR sky130_fd_sc_hd__fill_1
XFILLER_23_553 VGND VGND VPWR VPWR sky130_fd_sc_hd__fill_1
XFILLER_24_57 VGND VGND VPWR VPWR sky130_fd_sc_hd__fill_1
XFILLER_24_79 VGND VGND VPWR VPWR sky130_fd_sc_hd__decap_4
XFILLER_50_394 VGND VGND VPWR VPWR sky130_fd_sc_hd__decap_3
Xhold270 array\[2\]\[16\] VGND VGND VPWR VPWR net1036 sky130_fd_sc_hd__dlygate4sd3_1
XFILLER_2_457 VPWR VGND VPWR VGND sky130_ef_sc_hd__decap_12
XFILLER_49_10 VPWR VGND VPWR VGND sky130_ef_sc_hd__decap_12
Xhold292 array\[9\]\[25\] VGND VGND VPWR VPWR net1058 sky130_fd_sc_hd__dlygate4sd3_1
Xhold281 array\[9\]\[20\] VGND VGND VPWR VPWR net1047 sky130_fd_sc_hd__dlygate4sd3_1
Xfanout750 net13 VGND VGND VPWR VPWR net750 sky130_fd_sc_hd__clkbuf_2
Xfanout761 net101 VGND VGND VPWR VPWR net761 sky130_fd_sc_hd__dlymetal6s2s_1
XTAP_TAPCELL_ROW_5_251 VGND VPWR sky130_fd_sc_hd__tapvpwrvgnd_1
XFILLER_1_39 VGND VGND VPWR VPWR sky130_fd_sc_hd__fill_1
XFILLER_18_303 VGND VGND VPWR VPWR sky130_fd_sc_hd__decap_4
XFILLER_85_291 VPWR VGND VPWR VGND sky130_ef_sc_hd__decap_12
XFILLER_45_122 VGND VGND VPWR VPWR sky130_fd_sc_hd__decap_3
XTAP_TAPCELL_ROW_86_1067 VGND VPWR sky130_fd_sc_hd__tapvpwrvgnd_1
XANTENNA_132 _2045_ VGND VGND VPWR VPWR sky130_fd_sc_hd__diode_2
XANTENNA_121 net508 VGND VGND VPWR VPWR sky130_fd_sc_hd__diode_2
XANTENNA_110 net419 VGND VGND VPWR VPWR sky130_fd_sc_hd__diode_2
XANTENNA_143 net299 VGND VGND VPWR VPWR sky130_fd_sc_hd__diode_2
XFILLER_60_103 VGND VGND VPWR VPWR sky130_fd_sc_hd__fill_1
XANTENNA_165 net542 VGND VGND VPWR VPWR sky130_fd_sc_hd__diode_2
XANTENNA_154 net472 VGND VGND VPWR VPWR sky130_fd_sc_hd__diode_2
XFILLER_14_531 VGND VGND VPWR VPWR sky130_fd_sc_hd__fill_1
XFILLER_45_188 VGND VGND VPWR VPWR sky130_fd_sc_hd__decap_4
XANTENNA_176 net192 VGND VGND VPWR VPWR sky130_fd_sc_hd__diode_2
XTAP_TAPCELL_ROW_31_518 VGND VPWR sky130_fd_sc_hd__tapvpwrvgnd_1
X_2450_ net944 _0791_ net204 VGND VGND VPWR VPWR _0522_ sky130_fd_sc_hd__mux2_1
X_2381_ net617 net689 net520 VGND VGND VPWR VPWR _0742_ sky130_fd_sc_hd__mux2_1
X_4120_ array\[6\]\[31\] net466 net449 array\[4\]\[31\] VGND VGND VPWR VPWR _2028_
+ sky130_fd_sc_hd__a22o_1
X_4051_ array\[9\]\[25\] net553 net531 array\[11\]\[25\] _1964_ VGND VGND VPWR VPWR
+ _1965_ sky130_fd_sc_hd__a221o_1
X_3002_ net696 net624 net493 VGND VGND VPWR VPWR _1174_ sky130_fd_sc_hd__mux2_1
Xinput5 enable_write[2] VGND VGND VPWR VPWR net5 sky130_fd_sc_hd__buf_1
XFILLER_64_453 VGND VGND VPWR VPWR sky130_fd_sc_hd__fill_1
XFILLER_36_122 VGND VGND VPWR VPWR sky130_fd_sc_hd__fill_2
XFILLER_64_475 VGND VGND VPWR VPWR sky130_fd_sc_hd__fill_1
XTAP_TAPCELL_ROW_47_673 VGND VPWR sky130_fd_sc_hd__tapvpwrvgnd_1
XTAP_TAPCELL_ROW_19_397 VGND VPWR sky130_fd_sc_hd__tapvpwrvgnd_1
X_3904_ array\[14\]\[12\] net462 net445 array\[12\]\[12\] VGND VGND VPWR VPWR _1831_
+ sky130_fd_sc_hd__a22o_1
XFILLER_51_169 VGND VGND VPWR VPWR sky130_fd_sc_hd__decap_3
X_4884_ clknet_leaf_22_clk _0415_ VGND VGND VPWR VPWR array\[7\]\[27\] sky130_fd_sc_hd__dfxtp_1
X_3835_ array\[10\]\[6\] net461 net444 array\[8\]\[6\] VGND VGND VPWR VPWR _1768_
+ sky130_fd_sc_hd__a22o_1
X_3766_ array\[9\]\[0\] net543 net526 array\[11\]\[0\] _1704_ VGND VGND VPWR VPWR
+ _1705_ sky130_fd_sc_hd__a221o_1
X_2717_ net742 net289 _0975_ net387 VGND VGND VPWR VPWR _0976_ sky130_fd_sc_hd__a22o_1
X_3697_ net760 net426 net346 net631 net244 VGND VGND VPWR VPWR _1660_ sky130_fd_sc_hd__a221o_1
X_2648_ net812 net298 _0926_ _0927_ VGND VGND VPWR VPWR _0004_ sky130_fd_sc_hd__o22a_1
X_2579_ net1025 net297 _0881_ _0882_ VGND VGND VPWR VPWR _0560_ sky130_fd_sc_hd__o22a_1
X_4318_ net725 net336 VGND VGND VPWR VPWR _2160_ sky130_fd_sc_hd__and2_1
X_4249_ net1307 net218 _2115_ _2116_ VGND VGND VPWR VPWR _0420_ sky130_fd_sc_hd__o22a_1
XFILLER_59_258 VGND VGND VPWR VPWR sky130_fd_sc_hd__decap_3
XFILLER_59_269 VGND VGND VPWR VPWR sky130_fd_sc_hd__decap_8
XTAP_TAPCELL_ROW_2_221 VGND VPWR sky130_fd_sc_hd__tapvpwrvgnd_1
XFILLER_19_79 VGND VGND VPWR VPWR sky130_fd_sc_hd__decap_3
XFILLER_55_453 VGND VGND VPWR VPWR sky130_fd_sc_hd__fill_1
XFILLER_7_505 VPWR VGND VPWR VGND sky130_ef_sc_hd__decap_12
XFILLER_51_77 VGND VGND VPWR VPWR sky130_fd_sc_hd__fill_1
XFILLER_2_232 VPWR VGND VPWR VGND sky130_ef_sc_hd__decap_12
XFILLER_78_545 VPWR VGND VPWR VGND sky130_ef_sc_hd__decap_12
XFILLER_76_85 VPWR VGND VPWR VGND sky130_ef_sc_hd__decap_12
XFILLER_76_74 VGND VGND VPWR VPWR sky130_fd_sc_hd__fill_1
Xfanout591 net87 VGND VGND VPWR VPWR net591 sky130_fd_sc_hd__buf_2
Xfanout580 net92 VGND VGND VPWR VPWR net580 sky130_fd_sc_hd__dlymetal6s2s_1
XFILLER_93_559 VGND VGND VPWR VPWR sky130_fd_sc_hd__fill_1
XFILLER_33_169 VGND VGND VPWR VPWR sky130_fd_sc_hd__fill_1
XTAP_TAPCELL_ROW_44_643 VGND VPWR sky130_fd_sc_hd__tapvpwrvgnd_1
XTAP_TAPCELL_ROW_16_367 VGND VPWR sky130_fd_sc_hd__tapvpwrvgnd_1
X_3620_ _1218_ _1597_ VGND VGND VPWR VPWR _1602_ sky130_fd_sc_hd__nand2_1
X_3551_ net1276 net249 _1552_ _1553_ VGND VGND VPWR VPWR _0281_ sky130_fd_sc_hd__o22a_1
X_2502_ net680 net606 net515 VGND VGND VPWR VPWR _0826_ sky130_fd_sc_hd__mux2_1
X_3482_ net713 net257 VGND VGND VPWR VPWR _1505_ sky130_fd_sc_hd__and2_1
XFILLER_51_3 VGND VGND VPWR VPWR sky130_fd_sc_hd__fill_1
X_2433_ net715 net317 _0776_ net409 net314 VGND VGND VPWR VPWR _0777_ sky130_fd_sc_hd__a221o_1
X_2364_ net703 net315 _0730_ net406 net312 VGND VGND VPWR VPWR _0731_ sky130_fd_sc_hd__a221o_1
XFILLER_84_504 VPWR VGND VPWR VGND sky130_ef_sc_hd__decap_12
X_4103_ net215 _2011_ _2012_ VGND VGND VPWR VPWR _2013_ sky130_fd_sc_hd__or3_1
X_2295_ net741 net319 _0681_ net410 net327 VGND VGND VPWR VPWR _0682_ sky130_fd_sc_hd__a221o_1
XFILLER_37_431 VGND VGND VPWR VPWR sky130_fd_sc_hd__decap_6
X_4034_ net436 _1943_ _1947_ net352 VGND VGND VPWR VPWR _1950_ sky130_fd_sc_hd__a22o_1
XFILLER_12_309 VGND VGND VPWR VPWR sky130_fd_sc_hd__fill_2
XANTENNA_21 _1221_ VGND VGND VPWR VPWR sky130_fd_sc_hd__diode_2
X_4867_ clknet_leaf_45_clk _0398_ VGND VGND VPWR VPWR array\[7\]\[10\] sky130_fd_sc_hd__dfxtp_1
XANTENNA_32 _1301_ VGND VGND VPWR VPWR sky130_fd_sc_hd__diode_2
XANTENNA_10 _0869_ VGND VGND VPWR VPWR sky130_fd_sc_hd__diode_2
XANTENNA_65 net176 VGND VGND VPWR VPWR sky130_fd_sc_hd__diode_2
XANTENNA_43 _1611_ VGND VGND VPWR VPWR sky130_fd_sc_hd__diode_2
XANTENNA_54 _2047_ VGND VGND VPWR VPWR sky130_fd_sc_hd__diode_2
X_3818_ array\[1\]\[4\] net551 net531 array\[3\]\[4\] _1752_ VGND VGND VPWR VPWR _1753_
+ sky130_fd_sc_hd__a221o_1
X_4798_ clknet_leaf_21_clk _0329_ VGND VGND VPWR VPWR array\[9\]\[16\] sky130_fd_sc_hd__dfxtp_1
XANTENNA_76 net192 VGND VGND VPWR VPWR sky130_fd_sc_hd__diode_2
XANTENNA_87 net339 VGND VGND VPWR VPWR sky130_fd_sc_hd__diode_2
XANTENNA_98 net378 VGND VGND VPWR VPWR sky130_fd_sc_hd__diode_2
X_3749_ net1115 net240 _1692_ _1693_ VGND VGND VPWR VPWR _0339_ sky130_fd_sc_hd__o22a_1
Xoutput150 net150 VGND VGND VPWR VPWR out[8] sky130_fd_sc_hd__buf_2
XFILLER_87_353 VGND VGND VPWR VPWR sky130_fd_sc_hd__decap_6
XFILLER_47_206 VGND VGND VPWR VPWR sky130_fd_sc_hd__fill_1
XFILLER_75_559 VGND VGND VPWR VPWR sky130_fd_sc_hd__fill_1
XFILLER_62_209 VGND VGND VPWR VPWR sky130_fd_sc_hd__decap_6
XFILLER_55_272 VGND VGND VPWR VPWR sky130_fd_sc_hd__fill_1
XTAP_TAPCELL_ROW_83_1037 VGND VPWR sky130_fd_sc_hd__tapvpwrvgnd_1
XTAP_TAPCELL_ROW_41_613 VGND VPWR sky130_fd_sc_hd__tapvpwrvgnd_1
XTAP_TAPCELL_ROW_13_337 VGND VPWR sky130_fd_sc_hd__tapvpwrvgnd_1
XFILLER_7_27 VPWR VGND VPWR VGND sky130_ef_sc_hd__decap_12
XFILLER_7_49 VGND VGND VPWR VPWR sky130_fd_sc_hd__decap_6
XFILLER_7_379 VGND VGND VPWR VPWR sky130_fd_sc_hd__decap_4
XTAP_TAPCELL_ROW_94_1155 VGND VPWR sky130_fd_sc_hd__tapvpwrvgnd_1
XTAP_TAPCELL_ROW_94_1144 VGND VPWR sky130_fd_sc_hd__tapvpwrvgnd_1
XFILLER_3_541 VPWR VGND VPWR VGND sky130_ef_sc_hd__decap_12
XFILLER_87_51 VGND VGND VPWR VPWR sky130_fd_sc_hd__decap_4
XFILLER_19_420 VGND VGND VPWR VPWR sky130_fd_sc_hd__fill_1
XFILLER_34_401 VGND VGND VPWR VPWR sky130_fd_sc_hd__decap_3
XFILLER_46_261 VGND VGND VPWR VPWR sky130_fd_sc_hd__decap_3
XFILLER_61_220 VGND VGND VPWR VPWR sky130_fd_sc_hd__decap_4
XTAP_TAPCELL_ROW_29_492 VGND VPWR sky130_fd_sc_hd__tapvpwrvgnd_1
X_2982_ net711 net195 _1160_ net381 VGND VGND VPWR VPWR _1161_ sky130_fd_sc_hd__a22o_1
X_4721_ clknet_leaf_57_clk _0252_ VGND VGND VPWR VPWR array\[11\]\[22\] sky130_fd_sc_hd__dfxtp_1
X_4652_ clknet_leaf_25_clk _0183_ VGND VGND VPWR VPWR array\[13\]\[17\] sky130_fd_sc_hd__dfxtp_1
Xinput30 value0[30] VGND VGND VPWR VPWR net30 sky130_fd_sc_hd__clkbuf_1
X_3603_ net561 net560 VGND VGND VPWR VPWR _1589_ sky130_fd_sc_hd__nand2b_2
Xinput41 value1[11] VGND VGND VPWR VPWR net41 sky130_fd_sc_hd__buf_1
X_4583_ clknet_leaf_15_clk _0114_ VGND VGND VPWR VPWR array\[15\]\[12\] sky130_fd_sc_hd__dfxtp_1
Xinput63 value1[31] VGND VGND VPWR VPWR net63 sky130_fd_sc_hd__buf_1
Xinput52 value1[21] VGND VGND VPWR VPWR net52 sky130_fd_sc_hd__buf_1
Xinput74 value2[12] VGND VGND VPWR VPWR net74 sky130_fd_sc_hd__clkbuf_1
Xinput85 value2[22] VGND VGND VPWR VPWR net85 sky130_fd_sc_hd__buf_1
X_3534_ net616 net475 net360 net688 VGND VGND VPWR VPWR _1542_ sky130_fd_sc_hd__a22o_1
Xinput96 value2[3] VGND VGND VPWR VPWR net96 sky130_fd_sc_hd__buf_1
X_3465_ net589 net479 net365 net663 net265 VGND VGND VPWR VPWR _1494_ sky130_fd_sc_hd__a221o_1
XFILLER_88_139 VGND VGND VPWR VPWR sky130_fd_sc_hd__fill_1
X_2416_ net1014 net209 _0765_ VGND VGND VPWR VPWR _0514_ sky130_fd_sc_hd__o21a_1
X_3396_ net577 net479 net365 net647 net266 VGND VGND VPWR VPWR _1448_ sky130_fd_sc_hd__a221o_1
XFILLER_84_301 VGND VGND VPWR VPWR sky130_fd_sc_hd__fill_1
X_2347_ net807 net207 _0719_ VGND VGND VPWR VPWR _0491_ sky130_fd_sc_hd__o21a_1
X_2278_ net1002 net325 _0670_ VGND VGND VPWR VPWR _0471_ sky130_fd_sc_hd__o21a_1
XFILLER_72_518 VGND VGND VPWR VPWR sky130_fd_sc_hd__decap_6
X_4017_ array\[10\]\[22\] net456 net439 array\[8\]\[22\] VGND VGND VPWR VPWR _1934_
+ sky130_fd_sc_hd__a22o_1
XFILLER_25_412 VPWR VGND VPWR VGND sky130_ef_sc_hd__decap_12
XFILLER_52_253 VGND VGND VPWR VPWR sky130_fd_sc_hd__decap_4
XFILLER_12_139 VGND VGND VPWR VPWR sky130_fd_sc_hd__fill_1
XFILLER_40_448 VGND VGND VPWR VPWR sky130_fd_sc_hd__fill_1
X_4919_ clknet_leaf_19_clk _0450_ VGND VGND VPWR VPWR array\[6\]\[30\] sky130_fd_sc_hd__dfxtp_1
XTAP_TAPCELL_ROW_10_307 VGND VPWR sky130_fd_sc_hd__tapvpwrvgnd_1
XFILLER_32_79 VGND VGND VPWR VPWR sky130_fd_sc_hd__fill_2
XFILLER_0_533 VPWR VGND VPWR VGND sky130_ef_sc_hd__decap_12
XFILLER_94_109 VGND VGND VPWR VPWR sky130_fd_sc_hd__decap_3
XFILLER_75_334 VGND VGND VPWR VPWR sky130_fd_sc_hd__fill_2
XFILLER_75_378 VGND VGND VPWR VPWR sky130_fd_sc_hd__fill_1
XFILLER_73_31 VGND VGND VPWR VPWR sky130_fd_sc_hd__fill_1
XTAP_TAPCELL_ROW_26_462 VGND VPWR sky130_fd_sc_hd__tapvpwrvgnd_1
X_3250_ net669 net371 VGND VGND VPWR VPWR _1346_ sky130_fd_sc_hd__and2_1
XFILLER_3_393 VPWR VGND VPWR VGND sky130_ef_sc_hd__decap_12
X_2201_ net559 net526 VGND VGND VPWR VPWR _0610_ sky130_fd_sc_hd__xnor2_1
X_3181_ net653 _1295_ _1298_ VGND VGND VPWR VPWR _1299_ sky130_fd_sc_hd__or3_4
XFILLER_78_172 VGND VGND VPWR VPWR sky130_fd_sc_hd__fill_1
XFILLER_14_3 VPWR VGND VPWR VGND sky130_ef_sc_hd__decap_12
X_4704_ clknet_leaf_32_clk _0235_ VGND VGND VPWR VPWR array\[11\]\[5\] sky130_fd_sc_hd__dfxtp_1
X_2965_ net525 _1140_ net267 VGND VGND VPWR VPWR _1147_ sky130_fd_sc_hd__and3_1
X_2896_ net765 net274 _1097_ net384 net268 VGND VGND VPWR VPWR _1098_ sky130_fd_sc_hd__a221o_1
XFILLER_8_81 VGND VGND VPWR VPWR sky130_fd_sc_hd__decap_3
X_4635_ clknet_leaf_59_clk _0166_ VGND VGND VPWR VPWR array\[13\]\[0\] sky130_fd_sc_hd__dfxtp_1
X_4566_ clknet_leaf_26_clk _0097_ VGND VGND VPWR VPWR array\[0\]\[27\] sky130_fd_sc_hd__dfxtp_1
X_3517_ net701 net247 VGND VGND VPWR VPWR _1531_ sky130_fd_sc_hd__and2_1
X_4497_ clknet_leaf_2_clk _0028_ VGND VGND VPWR VPWR array\[5\]\[22\] sky130_fd_sc_hd__dfxtp_1
X_3448_ net1148 net259 _1482_ VGND VGND VPWR VPWR _0249_ sky130_fd_sc_hd__o21a_1
X_3379_ net574 net483 net368 net644 net178 VGND VGND VPWR VPWR _1434_ sky130_fd_sc_hd__a221o_1
XFILLER_57_334 VGND VGND VPWR VPWR sky130_fd_sc_hd__fill_2
XFILLER_57_345 VGND VGND VPWR VPWR sky130_fd_sc_hd__fill_1
XFILLER_57_367 VPWR VGND VPWR VGND sky130_ef_sc_hd__decap_12
XFILLER_84_197 VGND VGND VPWR VPWR sky130_fd_sc_hd__fill_1
XFILLER_84_186 VGND VGND VPWR VPWR sky130_fd_sc_hd__fill_2
XTAP_TAPCELL_ROW_68_885 VGND VPWR sky130_fd_sc_hd__tapvpwrvgnd_1
XFILLER_27_57 VGND VGND VPWR VPWR sky130_fd_sc_hd__decap_8
XTAP_TAPCELL_ROW_80_1007 VGND VPWR sky130_fd_sc_hd__tapvpwrvgnd_1
XTAP_TAPCELL_ROW_23_432 VGND VPWR sky130_fd_sc_hd__tapvpwrvgnd_1
XTAP_TAPCELL_ROW_91_1114 VGND VPWR sky130_fd_sc_hd__tapvpwrvgnd_1
XFILLER_88_470 VGND VGND VPWR VPWR sky130_fd_sc_hd__decap_6
XFILLER_68_64 VGND VGND VPWR VPWR sky130_fd_sc_hd__decap_4
XFILLER_67_109 VGND VGND VPWR VPWR sky130_fd_sc_hd__decap_3
XFILLER_0_363 VGND VGND VPWR VPWR sky130_fd_sc_hd__fill_1
XFILLER_84_41 VPWR VGND VPWR VGND sky130_ef_sc_hd__decap_12
XTAP_TAPCELL_ROW_89_1098 VGND VPWR sky130_fd_sc_hd__tapvpwrvgnd_1
XFILLER_63_337 VGND VGND VPWR VPWR sky130_fd_sc_hd__fill_1
XFILLER_84_85 VPWR VGND VPWR VGND sky130_ef_sc_hd__decap_12
XFILLER_16_253 VGND VGND VPWR VPWR sky130_fd_sc_hd__fill_1
X_2750_ net715 net289 _0997_ net388 VGND VGND VPWR VPWR _0998_ sky130_fd_sc_hd__a22o_1
X_2681_ net704 net289 _0951_ net387 VGND VGND VPWR VPWR _0952_ sky130_fd_sc_hd__a22o_1
X_4420_ clknet_leaf_52_clk _0531_ VGND VGND VPWR VPWR array\[3\]\[9\] sky130_fd_sc_hd__dfxtp_1
X_4351_ clknet_leaf_40_clk _0462_ VGND VGND VPWR VPWR array\[1\]\[4\] sky130_fd_sc_hd__dfxtp_1
X_3302_ net708 net175 VGND VGND VPWR VPWR _1383_ sky130_fd_sc_hd__and2_1
X_4282_ net1052 net219 _2136_ _2137_ VGND VGND VPWR VPWR _0432_ sky130_fd_sc_hd__o22a_1
Xfanout409 _0710_ VGND VGND VPWR VPWR net409 sky130_fd_sc_hd__buf_4
X_3233_ net612 net488 net184 net748 _1334_ VGND VGND VPWR VPWR _1335_ sky130_fd_sc_hd__a221o_1
XFILLER_86_429 VGND VGND VPWR VPWR sky130_fd_sc_hd__fill_2
XFILLER_39_334 VGND VGND VPWR VPWR sky130_fd_sc_hd__fill_2
X_3164_ net721 net186 _1285_ net190 VGND VGND VPWR VPWR _1286_ sky130_fd_sc_hd__a211o_1
X_3095_ net708 net187 _1239_ net191 VGND VGND VPWR VPWR _1240_ sky130_fd_sc_hd__a211o_1
XFILLER_66_197 VGND VGND VPWR VPWR sky130_fd_sc_hd__fill_2
XTAP_TAPCELL_ROW_65_855 VGND VPWR sky130_fd_sc_hd__tapvpwrvgnd_1
XTAP_TAPCELL_ROW_37_579 VGND VPWR sky130_fd_sc_hd__tapvpwrvgnd_1
XFILLER_22_223 VGND VGND VPWR VPWR sky130_fd_sc_hd__decap_4
XFILLER_13_15 VPWR VGND VPWR VGND sky130_ef_sc_hd__decap_12
XFILLER_22_267 VGND VGND VPWR VPWR sky130_fd_sc_hd__fill_2
X_3997_ array\[13\]\[20\] net546 net534 array\[15\]\[20\] _1915_ VGND VGND VPWR VPWR
+ _1916_ sky130_fd_sc_hd__a221o_1
XTAP_TAPCELL_ROW_20_402 VGND VPWR sky130_fd_sc_hd__tapvpwrvgnd_1
X_2948_ net1294 net200 _1132_ VGND VGND VPWR VPWR _0099_ sky130_fd_sc_hd__o21a_1
X_2879_ net1236 net199 _1086_ VGND VGND VPWR VPWR _0076_ sky130_fd_sc_hd__o21a_1
X_4618_ clknet_leaf_33_clk _0149_ VGND VGND VPWR VPWR array\[14\]\[15\] sky130_fd_sc_hd__dfxtp_1
Xhold463 array\[0\]\[13\] VGND VGND VPWR VPWR net1229 sky130_fd_sc_hd__dlygate4sd3_1
Xhold430 array\[10\]\[18\] VGND VGND VPWR VPWR net1196 sky130_fd_sc_hd__dlygate4sd3_1
Xhold441 array\[12\]\[22\] VGND VGND VPWR VPWR net1207 sky130_fd_sc_hd__dlygate4sd3_1
X_4549_ clknet_leaf_53_clk _0080_ VGND VGND VPWR VPWR array\[0\]\[10\] sky130_fd_sc_hd__dfxtp_1
Xhold452 array\[4\]\[2\] VGND VGND VPWR VPWR net1218 sky130_fd_sc_hd__dlygate4sd3_1
Xhold496 array\[12\]\[7\] VGND VGND VPWR VPWR net1262 sky130_fd_sc_hd__dlygate4sd3_1
Xhold485 array\[6\]\[2\] VGND VGND VPWR VPWR net1251 sky130_fd_sc_hd__dlygate4sd3_1
Xhold474 array\[12\]\[24\] VGND VGND VPWR VPWR net1240 sky130_fd_sc_hd__dlygate4sd3_1
XFILLER_89_289 VGND VGND VPWR VPWR sky130_fd_sc_hd__decap_6
XFILLER_77_429 VGND VGND VPWR VPWR sky130_fd_sc_hd__fill_1
XFILLER_18_529 VGND VGND VPWR VPWR sky130_fd_sc_hd__decap_3
XFILLER_54_33 VGND VGND VPWR VPWR sky130_fd_sc_hd__fill_1
XFILLER_60_329 VGND VGND VPWR VPWR sky130_fd_sc_hd__decap_3
XFILLER_13_223 VGND VGND VPWR VPWR sky130_fd_sc_hd__fill_1
XTAP_TAPCELL_ROW_0_193 VGND VPWR sky130_fd_sc_hd__tapvpwrvgnd_1
XFILLER_41_521 VGND VGND VPWR VPWR sky130_fd_sc_hd__fill_2
XFILLER_41_543 VGND VGND VPWR VPWR sky130_fd_sc_hd__fill_1
XFILLER_13_256 VGND VGND VPWR VPWR sky130_fd_sc_hd__decap_3
XFILLER_5_422 VPWR VGND VPWR VGND sky130_ef_sc_hd__decap_12
Xclkload19 clknet_leaf_47_clk VGND VGND VPWR VPWR clkload19/Y sky130_fd_sc_hd__clkinvlp_4
XFILLER_79_30 VPWR VGND VPWR VGND sky130_ef_sc_hd__decap_12
XTAP_TAPCELL_ROW_8_282 VGND VPWR sky130_fd_sc_hd__tapvpwrvgnd_1
XFILLER_0_182 VGND VGND VPWR VPWR sky130_fd_sc_hd__decap_3
XFILLER_63_123 VGND VGND VPWR VPWR sky130_fd_sc_hd__fill_1
XFILLER_91_476 VPWR VGND VPWR VGND sky130_ef_sc_hd__decap_12
X_3920_ array\[9\]\[13\] net546 net534 array\[11\]\[13\] _1845_ VGND VGND VPWR VPWR
+ _1846_ sky130_fd_sc_hd__a221o_1
XTAP_TAPCELL_ROW_62_825 VGND VPWR sky130_fd_sc_hd__tapvpwrvgnd_1
XTAP_TAPCELL_ROW_34_549 VGND VPWR sky130_fd_sc_hd__tapvpwrvgnd_1
X_3851_ array\[13\]\[7\] net543 net526 array\[15\]\[7\] _1782_ VGND VGND VPWR VPWR
+ _1783_ sky130_fd_sc_hd__a221o_1
XFILLER_81_3 VPWR VGND VPWR VGND sky130_ef_sc_hd__decap_12
X_2802_ net618 net504 net276 net690 net286 VGND VGND VPWR VPWR _1035_ sky130_fd_sc_hd__a221o_1
X_3782_ array\[10\]\[1\] net457 net440 array\[8\]\[1\] VGND VGND VPWR VPWR _1720_
+ sky130_fd_sc_hd__a22o_1
X_2733_ net808 _0986_ net296 VGND VGND VPWR VPWR _0030_ sky130_fd_sc_hd__mux2_1
X_2664_ net974 _0940_ net293 VGND VGND VPWR VPWR _0007_ sky130_fd_sc_hd__mux2_1
X_2595_ net619 net510 net395 net691 net300 VGND VGND VPWR VPWR _0893_ sky130_fd_sc_hd__a221o_1
X_4403_ clknet_leaf_37_clk _0514_ VGND VGND VPWR VPWR array\[2\]\[24\] sky130_fd_sc_hd__dfxtp_1
X_4334_ net959 net220 _2169_ _2170_ VGND VGND VPWR VPWR _0451_ sky130_fd_sc_hd__o22a_1
Xfanout217 _0602_ VGND VGND VPWR VPWR net217 sky130_fd_sc_hd__buf_2
Xfanout206 _0788_ VGND VGND VPWR VPWR net206 sky130_fd_sc_hd__clkbuf_4
Xfanout228 _2048_ VGND VGND VPWR VPWR net228 sky130_fd_sc_hd__clkbuf_4
X_4265_ net1107 net218 _2125_ _2126_ VGND VGND VPWR VPWR _0426_ sky130_fd_sc_hd__o22a_1
Xfanout239 net240 VGND VGND VPWR VPWR net239 sky130_fd_sc_hd__clkbuf_2
X_4196_ net747 net236 net232 _2079_ VGND VGND VPWR VPWR _2080_ sky130_fd_sc_hd__a211o_1
X_3216_ net833 _1323_ net158 VGND VGND VPWR VPWR _0176_ sky130_fd_sc_hd__mux2_1
XTAP_TAPCELL_ROW_78_980 VGND VPWR sky130_fd_sc_hd__tapvpwrvgnd_1
X_3147_ net1237 net161 _1274_ VGND VGND VPWR VPWR _0156_ sky130_fd_sc_hd__o21a_1
XFILLER_82_421 VGND VGND VPWR VPWR sky130_fd_sc_hd__fill_2
XFILLER_27_337 VGND VGND VPWR VPWR sky130_fd_sc_hd__decap_3
X_3078_ net489 _1222_ _1150_ VGND VGND VPWR VPWR _1228_ sky130_fd_sc_hd__and3b_1
Xhold271 array\[0\]\[11\] VGND VGND VPWR VPWR net1037 sky130_fd_sc_hd__dlygate4sd3_1
Xhold260 array\[15\]\[23\] VGND VGND VPWR VPWR net1026 sky130_fd_sc_hd__dlygate4sd3_1
Xhold293 array\[1\]\[30\] VGND VGND VPWR VPWR net1059 sky130_fd_sc_hd__dlygate4sd3_1
XFILLER_2_469 VGND VGND VPWR VPWR sky130_fd_sc_hd__decap_6
XFILLER_49_22 VPWR VGND VPWR VGND sky130_ef_sc_hd__decap_12
Xhold282 array\[6\]\[20\] VGND VGND VPWR VPWR net1048 sky130_fd_sc_hd__dlygate4sd3_1
Xfanout740 net18 VGND VGND VPWR VPWR net740 sky130_fd_sc_hd__clkbuf_2
Xfanout751 net12 VGND VGND VPWR VPWR net751 sky130_fd_sc_hd__buf_2
XTAP_TAPCELL_ROW_5_252 VGND VPWR sky130_fd_sc_hd__tapvpwrvgnd_1
Xfanout762 net100 VGND VGND VPWR VPWR net762 sky130_fd_sc_hd__buf_2
XFILLER_45_101 VGND VGND VPWR VPWR sky130_fd_sc_hd__fill_1
XFILLER_85_281 VGND VGND VPWR VPWR sky130_fd_sc_hd__fill_2
XFILLER_65_65 VGND VGND VPWR VPWR sky130_fd_sc_hd__decap_6
XFILLER_65_43 VPWR VGND VPWR VGND sky130_ef_sc_hd__decap_12
XFILLER_18_348 VGND VGND VPWR VPWR sky130_fd_sc_hd__decap_4
XFILLER_18_359 VGND VGND VPWR VPWR sky130_fd_sc_hd__decap_4
XANTENNA_100 net394 VGND VGND VPWR VPWR sky130_fd_sc_hd__diode_2
XTAP_TAPCELL_ROW_86_1068 VGND VPWR sky130_fd_sc_hd__tapvpwrvgnd_1
XANTENNA_122 net508 VGND VGND VPWR VPWR sky130_fd_sc_hd__diode_2
XANTENNA_111 net419 VGND VGND VPWR VPWR sky130_fd_sc_hd__diode_2
XANTENNA_133 _2047_ VGND VGND VPWR VPWR sky130_fd_sc_hd__diode_2
XANTENNA_166 net542 VGND VGND VPWR VPWR sky130_fd_sc_hd__diode_2
XANTENNA_155 net476 VGND VGND VPWR VPWR sky130_fd_sc_hd__diode_2
XANTENNA_144 net299 VGND VGND VPWR VPWR sky130_fd_sc_hd__diode_2
XANTENNA_177 net202 VGND VGND VPWR VPWR sky130_fd_sc_hd__diode_2
XTAP_TAPCELL_ROW_31_519 VGND VPWR sky130_fd_sc_hd__tapvpwrvgnd_1
XFILLER_5_241 VGND VGND VPWR VPWR sky130_fd_sc_hd__fill_1
XFILLER_5_285 VGND VGND VPWR VPWR sky130_fd_sc_hd__fill_1
XFILLER_46_6 VPWR VGND VPWR VGND sky130_ef_sc_hd__decap_12
X_2380_ net981 net207 _0741_ VGND VGND VPWR VPWR _0502_ sky130_fd_sc_hd__o21a_1
X_4050_ array\[10\]\[25\] net466 net449 array\[8\]\[25\] VGND VGND VPWR VPWR _1964_
+ sky130_fd_sc_hd__a22o_1
X_3001_ net818 _1173_ net165 VGND VGND VPWR VPWR _0111_ sky130_fd_sc_hd__mux2_1
Xinput6 reset VGND VGND VPWR VPWR net6 sky130_fd_sc_hd__buf_1
XFILLER_76_281 VPWR VGND VPWR VGND sky130_ef_sc_hd__decap_12
XFILLER_64_421 VGND VGND VPWR VPWR sky130_fd_sc_hd__fill_2
XTAP_TAPCELL_ROW_75_950 VGND VPWR sky130_fd_sc_hd__tapvpwrvgnd_1
XTAP_TAPCELL_ROW_47_674 VGND VPWR sky130_fd_sc_hd__tapvpwrvgnd_1
XFILLER_17_381 VGND VGND VPWR VPWR sky130_fd_sc_hd__fill_1
XTAP_TAPCELL_ROW_19_398 VGND VPWR sky130_fd_sc_hd__tapvpwrvgnd_1
X_3903_ array\[1\]\[12\] net547 net537 array\[3\]\[12\] _1829_ VGND VGND VPWR VPWR
+ _1830_ sky130_fd_sc_hd__a221o_1
X_4883_ clknet_leaf_16_clk _0414_ VGND VGND VPWR VPWR array\[7\]\[26\] sky130_fd_sc_hd__dfxtp_1
X_3834_ array\[5\]\[6\] net546 net534 array\[7\]\[6\] _1766_ VGND VGND VPWR VPWR _1767_
+ sky130_fd_sc_hd__a221o_1
X_3765_ array\[10\]\[0\] net456 net439 array\[8\]\[0\] VGND VGND VPWR VPWR _1704_
+ sky130_fd_sc_hd__a22o_1
X_3696_ net701 net349 net421 VGND VGND VPWR VPWR _1659_ sky130_fd_sc_hd__and3_1
X_2716_ net678 net604 net391 VGND VGND VPWR VPWR _0975_ sky130_fd_sc_hd__mux2_1
X_2647_ net575 _0858_ net396 net645 net301 VGND VGND VPWR VPWR _0927_ sky130_fd_sc_hd__a221o_1
XFILLER_87_502 VGND VGND VPWR VPWR sky130_fd_sc_hd__fill_2
X_2578_ net565 net509 net395 net635 net300 VGND VGND VPWR VPWR _0882_ sky130_fd_sc_hd__a221o_1
X_4317_ net1285 net223 net337 net727 _2159_ VGND VGND VPWR VPWR _0445_ sky130_fd_sc_hd__a221o_1
XFILLER_59_237 VGND VGND VPWR VPWR sky130_fd_sc_hd__decap_6
X_4248_ net626 net427 net335 net630 net221 VGND VGND VPWR VPWR _2116_ sky130_fd_sc_hd__a221o_1
XFILLER_74_218 VGND VGND VPWR VPWR sky130_fd_sc_hd__decap_6
XTAP_TAPCELL_ROW_2_222 VGND VPWR sky130_fd_sc_hd__tapvpwrvgnd_1
XFILLER_55_410 VGND VGND VPWR VPWR sky130_fd_sc_hd__decap_8
X_4179_ net624 net433 net342 net696 VGND VGND VPWR VPWR _2069_ sky130_fd_sc_hd__a22o_1
XFILLER_35_13 VPWR VGND VPWR VGND sky130_ef_sc_hd__decap_12
XPHY_EDGE_ROW_14_Right_14 VGND VGND VPWR VPWR sky130_fd_sc_hd__decap_3
Xclkbuf_3_3__f_clk clknet_0_clk VGND VGND VPWR VPWR clknet_3_3__leaf_clk sky130_fd_sc_hd__clkbuf_16
XFILLER_7_517 VPWR VGND VPWR VGND sky130_ef_sc_hd__decap_12
XFILLER_2_244 VGND VGND VPWR VPWR sky130_fd_sc_hd__decap_8
XFILLER_2_277 VPWR VGND VPWR VGND sky130_ef_sc_hd__decap_12
XPHY_EDGE_ROW_23_Right_23 VGND VGND VPWR VPWR sky130_fd_sc_hd__decap_3
XFILLER_93_505 VPWR VGND VPWR VGND sky130_ef_sc_hd__decap_12
XFILLER_78_557 VGND VGND VPWR VPWR sky130_fd_sc_hd__decap_4
Xfanout592 net87 VGND VGND VPWR VPWR net592 sky130_fd_sc_hd__clkbuf_2
Xfanout581 net91 VGND VGND VPWR VPWR net581 sky130_fd_sc_hd__buf_2
Xfanout570 net97 VGND VGND VPWR VPWR net570 sky130_fd_sc_hd__clkbuf_2
XFILLER_76_97 VGND VGND VPWR VPWR sky130_fd_sc_hd__decap_8
XFILLER_46_421 VGND VGND VPWR VPWR sky130_fd_sc_hd__decap_3
XFILLER_92_41 VPWR VGND VPWR VGND sky130_ef_sc_hd__decap_12
XTAP_TAPCELL_ROW_72_920 VGND VPWR sky130_fd_sc_hd__tapvpwrvgnd_1
XFILLER_92_85 VPWR VGND VPWR VGND sky130_ef_sc_hd__decap_12
XPHY_EDGE_ROW_32_Right_32 VGND VGND VPWR VPWR sky130_fd_sc_hd__decap_3
XTAP_TAPCELL_ROW_44_644 VGND VPWR sky130_fd_sc_hd__tapvpwrvgnd_1
XTAP_TAPCELL_ROW_16_368 VGND VPWR sky130_fd_sc_hd__tapvpwrvgnd_1
X_3550_ net603 net473 net359 net677 net254 VGND VGND VPWR VPWR _1553_ sky130_fd_sc_hd__a221o_1
X_2501_ net894 net206 _0825_ VGND VGND VPWR VPWR _0539_ sky130_fd_sc_hd__o21a_1
XFILLER_6_561 VGND VGND VPWR VPWR sky130_fd_sc_hd__fill_1
X_3481_ net1188 net262 _1503_ _1504_ VGND VGND VPWR VPWR _0260_ sky130_fd_sc_hd__o22a_1
X_2432_ net575 net645 net519 VGND VGND VPWR VPWR _0776_ sky130_fd_sc_hd__mux2_1
XFILLER_69_502 VGND VGND VPWR VPWR sky130_fd_sc_hd__fill_2
XPHY_EDGE_ROW_41_Right_41 VGND VGND VPWR VPWR sky130_fd_sc_hd__decap_3
XFILLER_44_3 VGND VGND VPWR VPWR sky130_fd_sc_hd__fill_1
X_2363_ net762 net633 net517 VGND VGND VPWR VPWR _0730_ sky130_fd_sc_hd__mux2_1
XFILLER_69_546 VGND VGND VPWR VPWR sky130_fd_sc_hd__fill_1
X_4102_ net357 _2006_ _2010_ net417 VGND VGND VPWR VPWR _2012_ sky130_fd_sc_hd__a22o_1
XFILLER_84_516 VPWR VGND VPWR VGND sky130_ef_sc_hd__decap_12
X_2294_ net677 net603 net521 VGND VGND VPWR VPWR _0681_ sky130_fd_sc_hd__mux2_1
X_4033_ array\[13\]\[23\] net556 net539 array\[15\]\[23\] _1948_ VGND VGND VPWR VPWR
+ _1949_ sky130_fd_sc_hd__a221o_1
XPHY_EDGE_ROW_50_Right_50 VGND VGND VPWR VPWR sky130_fd_sc_hd__decap_3
XANTENNA_11 _0936_ VGND VGND VPWR VPWR sky130_fd_sc_hd__diode_2
X_4866_ clknet_leaf_40_clk _0397_ VGND VGND VPWR VPWR array\[7\]\[9\] sky130_fd_sc_hd__dfxtp_1
XANTENNA_22 _1296_ VGND VGND VPWR VPWR sky130_fd_sc_hd__diode_2
XANTENNA_66 net176 VGND VGND VPWR VPWR sky130_fd_sc_hd__diode_2
XANTENNA_55 _2049_ VGND VGND VPWR VPWR sky130_fd_sc_hd__diode_2
XANTENNA_44 _1616_ VGND VGND VPWR VPWR sky130_fd_sc_hd__diode_2
X_3817_ array\[2\]\[4\] net465 net448 array\[0\]\[4\] VGND VGND VPWR VPWR _1752_ sky130_fd_sc_hd__a22o_1
XANTENNA_33 _1368_ VGND VGND VPWR VPWR sky130_fd_sc_hd__diode_2
X_4797_ clknet_leaf_37_clk _0328_ VGND VGND VPWR VPWR array\[9\]\[15\] sky130_fd_sc_hd__dfxtp_1
XANTENNA_77 net197 VGND VGND VPWR VPWR sky130_fd_sc_hd__diode_2
X_3748_ net587 net424 net345 net661 net242 VGND VGND VPWR VPWR _1693_ sky130_fd_sc_hd__a221o_1
XANTENNA_88 net350 VGND VGND VPWR VPWR sky130_fd_sc_hd__diode_2
XFILLER_21_26 VGND VGND VPWR VPWR sky130_fd_sc_hd__decap_3
XANTENNA_99 net394 VGND VGND VPWR VPWR sky130_fd_sc_hd__diode_2
X_3679_ net718 _1641_ _1647_ net243 VGND VGND VPWR VPWR _1648_ sky130_fd_sc_hd__a211o_1
Xoutput140 net140 VGND VGND VPWR VPWR out[28] sky130_fd_sc_hd__buf_2
Xoutput151 net151 VGND VGND VPWR VPWR out[9] sky130_fd_sc_hd__buf_2
XFILLER_87_387 VGND VGND VPWR VPWR sky130_fd_sc_hd__decap_4
XFILLER_87_365 VGND VGND VPWR VPWR sky130_fd_sc_hd__fill_1
XFILLER_46_45 VGND VGND VPWR VPWR sky130_fd_sc_hd__fill_1
XFILLER_55_240 VPWR VGND VPWR VGND sky130_ef_sc_hd__decap_12
XTAP_TAPCELL_ROW_83_1038 VGND VPWR sky130_fd_sc_hd__tapvpwrvgnd_1
XFILLER_43_446 VGND VGND VPWR VPWR sky130_fd_sc_hd__fill_2
XTAP_TAPCELL_ROW_41_614 VGND VPWR sky130_fd_sc_hd__tapvpwrvgnd_1
XTAP_TAPCELL_ROW_13_338 VGND VPWR sky130_fd_sc_hd__tapvpwrvgnd_1
Xclkbuf_leaf_50_clk clknet_3_2__leaf_clk VGND VGND VPWR VPWR clknet_leaf_50_clk sky130_fd_sc_hd__clkbuf_8
XFILLER_7_39 VGND VGND VPWR VPWR sky130_fd_sc_hd__decap_3
XTAP_TAPCELL_ROW_94_1156 VGND VPWR sky130_fd_sc_hd__tapvpwrvgnd_1
XTAP_TAPCELL_ROW_94_1145 VGND VPWR sky130_fd_sc_hd__tapvpwrvgnd_1
XFILLER_3_553 VGND VGND VPWR VPWR sky130_fd_sc_hd__decap_6
XFILLER_93_368 VGND VGND VPWR VPWR sky130_fd_sc_hd__fill_1
XFILLER_19_476 VGND VGND VPWR VPWR sky130_fd_sc_hd__fill_1
XTAP_TAPCELL_ROW_29_493 VGND VPWR sky130_fd_sc_hd__tapvpwrvgnd_1
X_2981_ net641 net571 net495 VGND VGND VPWR VPWR _1160_ sky130_fd_sc_hd__mux2_1
X_4720_ clknet_leaf_2_clk _0251_ VGND VGND VPWR VPWR array\[11\]\[21\] sky130_fd_sc_hd__dfxtp_1
Xclkbuf_leaf_41_clk clknet_3_3__leaf_clk VGND VGND VPWR VPWR clknet_leaf_41_clk sky130_fd_sc_hd__clkbuf_8
X_4651_ clknet_leaf_26_clk _0182_ VGND VGND VPWR VPWR array\[13\]\[16\] sky130_fd_sc_hd__dfxtp_1
Xinput31 value0[31] VGND VGND VPWR VPWR net31 sky130_fd_sc_hd__buf_1
X_3602_ net561 net560 VGND VGND VPWR VPWR _1588_ sky130_fd_sc_hd__and2b_1
Xinput20 value0[21] VGND VGND VPWR VPWR net20 sky130_fd_sc_hd__buf_1
Xinput42 value1[12] VGND VGND VPWR VPWR net42 sky130_fd_sc_hd__clkbuf_1
X_4582_ clknet_leaf_14_clk _0113_ VGND VGND VPWR VPWR array\[15\]\[11\] sky130_fd_sc_hd__dfxtp_1
Xinput53 value1[22] VGND VGND VPWR VPWR net53 sky130_fd_sc_hd__buf_1
Xinput64 value1[3] VGND VGND VPWR VPWR net64 sky130_fd_sc_hd__buf_1
Xinput75 value2[13] VGND VGND VPWR VPWR net75 sky130_fd_sc_hd__buf_1
Xinput97 value2[4] VGND VGND VPWR VPWR net97 sky130_fd_sc_hd__buf_1
Xinput86 value2[23] VGND VGND VPWR VPWR net86 sky130_fd_sc_hd__buf_1
X_3533_ net1054 net250 _1541_ VGND VGND VPWR VPWR _0275_ sky130_fd_sc_hd__o21a_1
X_3464_ net727 net257 VGND VGND VPWR VPWR _1493_ sky130_fd_sc_hd__and2_1
X_2415_ net729 net317 _0764_ net409 net314 VGND VGND VPWR VPWR _0765_ sky130_fd_sc_hd__a221o_1
X_3395_ net718 net257 VGND VGND VPWR VPWR _1447_ sky130_fd_sc_hd__and2_1
X_2346_ net739 net315 _0718_ net406 net312 VGND VGND VPWR VPWR _0719_ sky130_fd_sc_hd__a221o_1
XFILLER_84_346 VGND VGND VPWR VPWR sky130_fd_sc_hd__decap_8
X_2277_ net754 net321 _0669_ net412 net329 VGND VGND VPWR VPWR _0670_ sky130_fd_sc_hd__a221o_1
XFILLER_29_229 VGND VGND VPWR VPWR sky130_fd_sc_hd__fill_1
XFILLER_37_251 VGND VGND VPWR VPWR sky130_fd_sc_hd__fill_2
X_4016_ array\[5\]\[22\] net544 net527 array\[7\]\[22\] _1932_ VGND VGND VPWR VPWR
+ _1933_ sky130_fd_sc_hd__a221o_1
XFILLER_25_424 VGND VGND VPWR VPWR sky130_fd_sc_hd__fill_2
Xclkbuf_leaf_32_clk clknet_3_6__leaf_clk VGND VGND VPWR VPWR clknet_leaf_32_clk sky130_fd_sc_hd__clkbuf_8
X_4918_ clknet_leaf_55_clk _0449_ VGND VGND VPWR VPWR array\[6\]\[29\] sky130_fd_sc_hd__dfxtp_1
XTAP_TAPCELL_ROW_10_308 VGND VPWR sky130_fd_sc_hd__tapvpwrvgnd_1
X_4849_ clknet_leaf_62_clk _0380_ VGND VGND VPWR VPWR head\[3\] sky130_fd_sc_hd__dfxtp_2
XFILLER_0_501 VGND VGND VPWR VPWR sky130_fd_sc_hd__decap_3
XFILLER_0_545 VPWR VGND VPWR VGND sky130_ef_sc_hd__decap_12
XFILLER_87_162 VGND VGND VPWR VPWR sky130_fd_sc_hd__decap_6
XTAP_TAPCELL_ROW_26_463 VGND VPWR sky130_fd_sc_hd__tapvpwrvgnd_1
Xclkbuf_leaf_23_clk clknet_3_7__leaf_clk VGND VGND VPWR VPWR clknet_leaf_23_clk sky130_fd_sc_hd__clkbuf_8
XFILLER_31_449 VPWR VGND VPWR VGND sky130_ef_sc_hd__decap_12
XFILLER_22_91 VGND VGND VPWR VPWR sky130_fd_sc_hd__fill_1
XFILLER_3_361 VPWR VGND VPWR VGND sky130_ef_sc_hd__decap_12
X_2200_ net560 net561 VGND VGND VPWR VPWR _0609_ sky130_fd_sc_hd__nand2_2
X_3180_ _0931_ _1150_ net485 VGND VGND VPWR VPWR _1298_ sky130_fd_sc_hd__a21o_1
XFILLER_39_505 VGND VGND VPWR VPWR sky130_fd_sc_hd__decap_3
X_2964_ _1140_ net267 VGND VGND VPWR VPWR _1146_ sky130_fd_sc_hd__nand2_1
XFILLER_22_438 VPWR VGND VPWR VGND sky130_ef_sc_hd__decap_12
Xclkbuf_leaf_14_clk clknet_3_5__leaf_clk VGND VGND VPWR VPWR clknet_leaf_14_clk sky130_fd_sc_hd__clkbuf_8
X_4703_ clknet_leaf_41_clk _0234_ VGND VGND VPWR VPWR array\[11\]\[4\] sky130_fd_sc_hd__dfxtp_1
X_2895_ net620 net692 net500 VGND VGND VPWR VPWR _1097_ sky130_fd_sc_hd__mux2_1
XFILLER_8_93 VGND VGND VPWR VPWR sky130_fd_sc_hd__fill_2
X_4634_ clknet_leaf_47_clk _0165_ VGND VGND VPWR VPWR array\[14\]\[31\] sky130_fd_sc_hd__dfxtp_1
X_4565_ clknet_leaf_16_clk _0096_ VGND VGND VPWR VPWR array\[0\]\[26\] sky130_fd_sc_hd__dfxtp_1
XFILLER_89_405 VPWR VGND VPWR VGND sky130_ef_sc_hd__decap_12
X_3516_ net1126 net249 _1529_ _1530_ VGND VGND VPWR VPWR _0269_ sky130_fd_sc_hd__o22a_1
XPHY_EDGE_ROW_4_Right_4 VGND VGND VPWR VPWR sky130_fd_sc_hd__decap_3
X_4496_ clknet_leaf_2_clk _0027_ VGND VGND VPWR VPWR array\[5\]\[21\] sky130_fd_sc_hd__dfxtp_1
XFILLER_89_449 VGND VGND VPWR VPWR sky130_fd_sc_hd__fill_1
X_3447_ net742 net255 _1481_ net263 VGND VGND VPWR VPWR _1482_ sky130_fd_sc_hd__a211o_1
X_3378_ net714 net174 VGND VGND VPWR VPWR _1433_ sky130_fd_sc_hd__and2_1
XFILLER_84_121 VGND VGND VPWR VPWR sky130_fd_sc_hd__decap_4
X_2329_ net1059 net326 _0704_ VGND VGND VPWR VPWR _0488_ sky130_fd_sc_hd__o21a_1
XFILLER_84_165 VGND VGND VPWR VPWR sky130_fd_sc_hd__decap_4
XTAP_TAPCELL_ROW_68_886 VGND VPWR sky130_fd_sc_hd__tapvpwrvgnd_1
XFILLER_57_379 VGND VGND VPWR VPWR sky130_fd_sc_hd__decap_6
XTAP_TAPCELL_ROW_80_1008 VGND VPWR sky130_fd_sc_hd__tapvpwrvgnd_1
XFILLER_13_449 VGND VGND VPWR VPWR sky130_fd_sc_hd__decap_3
XFILLER_40_224 VGND VGND VPWR VPWR sky130_fd_sc_hd__fill_1
XTAP_TAPCELL_ROW_23_433 VGND VPWR sky130_fd_sc_hd__tapvpwrvgnd_1
XTAP_TAPCELL_ROW_91_1115 VGND VPWR sky130_fd_sc_hd__tapvpwrvgnd_1
XFILLER_84_53 VPWR VGND VPWR VGND sky130_ef_sc_hd__decap_12
XFILLER_63_316 VGND VGND VPWR VPWR sky130_fd_sc_hd__decap_6
XTAP_TAPCELL_ROW_89_1099 VGND VPWR sky130_fd_sc_hd__tapvpwrvgnd_1
XFILLER_84_97 VPWR VGND VPWR VGND sky130_ef_sc_hd__decap_12
XFILLER_71_360 VGND VGND VPWR VPWR sky130_fd_sc_hd__fill_1
XFILLER_44_552 VGND VGND VPWR VPWR sky130_fd_sc_hd__fill_2
X_2680_ net634 net763 net391 VGND VGND VPWR VPWR _0951_ sky130_fd_sc_hd__mux2_1
XFILLER_8_475 VGND VGND VPWR VPWR sky130_fd_sc_hd__fill_1
X_4350_ clknet_leaf_9_clk _0461_ VGND VGND VPWR VPWR array\[1\]\[3\] sky130_fd_sc_hd__dfxtp_1
X_3301_ net1158 net154 _1381_ _1382_ VGND VGND VPWR VPWR _0202_ sky130_fd_sc_hd__o22a_1
X_4281_ net619 net428 net332 net691 net222 VGND VGND VPWR VPWR _2137_ sky130_fd_sc_hd__a221o_1
X_3232_ net684 net374 VGND VGND VPWR VPWR _1334_ sky130_fd_sc_hd__and2_1
Xclkbuf_leaf_3_clk clknet_3_4__leaf_clk VGND VGND VPWR VPWR clknet_leaf_3_clk sky130_fd_sc_hd__clkbuf_8
XFILLER_66_110 VGND VGND VPWR VPWR sky130_fd_sc_hd__decap_6
X_3163_ net581 net491 net376 net657 VGND VGND VPWR VPWR _1285_ sky130_fd_sc_hd__a22o_1
XFILLER_94_441 VGND VGND VPWR VPWR sky130_fd_sc_hd__decap_3
XFILLER_66_132 VGND VGND VPWR VPWR sky130_fd_sc_hd__fill_1
XFILLER_94_496 VGND VGND VPWR VPWR sky130_fd_sc_hd__decap_4
XFILLER_81_113 VPWR VGND VPWR VGND sky130_ef_sc_hd__decap_12
X_3094_ net568 net492 net377 net638 VGND VGND VPWR VPWR _1239_ sky130_fd_sc_hd__a22o_1
XTAP_TAPCELL_ROW_65_856 VGND VPWR sky130_fd_sc_hd__tapvpwrvgnd_1
XFILLER_54_338 VGND VGND VPWR VPWR sky130_fd_sc_hd__fill_1
X_3996_ array\[14\]\[20\] net459 net442 array\[12\]\[20\] VGND VGND VPWR VPWR _1915_
+ sky130_fd_sc_hd__a22o_1
XFILLER_13_27 VPWR VGND VPWR VGND sky130_ef_sc_hd__decap_12
XTAP_TAPCELL_ROW_20_403 VGND VPWR sky130_fd_sc_hd__tapvpwrvgnd_1
X_2947_ net720 net272 _1131_ net385 net269 VGND VGND VPWR VPWR _1132_ sky130_fd_sc_hd__a221o_1
X_4617_ clknet_leaf_0_clk _0148_ VGND VGND VPWR VPWR array\[14\]\[14\] sky130_fd_sc_hd__dfxtp_1
X_2878_ net705 net271 _1085_ net383 net268 VGND VGND VPWR VPWR _1086_ sky130_fd_sc_hd__a221o_1
Xhold420 array\[12\]\[15\] VGND VGND VPWR VPWR net1186 sky130_fd_sc_hd__dlygate4sd3_1
Xhold442 array\[14\]\[27\] VGND VGND VPWR VPWR net1208 sky130_fd_sc_hd__dlygate4sd3_1
X_4548_ clknet_leaf_53_clk _0079_ VGND VGND VPWR VPWR array\[0\]\[9\] sky130_fd_sc_hd__dfxtp_1
Xhold453 array\[4\]\[25\] VGND VGND VPWR VPWR net1219 sky130_fd_sc_hd__dlygate4sd3_1
Xhold431 array\[9\]\[23\] VGND VGND VPWR VPWR net1197 sky130_fd_sc_hd__dlygate4sd3_1
XFILLER_1_128 VPWR VGND VPWR VGND sky130_ef_sc_hd__decap_12
Xhold475 array\[0\]\[22\] VGND VGND VPWR VPWR net1241 sky130_fd_sc_hd__dlygate4sd3_1
Xhold486 array\[4\]\[19\] VGND VGND VPWR VPWR net1252 sky130_fd_sc_hd__dlygate4sd3_1
Xhold464 array\[3\]\[4\] VGND VGND VPWR VPWR net1230 sky130_fd_sc_hd__dlygate4sd3_1
X_4479_ clknet_leaf_43_clk _0010_ VGND VGND VPWR VPWR array\[5\]\[4\] sky130_fd_sc_hd__dfxtp_1
XFILLER_89_279 VGND VGND VPWR VPWR sky130_fd_sc_hd__fill_1
Xhold497 array\[10\]\[17\] VGND VGND VPWR VPWR net1263 sky130_fd_sc_hd__dlygate4sd3_1
XFILLER_38_24 VGND VGND VPWR VPWR sky130_fd_sc_hd__decap_4
XPHY_EDGE_ROW_79_Right_79 VGND VGND VPWR VPWR sky130_fd_sc_hd__decap_3
XFILLER_18_519 VGND VGND VPWR VPWR sky130_fd_sc_hd__fill_2
XTAP_TAPCELL_ROW_0_194 VGND VPWR sky130_fd_sc_hd__tapvpwrvgnd_1
XPHY_EDGE_ROW_88_Right_88 VGND VGND VPWR VPWR sky130_fd_sc_hd__decap_3
XFILLER_5_434 VPWR VGND VPWR VGND sky130_ef_sc_hd__decap_12
XFILLER_79_42 VPWR VGND VPWR VGND sky130_ef_sc_hd__decap_12
XTAP_TAPCELL_ROW_8_283 VGND VPWR sky130_fd_sc_hd__tapvpwrvgnd_1
XFILLER_48_121 VPWR VGND VPWR VGND sky130_ef_sc_hd__decap_12
XFILLER_48_165 VGND VGND VPWR VPWR sky130_fd_sc_hd__decap_3
XFILLER_91_488 VPWR VGND VPWR VGND sky130_ef_sc_hd__decap_12
XFILLER_51_308 VGND VGND VPWR VPWR sky130_fd_sc_hd__fill_1
XTAP_TAPCELL_ROW_62_826 VGND VPWR sky130_fd_sc_hd__tapvpwrvgnd_1
X_3850_ array\[14\]\[7\] net458 net441 array\[12\]\[7\] VGND VGND VPWR VPWR _1782_
+ sky130_fd_sc_hd__a22o_1
X_2801_ net755 net280 VGND VGND VPWR VPWR _1034_ sky130_fd_sc_hd__and2_1
X_3781_ array\[1\]\[1\] net548 net535 array\[3\]\[1\] _1718_ VGND VGND VPWR VPWR _1719_
+ sky130_fd_sc_hd__a221o_1
XFILLER_74_3 VGND VGND VPWR VPWR sky130_fd_sc_hd__decap_8
X_2732_ net729 net292 _0985_ net390 VGND VGND VPWR VPWR _0986_ sky130_fd_sc_hd__a22o_1
X_2663_ net739 net289 _0939_ net387 VGND VGND VPWR VPWR _0940_ sky130_fd_sc_hd__a22o_1
X_2594_ net764 net400 net507 VGND VGND VPWR VPWR _0892_ sky130_fd_sc_hd__and3_1
X_4402_ clknet_leaf_38_clk _0513_ VGND VGND VPWR VPWR array\[2\]\[23\] sky130_fd_sc_hd__dfxtp_1
XFILLER_5_50 VGND VGND VPWR VPWR sky130_fd_sc_hd__fill_2
X_4333_ net573 net429 net333 net643 net223 VGND VGND VPWR VPWR _2170_ sky130_fd_sc_hd__a221o_1
Xfanout229 _2047_ VGND VGND VPWR VPWR net229 sky130_fd_sc_hd__clkbuf_4
Xfanout218 net220 VGND VGND VPWR VPWR net218 sky130_fd_sc_hd__clkbuf_4
Xfanout207 net210 VGND VGND VPWR VPWR net207 sky130_fd_sc_hd__buf_4
X_4264_ net566 net427 net331 net636 net221 VGND VGND VPWR VPWR _2126_ sky130_fd_sc_hd__a221o_1
X_3215_ net624 net486 net181 net608 _1322_ VGND VGND VPWR VPWR _1323_ sky130_fd_sc_hd__a221o_1
X_4195_ net611 net434 net343 net683 VGND VGND VPWR VPWR _2079_ sky130_fd_sc_hd__a22o_1
XFILLER_94_260 VGND VGND VPWR VPWR sky130_fd_sc_hd__fill_2
XTAP_TAPCELL_ROW_78_981 VGND VPWR sky130_fd_sc_hd__tapvpwrvgnd_1
X_3146_ net733 net185 _1273_ net189 VGND VGND VPWR VPWR _1274_ sky130_fd_sc_hd__a211o_1
XFILLER_82_433 VGND VGND VPWR VPWR sky130_fd_sc_hd__fill_1
X_3077_ net525 net267 _1218_ _1223_ VGND VGND VPWR VPWR _1227_ sky130_fd_sc_hd__and4_1
XFILLER_54_179 VGND VGND VPWR VPWR sky130_fd_sc_hd__fill_2
XPHY_EDGE_ROW_59_Left_154 VGND VGND VPWR VPWR sky130_fd_sc_hd__decap_3
XFILLER_35_393 VGND VGND VPWR VPWR sky130_fd_sc_hd__decap_8
XFILLER_50_374 VPWR VGND VPWR VGND sky130_ef_sc_hd__decap_12
X_3979_ net840 net170 _1898_ _1899_ VGND VGND VPWR VPWR _0363_ sky130_fd_sc_hd__o22a_1
Xhold250 array\[2\]\[5\] VGND VGND VPWR VPWR net1016 sky130_fd_sc_hd__dlygate4sd3_1
XPHY_EDGE_ROW_68_Left_163 VGND VGND VPWR VPWR sky130_fd_sc_hd__decap_3
Xhold261 array\[10\]\[20\] VGND VGND VPWR VPWR net1027 sky130_fd_sc_hd__dlygate4sd3_1
Xhold294 array\[12\]\[26\] VGND VGND VPWR VPWR net1060 sky130_fd_sc_hd__dlygate4sd3_1
Xhold272 array\[3\]\[18\] VGND VGND VPWR VPWR net1038 sky130_fd_sc_hd__dlygate4sd3_1
Xhold283 array\[4\]\[13\] VGND VGND VPWR VPWR net1049 sky130_fd_sc_hd__dlygate4sd3_1
XFILLER_49_34 VGND VGND VPWR VPWR sky130_fd_sc_hd__decap_8
Xfanout730 net23 VGND VGND VPWR VPWR net730 sky130_fd_sc_hd__dlymetal6s2s_1
Xfanout741 net17 VGND VGND VPWR VPWR net741 sky130_fd_sc_hd__buf_2
XTAP_TAPCELL_ROW_5_253 VGND VPWR sky130_fd_sc_hd__tapvpwrvgnd_1
Xfanout763 net100 VGND VGND VPWR VPWR net763 sky130_fd_sc_hd__dlymetal6s2s_1
Xfanout752 net12 VGND VGND VPWR VPWR net752 sky130_fd_sc_hd__dlymetal6s2s_1
XFILLER_18_316 VGND VGND VPWR VPWR sky130_fd_sc_hd__fill_1
XFILLER_58_485 VGND VGND VPWR VPWR sky130_fd_sc_hd__decap_6
XFILLER_65_55 VGND VGND VPWR VPWR sky130_fd_sc_hd__fill_1
XTAP_TAPCELL_ROW_86_1069 VGND VPWR sky130_fd_sc_hd__tapvpwrvgnd_1
XPHY_EDGE_ROW_77_Left_172 VGND VGND VPWR VPWR sky130_fd_sc_hd__decap_3
XANTENNA_101 net401 VGND VGND VPWR VPWR sky130_fd_sc_hd__diode_2
XANTENNA_112 net422 VGND VGND VPWR VPWR sky130_fd_sc_hd__diode_2
XANTENNA_134 net156 VGND VGND VPWR VPWR sky130_fd_sc_hd__diode_2
XANTENNA_123 net508 VGND VGND VPWR VPWR sky130_fd_sc_hd__diode_2
XANTENNA_167 net549 VGND VGND VPWR VPWR sky130_fd_sc_hd__diode_2
XANTENNA_156 net483 VGND VGND VPWR VPWR sky130_fd_sc_hd__diode_2
XANTENNA_145 net299 VGND VGND VPWR VPWR sky130_fd_sc_hd__diode_2
XFILLER_14_533 VPWR VGND VPWR VGND sky130_ef_sc_hd__decap_12
XANTENNA_178 net249 VGND VGND VPWR VPWR sky130_fd_sc_hd__diode_2
XPHY_EDGE_ROW_86_Left_181 VGND VGND VPWR VPWR sky130_fd_sc_hd__decap_3
X_3000_ net699 net193 _1172_ net380 VGND VGND VPWR VPWR _1173_ sky130_fd_sc_hd__a22o_1
Xinput7 value0[0] VGND VGND VPWR VPWR net7 sky130_fd_sc_hd__buf_1
XFILLER_76_293 VGND VGND VPWR VPWR sky130_fd_sc_hd__decap_3
XTAP_TAPCELL_ROW_75_951 VGND VPWR sky130_fd_sc_hd__tapvpwrvgnd_1
XFILLER_64_477 VGND VGND VPWR VPWR sky130_fd_sc_hd__fill_2
XTAP_TAPCELL_ROW_19_399 VGND VPWR sky130_fd_sc_hd__tapvpwrvgnd_1
XTAP_TAPCELL_ROW_47_675 VGND VPWR sky130_fd_sc_hd__tapvpwrvgnd_1
X_3902_ array\[2\]\[12\] net462 net445 array\[0\]\[12\] VGND VGND VPWR VPWR _1829_
+ sky130_fd_sc_hd__a22o_1
XFILLER_17_393 VGND VGND VPWR VPWR sky130_fd_sc_hd__fill_1
X_4882_ clknet_leaf_41_clk _0413_ VGND VGND VPWR VPWR array\[7\]\[25\] sky130_fd_sc_hd__dfxtp_1
XFILLER_51_138 VGND VGND VPWR VPWR sky130_fd_sc_hd__fill_1
X_3833_ array\[6\]\[6\] net458 net441 array\[4\]\[6\] VGND VGND VPWR VPWR _1766_ sky130_fd_sc_hd__a22o_1
X_3764_ net930 net238 _1702_ _1703_ VGND VGND VPWR VPWR _0344_ sky130_fd_sc_hd__o22a_1
X_2715_ net961 _0974_ net294 VGND VGND VPWR VPWR _0024_ sky130_fd_sc_hd__mux2_1
X_3695_ net1203 net237 _1657_ _1658_ VGND VGND VPWR VPWR _0320_ sky130_fd_sc_hd__o22a_1
X_2646_ net715 net400 net507 VGND VGND VPWR VPWR _0926_ sky130_fd_sc_hd__and3_1
X_2577_ net705 net399 net506 VGND VGND VPWR VPWR _0881_ sky130_fd_sc_hd__and3_1
X_4316_ net589 net429 net333 net663 VGND VGND VPWR VPWR _2159_ sky130_fd_sc_hd__a22o_1
X_4247_ net698 net331 VGND VGND VPWR VPWR _2115_ sky130_fd_sc_hd__and2_1
X_4178_ net1249 net226 _2067_ _2068_ VGND VGND VPWR VPWR _0397_ sky130_fd_sc_hd__o22a_1
XTAP_TAPCELL_ROW_2_223 VGND VPWR sky130_fd_sc_hd__tapvpwrvgnd_1
XFILLER_27_113 VGND VGND VPWR VPWR sky130_fd_sc_hd__decap_8
X_3129_ net1165 net163 _1262_ VGND VGND VPWR VPWR _0150_ sky130_fd_sc_hd__o21a_1
XFILLER_35_25 VPWR VGND VPWR VGND sky130_ef_sc_hd__decap_12
XFILLER_82_296 VGND VGND VPWR VPWR sky130_fd_sc_hd__decap_3
XFILLER_11_503 VGND VGND VPWR VPWR sky130_fd_sc_hd__fill_1
XFILLER_50_160 VGND VGND VPWR VPWR sky130_fd_sc_hd__fill_2
XFILLER_7_529 VPWR VGND VPWR VGND sky130_ef_sc_hd__decap_12
XFILLER_4_3 VPWR VGND VPWR VGND sky130_ef_sc_hd__decap_12
XFILLER_2_289 VGND VGND VPWR VPWR sky130_fd_sc_hd__decap_8
Xfanout560 head\[1\] VGND VGND VPWR VPWR net560 sky130_fd_sc_hd__buf_2
XFILLER_93_517 VPWR VGND VPWR VGND sky130_ef_sc_hd__decap_12
Xfanout571 net96 VGND VGND VPWR VPWR net571 sky130_fd_sc_hd__buf_2
Xfanout582 net91 VGND VGND VPWR VPWR net582 sky130_fd_sc_hd__dlymetal6s2s_1
Xfanout593 net86 VGND VGND VPWR VPWR net593 sky130_fd_sc_hd__clkbuf_2
XFILLER_46_466 VGND VGND VPWR VPWR sky130_fd_sc_hd__fill_1
XFILLER_92_53 VPWR VGND VPWR VGND sky130_ef_sc_hd__decap_12
XTAP_TAPCELL_ROW_72_921 VGND VPWR sky130_fd_sc_hd__tapvpwrvgnd_1
XFILLER_46_488 VGND VGND VPWR VPWR sky130_fd_sc_hd__fill_1
XFILLER_92_97 VPWR VGND VPWR VGND sky130_ef_sc_hd__decap_12
XTAP_TAPCELL_ROW_44_645 VGND VPWR sky130_fd_sc_hd__tapvpwrvgnd_1
XFILLER_14_374 VPWR VGND VPWR VGND sky130_ef_sc_hd__decap_12
XFILLER_14_363 VGND VGND VPWR VPWR sky130_fd_sc_hd__fill_1
XTAP_TAPCELL_ROW_16_369 VGND VPWR sky130_fd_sc_hd__tapvpwrvgnd_1
X_2500_ net746 net307 _0824_ net404 net311 VGND VGND VPWR VPWR _0825_ sky130_fd_sc_hd__a221o_1
X_3480_ net575 net480 net366 net645 net266 VGND VGND VPWR VPWR _1504_ sky130_fd_sc_hd__a221o_1
X_2431_ net940 net208 _0775_ VGND VGND VPWR VPWR _0519_ sky130_fd_sc_hd__o21a_1
X_2362_ net1145 net207 _0729_ VGND VGND VPWR VPWR _0496_ sky130_fd_sc_hd__o21a_1
X_2293_ net1077 net325 _0680_ VGND VGND VPWR VPWR _0476_ sky130_fd_sc_hd__o21a_1
X_4101_ net352 _2004_ _2008_ net436 VGND VGND VPWR VPWR _2011_ sky130_fd_sc_hd__a22o_1
XFILLER_84_528 VGND VGND VPWR VPWR sky130_fd_sc_hd__decap_4
X_4032_ array\[14\]\[23\] net470 net453 array\[12\]\[23\] VGND VGND VPWR VPWR _1948_
+ sky130_fd_sc_hd__a22o_1
XFILLER_92_561 VGND VGND VPWR VPWR sky130_fd_sc_hd__fill_1
XFILLER_24_105 VGND VGND VPWR VPWR sky130_fd_sc_hd__fill_2
XFILLER_24_149 VGND VGND VPWR VPWR sky130_fd_sc_hd__fill_2
X_4865_ clknet_leaf_32_clk _0396_ VGND VGND VPWR VPWR array\[7\]\[8\] sky130_fd_sc_hd__dfxtp_1
XANTENNA_23 _1296_ VGND VGND VPWR VPWR sky130_fd_sc_hd__diode_2
XANTENNA_12 _1149_ VGND VGND VPWR VPWR sky130_fd_sc_hd__diode_2
XANTENNA_56 _2111_ VGND VGND VPWR VPWR sky130_fd_sc_hd__diode_2
X_3816_ array\[9\]\[4\] net553 net532 array\[11\]\[4\] _1750_ VGND VGND VPWR VPWR
+ _1751_ sky130_fd_sc_hd__a221o_1
X_4796_ clknet_leaf_3_clk _0327_ VGND VGND VPWR VPWR array\[9\]\[14\] sky130_fd_sc_hd__dfxtp_1
XANTENNA_45 _1616_ VGND VGND VPWR VPWR sky130_fd_sc_hd__diode_2
XANTENNA_34 _1435_ VGND VGND VPWR VPWR sky130_fd_sc_hd__diode_2
XANTENNA_67 net176 VGND VGND VPWR VPWR sky130_fd_sc_hd__diode_2
XANTENNA_89 net350 VGND VGND VPWR VPWR sky130_fd_sc_hd__diode_2
XANTENNA_78 net206 VGND VGND VPWR VPWR sky130_fd_sc_hd__diode_2
X_3747_ net725 net350 net420 VGND VGND VPWR VPWR _1692_ sky130_fd_sc_hd__and3_1
XFILLER_21_38 VPWR VGND VPWR VGND sky130_ef_sc_hd__decap_12
X_3678_ net578 net425 net346 net648 VGND VGND VPWR VPWR _1647_ sky130_fd_sc_hd__a22o_1
Xoutput152 net152 VGND VGND VPWR VPWR success sky130_fd_sc_hd__buf_2
Xoutput130 net130 VGND VGND VPWR VPWR out[19] sky130_fd_sc_hd__buf_2
Xoutput141 net141 VGND VGND VPWR VPWR out[29] sky130_fd_sc_hd__buf_2
X_2629_ net729 net401 net508 VGND VGND VPWR VPWR _0915_ sky130_fd_sc_hd__and3_1
XFILLER_83_561 VGND VGND VPWR VPWR sky130_fd_sc_hd__fill_1
XFILLER_83_550 VGND VGND VPWR VPWR sky130_fd_sc_hd__decap_8
XFILLER_55_252 VGND VGND VPWR VPWR sky130_fd_sc_hd__decap_6
XFILLER_15_105 VGND VGND VPWR VPWR sky130_fd_sc_hd__fill_1
XFILLER_28_477 VGND VGND VPWR VPWR sky130_fd_sc_hd__decap_3
XTAP_TAPCELL_ROW_83_1039 VGND VPWR sky130_fd_sc_hd__tapvpwrvgnd_1
XFILLER_62_12 VGND VGND VPWR VPWR sky130_fd_sc_hd__fill_1
XTAP_TAPCELL_ROW_41_615 VGND VPWR sky130_fd_sc_hd__tapvpwrvgnd_1
XFILLER_62_45 VGND VGND VPWR VPWR sky130_fd_sc_hd__fill_1
XFILLER_70_288 VGND VGND VPWR VPWR sky130_fd_sc_hd__fill_1
XTAP_TAPCELL_ROW_13_339 VGND VPWR sky130_fd_sc_hd__tapvpwrvgnd_1
XTAP_TAPCELL_ROW_94_1146 VGND VPWR sky130_fd_sc_hd__tapvpwrvgnd_1
XTAP_TAPCELL_ROW_94_1157 VGND VPWR sky130_fd_sc_hd__tapvpwrvgnd_1
Xfanout390 _0933_ VGND VGND VPWR VPWR net390 sky130_fd_sc_hd__buf_4
XFILLER_93_358 VGND VGND VPWR VPWR sky130_fd_sc_hd__fill_2
XTAP_TAPCELL_ROW_57_770 VGND VPWR sky130_fd_sc_hd__tapvpwrvgnd_1
XTAP_TAPCELL_ROW_29_494 VGND VPWR sky130_fd_sc_hd__tapvpwrvgnd_1
X_2980_ net970 _1159_ net165 VGND VGND VPWR VPWR _0104_ sky130_fd_sc_hd__mux2_1
XFILLER_14_193 VGND VGND VPWR VPWR sky130_fd_sc_hd__decap_3
X_4650_ clknet_leaf_33_clk _0181_ VGND VGND VPWR VPWR array\[13\]\[15\] sky130_fd_sc_hd__dfxtp_1
Xinput10 value0[12] VGND VGND VPWR VPWR net10 sky130_fd_sc_hd__clkbuf_1
X_3601_ tail\[3\] _1578_ _1587_ _0587_ VGND VGND VPWR VPWR _0297_ sky130_fd_sc_hd__o211a_1
Xinput21 value0[22] VGND VGND VPWR VPWR net21 sky130_fd_sc_hd__buf_1
Xinput43 value1[13] VGND VGND VPWR VPWR net43 sky130_fd_sc_hd__buf_1
Xinput32 value0[3] VGND VGND VPWR VPWR net32 sky130_fd_sc_hd__buf_1
X_4581_ clknet_leaf_47_clk _0112_ VGND VGND VPWR VPWR array\[15\]\[10\] sky130_fd_sc_hd__dfxtp_1
Xinput54 value1[23] VGND VGND VPWR VPWR net54 sky130_fd_sc_hd__clkbuf_1
Xinput98 value2[5] VGND VGND VPWR VPWR net98 sky130_fd_sc_hd__buf_1
X_3532_ net755 net246 _1540_ net252 VGND VGND VPWR VPWR _1541_ sky130_fd_sc_hd__a211o_1
Xinput65 value1[4] VGND VGND VPWR VPWR net65 sky130_fd_sc_hd__clkbuf_1
Xinput76 value2[14] VGND VGND VPWR VPWR net76 sky130_fd_sc_hd__clkbuf_1
Xinput87 value2[24] VGND VGND VPWR VPWR net87 sky130_fd_sc_hd__buf_1
X_3463_ net1074 net262 _1491_ _1492_ VGND VGND VPWR VPWR _0254_ sky130_fd_sc_hd__o22a_1
X_2414_ net591 net665 net519 VGND VGND VPWR VPWR _0764_ sky130_fd_sc_hd__mux2_1
XFILLER_69_333 VGND VGND VPWR VPWR sky130_fd_sc_hd__decap_3
X_3394_ net1089 net259 _1446_ VGND VGND VPWR VPWR _0231_ sky130_fd_sc_hd__o21a_1
X_2345_ net601 net675 net517 VGND VGND VPWR VPWR _0718_ sky130_fd_sc_hd__mux2_1
X_2276_ net689 net617 net523 VGND VGND VPWR VPWR _0669_ sky130_fd_sc_hd__mux2_1
XFILLER_37_241 VGND VGND VPWR VPWR sky130_fd_sc_hd__fill_2
X_4015_ array\[6\]\[22\] net457 net440 array\[4\]\[22\] VGND VGND VPWR VPWR _1932_
+ sky130_fd_sc_hd__a22o_1
XFILLER_65_561 VGND VGND VPWR VPWR sky130_fd_sc_hd__fill_1
XFILLER_37_285 VGND VGND VPWR VPWR sky130_fd_sc_hd__fill_1
XFILLER_80_531 VGND VGND VPWR VPWR sky130_fd_sc_hd__fill_1
XFILLER_52_244 VGND VGND VPWR VPWR sky130_fd_sc_hd__fill_2
XFILLER_33_480 VGND VGND VPWR VPWR sky130_fd_sc_hd__decap_8
X_4917_ clknet_leaf_40_clk _0448_ VGND VGND VPWR VPWR array\[6\]\[28\] sky130_fd_sc_hd__dfxtp_1
X_4848_ clknet_leaf_61_clk _0379_ VGND VGND VPWR VPWR head\[2\] sky130_fd_sc_hd__dfxtp_1
XFILLER_20_141 VGND VGND VPWR VPWR sky130_fd_sc_hd__fill_1
XFILLER_32_26 VGND VGND VPWR VPWR sky130_fd_sc_hd__fill_2
XTAP_TAPCELL_ROW_10_309 VGND VPWR sky130_fd_sc_hd__tapvpwrvgnd_1
XFILLER_4_307 VGND VGND VPWR VPWR sky130_fd_sc_hd__fill_1
X_4779_ clknet_leaf_64_clk _0310_ VGND VGND VPWR VPWR ready_check\[2\] sky130_fd_sc_hd__dfxtp_1
XFILLER_0_557 VGND VGND VPWR VPWR sky130_fd_sc_hd__decap_3
XFILLER_75_325 VGND VGND VPWR VPWR sky130_fd_sc_hd__fill_1
XFILLER_75_369 VGND VGND VPWR VPWR sky130_fd_sc_hd__fill_1
XTAP_TAPCELL_ROW_54_740 VGND VPWR sky130_fd_sc_hd__tapvpwrvgnd_1
XTAP_TAPCELL_ROW_26_464 VGND VPWR sky130_fd_sc_hd__tapvpwrvgnd_1
XFILLER_31_428 VGND VGND VPWR VPWR sky130_fd_sc_hd__decap_8
XPHY_EDGE_ROW_13_Left_108 VGND VGND VPWR VPWR sky130_fd_sc_hd__decap_3
XFILLER_3_373 VPWR VGND VPWR VGND sky130_ef_sc_hd__decap_12
XFILLER_21_6 VGND VGND VPWR VPWR sky130_fd_sc_hd__decap_4
XFILLER_93_111 VGND VGND VPWR VPWR sky130_fd_sc_hd__fill_1
XFILLER_93_177 VGND VGND VPWR VPWR sky130_fd_sc_hd__fill_2
XFILLER_47_561 VGND VGND VPWR VPWR sky130_fd_sc_hd__fill_1
XPHY_EDGE_ROW_22_Left_117 VGND VGND VPWR VPWR sky130_fd_sc_hd__decap_3
XFILLER_62_553 VGND VGND VPWR VPWR sky130_fd_sc_hd__fill_1
X_2963_ _1142_ _1143_ VGND VGND VPWR VPWR _1145_ sky130_fd_sc_hd__nand2_1
X_4702_ clknet_leaf_19_clk _0233_ VGND VGND VPWR VPWR array\[11\]\[3\] sky130_fd_sc_hd__dfxtp_1
X_2894_ net1037 net199 _1096_ VGND VGND VPWR VPWR _0081_ sky130_fd_sc_hd__o21a_1
XFILLER_30_461 VGND VGND VPWR VPWR sky130_fd_sc_hd__fill_2
X_4633_ clknet_leaf_25_clk _0164_ VGND VGND VPWR VPWR array\[14\]\[30\] sky130_fd_sc_hd__dfxtp_1
X_4564_ clknet_leaf_40_clk _0095_ VGND VGND VPWR VPWR array\[0\]\[25\] sky130_fd_sc_hd__dfxtp_1
X_3515_ net762 net473 net359 net633 net254 VGND VGND VPWR VPWR _1530_ sky130_fd_sc_hd__a221o_1
XFILLER_89_417 VPWR VGND VPWR VGND sky130_ef_sc_hd__decap_12
XPHY_EDGE_ROW_31_Left_126 VGND VGND VPWR VPWR sky130_fd_sc_hd__decap_3
X_4495_ clknet_leaf_6_clk _0026_ VGND VGND VPWR VPWR array\[5\]\[20\] sky130_fd_sc_hd__dfxtp_1
XFILLER_89_439 VGND VGND VPWR VPWR sky130_fd_sc_hd__fill_1
X_3446_ net604 net477 net363 net678 VGND VGND VPWR VPWR _1481_ sky130_fd_sc_hd__a22o_1
X_3377_ net923 net155 _1431_ _1432_ VGND VGND VPWR VPWR _0228_ sky130_fd_sc_hd__o22a_1
X_2328_ net715 net322 _0703_ net412 net330 VGND VGND VPWR VPWR _0704_ sky130_fd_sc_hd__a221o_1
XFILLER_69_196 VGND VGND VPWR VPWR sky130_fd_sc_hd__fill_1
XFILLER_84_177 VGND VGND VPWR VPWR sky130_fd_sc_hd__fill_1
XTAP_TAPCELL_ROW_68_887 VGND VPWR sky130_fd_sc_hd__tapvpwrvgnd_1
X_2259_ net703 net320 _0657_ net411 net328 VGND VGND VPWR VPWR _0658_ sky130_fd_sc_hd__a221o_1
XFILLER_38_550 VGND VGND VPWR VPWR sky130_fd_sc_hd__fill_1
XFILLER_38_561 VGND VGND VPWR VPWR sky130_fd_sc_hd__fill_1
XFILLER_65_391 VGND VGND VPWR VPWR sky130_fd_sc_hd__fill_1
XPHY_EDGE_ROW_40_Left_135 VGND VGND VPWR VPWR sky130_fd_sc_hd__decap_3
XFILLER_80_361 VGND VGND VPWR VPWR sky130_fd_sc_hd__decap_3
XTAP_TAPCELL_ROW_80_1009 VGND VPWR sky130_fd_sc_hd__tapvpwrvgnd_1
XFILLER_13_417 VGND VGND VPWR VPWR sky130_fd_sc_hd__decap_8
XTAP_TAPCELL_ROW_51_710 VGND VPWR sky130_fd_sc_hd__tapvpwrvgnd_1
XTAP_TAPCELL_ROW_23_434 VGND VPWR sky130_fd_sc_hd__tapvpwrvgnd_1
XTAP_TAPCELL_ROW_91_1116 VGND VPWR sky130_fd_sc_hd__tapvpwrvgnd_1
XFILLER_0_321 VGND VGND VPWR VPWR sky130_fd_sc_hd__decap_4
XFILLER_0_365 VGND VGND VPWR VPWR sky130_fd_sc_hd__fill_2
XFILLER_0_398 VGND VGND VPWR VPWR sky130_fd_sc_hd__decap_4
XFILLER_84_65 VPWR VGND VPWR VGND sky130_ef_sc_hd__decap_12
XFILLER_29_561 VGND VGND VPWR VPWR sky130_fd_sc_hd__fill_1
XFILLER_90_169 VPWR VGND VPWR VGND sky130_ef_sc_hd__decap_12
XFILLER_31_225 VGND VGND VPWR VPWR sky130_fd_sc_hd__decap_3
XFILLER_8_421 VPWR VGND VPWR VGND sky130_ef_sc_hd__decap_12
XFILLER_33_80 VGND VGND VPWR VPWR sky130_fd_sc_hd__decap_6
X_3300_ net570 net483 net368 net640 net178 VGND VGND VPWR VPWR _1382_ sky130_fd_sc_hd__a221o_1
X_4280_ net764 net336 VGND VGND VPWR VPWR _2136_ sky130_fd_sc_hd__and2_1
XFILLER_3_181 VPWR VGND VPWR VGND sky130_ef_sc_hd__decap_12
X_3231_ net881 _1333_ net160 VGND VGND VPWR VPWR _0181_ sky130_fd_sc_hd__mux2_1
X_3162_ net1208 net163 _1284_ VGND VGND VPWR VPWR _0161_ sky130_fd_sc_hd__o21a_1
XFILLER_94_475 VGND VGND VPWR VPWR sky130_fd_sc_hd__fill_1
X_3093_ net1141 net162 _1238_ VGND VGND VPWR VPWR _0138_ sky130_fd_sc_hd__o21a_1
XFILLER_54_306 VGND VGND VPWR VPWR sky130_fd_sc_hd__fill_2
XFILLER_81_125 VGND VGND VPWR VPWR sky130_fd_sc_hd__fill_1
XTAP_TAPCELL_ROW_65_857 VGND VPWR sky130_fd_sc_hd__tapvpwrvgnd_1
XFILLER_47_391 VGND VGND VPWR VPWR sky130_fd_sc_hd__fill_1
XFILLER_81_169 VPWR VGND VPWR VGND sky130_ef_sc_hd__decap_12
X_3995_ array\[9\]\[20\] net548 net534 array\[11\]\[20\] _1913_ VGND VGND VPWR VPWR
+ _1914_ sky130_fd_sc_hd__a221o_1
XFILLER_13_39 VPWR VGND VPWR VGND sky130_ef_sc_hd__decap_12
XTAP_TAPCELL_ROW_20_404 VGND VPWR sky130_fd_sc_hd__tapvpwrvgnd_1
X_2946_ net580 net650 net498 VGND VGND VPWR VPWR _1131_ sky130_fd_sc_hd__mux2_1
X_2877_ net565 net635 net497 VGND VGND VPWR VPWR _1085_ sky130_fd_sc_hd__mux2_1
X_4616_ clknet_leaf_11_clk _0147_ VGND VGND VPWR VPWR array\[14\]\[13\] sky130_fd_sc_hd__dfxtp_1
Xhold410 array\[4\]\[4\] VGND VGND VPWR VPWR net1176 sky130_fd_sc_hd__dlygate4sd3_1
X_4547_ clknet_leaf_27_clk _0078_ VGND VGND VPWR VPWR array\[0\]\[8\] sky130_fd_sc_hd__dfxtp_1
Xhold432 array\[6\]\[17\] VGND VGND VPWR VPWR net1198 sky130_fd_sc_hd__dlygate4sd3_1
Xhold454 array\[10\]\[10\] VGND VGND VPWR VPWR net1220 sky130_fd_sc_hd__dlygate4sd3_1
Xhold443 array\[11\]\[9\] VGND VGND VPWR VPWR net1209 sky130_fd_sc_hd__dlygate4sd3_1
Xhold421 array\[8\]\[6\] VGND VGND VPWR VPWR net1187 sky130_fd_sc_hd__dlygate4sd3_1
XFILLER_89_225 VGND VGND VPWR VPWR sky130_fd_sc_hd__decap_4
XFILLER_89_214 VGND VGND VPWR VPWR sky130_fd_sc_hd__decap_8
Xhold487 array\[9\]\[17\] VGND VGND VPWR VPWR net1253 sky130_fd_sc_hd__dlygate4sd3_1
Xhold476 array\[10\]\[11\] VGND VGND VPWR VPWR net1242 sky130_fd_sc_hd__dlygate4sd3_1
Xhold465 array\[12\]\[3\] VGND VGND VPWR VPWR net1231 sky130_fd_sc_hd__dlygate4sd3_1
X_4478_ clknet_leaf_18_clk _0009_ VGND VGND VPWR VPWR array\[5\]\[3\] sky130_fd_sc_hd__dfxtp_1
X_3429_ net755 net256 _1469_ net264 VGND VGND VPWR VPWR _1470_ sky130_fd_sc_hd__a211o_1
Xhold498 array\[0\]\[20\] VGND VGND VPWR VPWR net1264 sky130_fd_sc_hd__dlygate4sd3_1
XFILLER_85_464 VPWR VGND VPWR VGND sky130_ef_sc_hd__decap_12
XFILLER_45_306 VGND VGND VPWR VPWR sky130_fd_sc_hd__fill_1
XFILLER_57_166 VGND VGND VPWR VPWR sky130_fd_sc_hd__fill_2
XFILLER_13_225 VGND VGND VPWR VPWR sky130_fd_sc_hd__decap_6
XTAP_TAPCELL_ROW_0_195 VGND VPWR sky130_fd_sc_hd__tapvpwrvgnd_1
XFILLER_5_446 VGND VGND VPWR VPWR sky130_fd_sc_hd__fill_2
XFILLER_79_54 VGND VGND VPWR VPWR sky130_fd_sc_hd__fill_2
XFILLER_68_409 VGND VGND VPWR VPWR sky130_fd_sc_hd__decap_3
XTAP_TAPCELL_ROW_8_284 VGND VPWR sky130_fd_sc_hd__tapvpwrvgnd_1
XFILLER_0_195 VGND VGND VPWR VPWR sky130_fd_sc_hd__fill_1
XFILLER_29_391 VGND VGND VPWR VPWR sky130_fd_sc_hd__fill_1
XFILLER_63_169 VGND VGND VPWR VPWR sky130_fd_sc_hd__decap_4
XTAP_TAPCELL_ROW_62_827 VGND VPWR sky130_fd_sc_hd__tapvpwrvgnd_1
X_3780_ array\[2\]\[1\] net461 net444 array\[0\]\[1\] VGND VGND VPWR VPWR _1718_ sky130_fd_sc_hd__a22o_1
X_2800_ net1221 net283 _1032_ _1033_ VGND VGND VPWR VPWR _0050_ sky130_fd_sc_hd__o22a_1
X_2731_ net666 net591 net394 VGND VGND VPWR VPWR _0985_ sky130_fd_sc_hd__mux2_1
XFILLER_8_251 VGND VGND VPWR VPWR sky130_fd_sc_hd__fill_1
XFILLER_67_3 VPWR VGND VPWR VGND sky130_ef_sc_hd__decap_12
X_4401_ clknet_leaf_57_clk _0512_ VGND VGND VPWR VPWR array\[2\]\[22\] sky130_fd_sc_hd__dfxtp_1
X_2662_ net675 net601 net391 VGND VGND VPWR VPWR _0939_ sky130_fd_sc_hd__mux2_1
X_2593_ net1071 net298 _0890_ _0891_ VGND VGND VPWR VPWR _0565_ sky130_fd_sc_hd__o22a_1
X_4332_ net713 net337 VGND VGND VPWR VPWR _2169_ sky130_fd_sc_hd__and2_1
Xfanout208 net209 VGND VGND VPWR VPWR net208 sky130_fd_sc_hd__clkbuf_4
X_4263_ net706 net335 VGND VGND VPWR VPWR _2125_ sky130_fd_sc_hd__and2_1
Xfanout219 net220 VGND VGND VPWR VPWR net219 sky130_fd_sc_hd__clkbuf_2
X_3214_ net696 net372 VGND VGND VPWR VPWR _1322_ sky130_fd_sc_hd__and2_1
X_4194_ net1130 net227 _2077_ _2078_ VGND VGND VPWR VPWR _0403_ sky130_fd_sc_hd__o22a_1
XTAP_TAPCELL_ROW_78_982 VGND VPWR sky130_fd_sc_hd__tapvpwrvgnd_1
XFILLER_67_464 VPWR VGND VPWR VGND sky130_ef_sc_hd__decap_12
X_3145_ net595 net489 net375 net669 VGND VGND VPWR VPWR _1273_ sky130_fd_sc_hd__a22o_1
X_3076_ net653 _1220_ _1224_ VGND VGND VPWR VPWR _1226_ sky130_fd_sc_hd__or3_1
XFILLER_42_309 VGND VGND VPWR VPWR sky130_fd_sc_hd__fill_1
XFILLER_24_27 VGND VGND VPWR VPWR sky130_fd_sc_hd__fill_1
X_3978_ net353 _1893_ _1897_ net356 net214 VGND VGND VPWR VPWR _1899_ sky130_fd_sc_hd__a221o_1
XFILLER_50_386 VGND VGND VPWR VPWR sky130_fd_sc_hd__decap_8
X_2929_ net731 net273 _1119_ net386 net269 VGND VGND VPWR VPWR _1120_ sky130_fd_sc_hd__a221o_1
Xhold262 array\[3\]\[12\] VGND VGND VPWR VPWR net1028 sky130_fd_sc_hd__dlygate4sd3_1
Xhold240 array\[5\]\[13\] VGND VGND VPWR VPWR net1006 sky130_fd_sc_hd__dlygate4sd3_1
Xhold251 array\[10\]\[26\] VGND VGND VPWR VPWR net1017 sky130_fd_sc_hd__dlygate4sd3_1
Xhold284 array\[15\]\[11\] VGND VGND VPWR VPWR net1050 sky130_fd_sc_hd__dlygate4sd3_1
Xhold295 array\[6\]\[16\] VGND VGND VPWR VPWR net1061 sky130_fd_sc_hd__dlygate4sd3_1
Xhold273 array\[12\]\[9\] VGND VGND VPWR VPWR net1039 sky130_fd_sc_hd__dlygate4sd3_1
Xfanout742 net17 VGND VGND VPWR VPWR net742 sky130_fd_sc_hd__dlymetal6s2s_1
Xfanout720 net28 VGND VGND VPWR VPWR net720 sky130_fd_sc_hd__dlymetal6s2s_1
XFILLER_49_79 VGND VGND VPWR VPWR sky130_fd_sc_hd__decap_3
Xfanout731 net22 VGND VGND VPWR VPWR net731 sky130_fd_sc_hd__clkbuf_2
Xfanout764 net10 VGND VGND VPWR VPWR net764 sky130_fd_sc_hd__buf_2
XTAP_TAPCELL_ROW_5_254 VGND VPWR sky130_fd_sc_hd__tapvpwrvgnd_1
Xfanout753 net114 VGND VGND VPWR VPWR net753 sky130_fd_sc_hd__clkbuf_2
XANTENNA_102 net401 VGND VGND VPWR VPWR sky130_fd_sc_hd__diode_2
XANTENNA_124 net533 VGND VGND VPWR VPWR sky130_fd_sc_hd__diode_2
XANTENNA_113 net422 VGND VGND VPWR VPWR sky130_fd_sc_hd__diode_2
XANTENNA_135 net156 VGND VGND VPWR VPWR sky130_fd_sc_hd__diode_2
XANTENNA_146 net326 VGND VGND VPWR VPWR sky130_fd_sc_hd__diode_2
XFILLER_14_501 VPWR VGND VPWR VGND sky130_ef_sc_hd__decap_12
XANTENNA_157 net508 VGND VGND VPWR VPWR sky130_fd_sc_hd__diode_2
XANTENNA_168 net558 VGND VGND VPWR VPWR sky130_fd_sc_hd__diode_2
XFILLER_14_545 VPWR VGND VPWR VGND sky130_ef_sc_hd__decap_12
XANTENNA_179 net299 VGND VGND VPWR VPWR sky130_fd_sc_hd__diode_2
XFILLER_81_77 VGND VGND VPWR VPWR sky130_fd_sc_hd__fill_1
XFILLER_81_55 VGND VGND VPWR VPWR sky130_fd_sc_hd__fill_1
XFILLER_81_99 VPWR VGND VPWR VGND sky130_ef_sc_hd__decap_12
XFILLER_49_442 VGND VGND VPWR VPWR sky130_fd_sc_hd__decap_6
Xinput8 value0[10] VGND VGND VPWR VPWR net8 sky130_fd_sc_hd__buf_1
XTAP_TAPCELL_ROW_75_952 VGND VPWR sky130_fd_sc_hd__tapvpwrvgnd_1
XFILLER_17_361 VPWR VGND VPWR VGND sky130_ef_sc_hd__decap_12
XTAP_TAPCELL_ROW_47_676 VGND VPWR sky130_fd_sc_hd__tapvpwrvgnd_1
X_3901_ net905 net170 _1827_ _1828_ VGND VGND VPWR VPWR _0356_ sky130_fd_sc_hd__o22a_1
X_4881_ clknet_leaf_32_clk _0412_ VGND VGND VPWR VPWR array\[7\]\[24\] sky130_fd_sc_hd__dfxtp_1
XFILLER_32_331 VGND VGND VPWR VPWR sky130_fd_sc_hd__fill_2
X_3832_ net1100 net172 _1764_ _1765_ VGND VGND VPWR VPWR _0350_ sky130_fd_sc_hd__o22a_1
X_3763_ net573 net425 net346 net643 net243 VGND VGND VPWR VPWR _1703_ sky130_fd_sc_hd__a221o_1
XFILLER_20_559 VGND VGND VPWR VPWR sky130_fd_sc_hd__decap_3
X_2714_ net743 net290 _0973_ net388 VGND VGND VPWR VPWR _0974_ sky130_fd_sc_hd__a22o_1
X_3694_ net763 net423 net344 net634 net241 VGND VGND VPWR VPWR _1658_ sky130_fd_sc_hd__a221o_1
X_2645_ net1232 net297 _0925_ VGND VGND VPWR VPWR _0583_ sky130_fd_sc_hd__o21a_1
X_2576_ net1066 net299 _0879_ _0880_ VGND VGND VPWR VPWR _0559_ sky130_fd_sc_hd__o22a_1
X_4315_ net1019 net220 _2157_ _2158_ VGND VGND VPWR VPWR _0444_ sky130_fd_sc_hd__o22a_1
XFILLER_87_559 VGND VGND VPWR VPWR sky130_fd_sc_hd__fill_1
X_4246_ net427 _1620_ VGND VGND VPWR VPWR _2114_ sky130_fd_sc_hd__and2b_2
X_4177_ net759 net433 net342 net628 net231 VGND VGND VPWR VPWR _2068_ sky130_fd_sc_hd__a221o_1
X_3128_ net748 net187 _1261_ net191 VGND VGND VPWR VPWR _1262_ sky130_fd_sc_hd__a211o_1
XTAP_TAPCELL_ROW_2_224 VGND VPWR sky130_fd_sc_hd__tapvpwrvgnd_1
XFILLER_55_434 VGND VGND VPWR VPWR sky130_fd_sc_hd__decap_4
XFILLER_55_445 VGND VGND VPWR VPWR sky130_fd_sc_hd__decap_3
XFILLER_55_467 VGND VGND VPWR VPWR sky130_fd_sc_hd__fill_1
XFILLER_70_404 VPWR VGND VPWR VGND sky130_ef_sc_hd__decap_12
X_3059_ net649 net579 net494 VGND VGND VPWR VPWR _1212_ sky130_fd_sc_hd__mux2_1
XFILLER_35_37 VPWR VGND VPWR VGND sky130_ef_sc_hd__decap_12
XFILLER_11_559 VGND VGND VPWR VPWR sky130_fd_sc_hd__fill_1
Xfanout550 net551 VGND VGND VPWR VPWR net550 sky130_fd_sc_hd__clkbuf_4
XFILLER_93_529 VPWR VGND VPWR VGND sky130_ef_sc_hd__decap_12
Xfanout583 net90 VGND VGND VPWR VPWR net583 sky130_fd_sc_hd__buf_2
Xfanout561 head\[0\] VGND VGND VPWR VPWR net561 sky130_fd_sc_hd__buf_2
Xfanout572 net96 VGND VGND VPWR VPWR net572 sky130_fd_sc_hd__clkbuf_2
Xfanout594 net86 VGND VGND VPWR VPWR net594 sky130_fd_sc_hd__dlymetal6s2s_1
XTAP_TAPCELL_ROW_72_922 VGND VPWR sky130_fd_sc_hd__tapvpwrvgnd_1
XFILLER_92_65 VPWR VGND VPWR VGND sky130_ef_sc_hd__decap_12
XTAP_TAPCELL_ROW_44_646 VGND VPWR sky130_fd_sc_hd__tapvpwrvgnd_1
XFILLER_61_437 VGND VGND VPWR VPWR sky130_fd_sc_hd__decap_6
XFILLER_25_70 VPWR VGND VPWR VGND sky130_ef_sc_hd__decap_12
XFILLER_14_386 VGND VGND VPWR VPWR sky130_fd_sc_hd__decap_4
X_2430_ net719 net316 _0774_ net408 net313 VGND VGND VPWR VPWR _0775_ sky130_fd_sc_hd__a221o_1
X_2361_ net705 net315 _0728_ net406 net312 VGND VGND VPWR VPWR _0729_ sky130_fd_sc_hd__a221o_1
X_2292_ net744 net321 _0679_ net412 net329 VGND VGND VPWR VPWR _0680_ sky130_fd_sc_hd__a221o_1
X_4100_ array\[13\]\[29\] net550 net529 array\[15\]\[29\] _2009_ VGND VGND VPWR VPWR
+ _2010_ sky130_fd_sc_hd__a221o_1
X_4031_ array\[5\]\[23\] net553 net532 array\[7\]\[23\] _1946_ VGND VGND VPWR VPWR
+ _1947_ sky130_fd_sc_hd__a221o_1
XFILLER_56_209 VGND VGND VPWR VPWR sky130_fd_sc_hd__fill_1
XFILLER_2_85 VGND VGND VPWR VPWR sky130_fd_sc_hd__fill_2
XFILLER_64_220 VGND VGND VPWR VPWR sky130_fd_sc_hd__fill_1
XFILLER_64_253 VPWR VGND VPWR VGND sky130_ef_sc_hd__decap_12
XFILLER_52_404 VGND VGND VPWR VPWR sky130_fd_sc_hd__fill_2
XANTENNA_13 _1149_ VGND VGND VPWR VPWR sky130_fd_sc_hd__diode_2
X_4864_ clknet_leaf_2_clk _0395_ VGND VGND VPWR VPWR array\[7\]\[7\] sky130_fd_sc_hd__dfxtp_1
XANTENNA_57 _2111_ VGND VGND VPWR VPWR sky130_fd_sc_hd__diode_2
X_4795_ clknet_leaf_6_clk _0326_ VGND VGND VPWR VPWR array\[9\]\[13\] sky130_fd_sc_hd__dfxtp_1
XANTENNA_35 _1439_ VGND VGND VPWR VPWR sky130_fd_sc_hd__diode_2
X_3815_ array\[10\]\[4\] net466 net449 array\[8\]\[4\] VGND VGND VPWR VPWR _1750_
+ sky130_fd_sc_hd__a22o_1
XANTENNA_46 _1616_ VGND VGND VPWR VPWR sky130_fd_sc_hd__diode_2
XANTENNA_24 _1296_ VGND VGND VPWR VPWR sky130_fd_sc_hd__diode_2
X_3746_ net1058 net238 _1690_ _1691_ VGND VGND VPWR VPWR _0338_ sky130_fd_sc_hd__o22a_1
XANTENNA_79 net245 VGND VGND VPWR VPWR sky130_fd_sc_hd__diode_2
XANTENNA_68 net178 VGND VGND VPWR VPWR sky130_fd_sc_hd__diode_2
XFILLER_9_390 VGND VGND VPWR VPWR sky130_fd_sc_hd__fill_2
X_3677_ net1286 net237 _1645_ _1646_ VGND VGND VPWR VPWR _0314_ sky130_fd_sc_hd__o22a_1
Xoutput120 net120 VGND VGND VPWR VPWR out[0] sky130_fd_sc_hd__buf_2
Xoutput131 net131 VGND VGND VPWR VPWR out[1] sky130_fd_sc_hd__buf_2
Xoutput142 net142 VGND VGND VPWR VPWR out[2] sky130_fd_sc_hd__buf_2
X_2628_ net1258 net302 _0868_ net731 _0914_ VGND VGND VPWR VPWR _0577_ sky130_fd_sc_hd__a221o_1
X_2559_ net509 _0860_ _0861_ VGND VGND VPWR VPWR _0869_ sky130_fd_sc_hd__and3b_2
XFILLER_87_323 VGND VGND VPWR VPWR sky130_fd_sc_hd__fill_2
X_4229_ net583 net434 net343 net659 net232 VGND VGND VPWR VPWR _2102_ sky130_fd_sc_hd__a221o_1
XFILLER_55_297 VGND VGND VPWR VPWR sky130_fd_sc_hd__fill_1
XFILLER_11_312 VGND VGND VPWR VPWR sky130_fd_sc_hd__decap_3
XTAP_TAPCELL_ROW_41_616 VGND VPWR sky130_fd_sc_hd__tapvpwrvgnd_1
XFILLER_51_481 VGND VGND VPWR VPWR sky130_fd_sc_hd__decap_8
XTAP_TAPCELL_ROW_94_1147 VGND VPWR sky130_fd_sc_hd__tapvpwrvgnd_1
XTAP_TAPCELL_ROW_94_1158 VGND VPWR sky130_fd_sc_hd__tapvpwrvgnd_1
XFILLER_11_83 VGND VGND VPWR VPWR sky130_fd_sc_hd__fill_1
XFILLER_66_529 VGND VGND VPWR VPWR sky130_fd_sc_hd__decap_3
Xfanout380 _1151_ VGND VGND VPWR VPWR net380 sky130_fd_sc_hd__clkbuf_4
Xfanout391 net394 VGND VGND VPWR VPWR net391 sky130_fd_sc_hd__buf_4
XFILLER_46_253 VGND VGND VPWR VPWR sky130_fd_sc_hd__decap_8
XTAP_TAPCELL_ROW_57_771 VGND VPWR sky130_fd_sc_hd__tapvpwrvgnd_1
XFILLER_61_201 VGND VGND VPWR VPWR sky130_fd_sc_hd__decap_8
XTAP_TAPCELL_ROW_29_495 VGND VPWR sky130_fd_sc_hd__tapvpwrvgnd_1
XFILLER_36_91 VGND VGND VPWR VPWR sky130_fd_sc_hd__fill_1
XFILLER_61_234 VGND VGND VPWR VPWR sky130_fd_sc_hd__fill_2
XFILLER_21_109 VGND VGND VPWR VPWR sky130_fd_sc_hd__decap_3
Xinput11 value0[13] VGND VGND VPWR VPWR net11 sky130_fd_sc_hd__buf_1
X_4580_ clknet_leaf_50_clk _0111_ VGND VGND VPWR VPWR array\[15\]\[9\] sky130_fd_sc_hd__dfxtp_1
X_3600_ _1578_ _1586_ VGND VGND VPWR VPWR _1587_ sky130_fd_sc_hd__nand2_1
Xinput22 value0[23] VGND VGND VPWR VPWR net22 sky130_fd_sc_hd__buf_1
X_3531_ net618 net475 net360 net690 VGND VGND VPWR VPWR _1540_ sky130_fd_sc_hd__a22o_1
Xinput33 value0[4] VGND VGND VPWR VPWR net33 sky130_fd_sc_hd__buf_1
Xinput44 value1[14] VGND VGND VPWR VPWR net44 sky130_fd_sc_hd__buf_1
Xinput55 value1[24] VGND VGND VPWR VPWR net55 sky130_fd_sc_hd__buf_1
Xinput66 value1[5] VGND VGND VPWR VPWR net66 sky130_fd_sc_hd__buf_1
Xinput77 value2[15] VGND VGND VPWR VPWR net77 sky130_fd_sc_hd__buf_1
Xinput88 value2[25] VGND VGND VPWR VPWR net88 sky130_fd_sc_hd__buf_1
XFILLER_6_382 VGND VGND VPWR VPWR sky130_fd_sc_hd__fill_2
Xinput99 value2[6] VGND VGND VPWR VPWR net99 sky130_fd_sc_hd__buf_1
X_3462_ net591 net480 net366 net665 net266 VGND VGND VPWR VPWR _1492_ sky130_fd_sc_hd__a221o_1
XFILLER_88_109 VPWR VGND VPWR VGND sky130_ef_sc_hd__decap_12
X_3393_ net739 net255 _1445_ net263 VGND VGND VPWR VPWR _1446_ sky130_fd_sc_hd__a211o_1
X_2413_ net875 net208 _0763_ VGND VGND VPWR VPWR _0513_ sky130_fd_sc_hd__o21a_1
X_2344_ net1132 _0717_ net207 VGND VGND VPWR VPWR _0490_ sky130_fd_sc_hd__mux2_1
X_2275_ net892 net325 _0668_ VGND VGND VPWR VPWR _0470_ sky130_fd_sc_hd__o21a_1
XFILLER_84_326 VGND VGND VPWR VPWR sky130_fd_sc_hd__decap_6
X_4014_ net938 net169 _1931_ VGND VGND VPWR VPWR _0366_ sky130_fd_sc_hd__o21a_1
X_4916_ clknet_leaf_22_clk _0447_ VGND VGND VPWR VPWR array\[6\]\[27\] sky130_fd_sc_hd__dfxtp_1
XFILLER_40_429 VGND VGND VPWR VPWR sky130_fd_sc_hd__decap_8
X_4847_ clknet_leaf_63_clk _0378_ VGND VGND VPWR VPWR head\[1\] sky130_fd_sc_hd__dfxtp_1
X_4778_ clknet_leaf_64_clk _0309_ VGND VGND VPWR VPWR ready_check\[3\] sky130_fd_sc_hd__dfxtp_1
X_3729_ net738 net350 net420 VGND VGND VPWR VPWR _1680_ sky130_fd_sc_hd__and3_1
XFILLER_57_35 VGND VGND VPWR VPWR sky130_fd_sc_hd__fill_1
XFILLER_75_337 VGND VGND VPWR VPWR sky130_fd_sc_hd__decap_3
XFILLER_75_304 VGND VGND VPWR VPWR sky130_fd_sc_hd__decap_4
XFILLER_57_68 VGND VGND VPWR VPWR sky130_fd_sc_hd__fill_1
XFILLER_90_307 VGND VGND VPWR VPWR sky130_fd_sc_hd__fill_1
XTAP_TAPCELL_ROW_54_741 VGND VPWR sky130_fd_sc_hd__tapvpwrvgnd_1
XTAP_TAPCELL_ROW_26_465 VGND VPWR sky130_fd_sc_hd__tapvpwrvgnd_1
XFILLER_3_385 VGND VGND VPWR VPWR sky130_fd_sc_hd__decap_6
XFILLER_78_197 VGND VGND VPWR VPWR sky130_fd_sc_hd__decap_8
XFILLER_19_297 VGND VGND VPWR VPWR sky130_fd_sc_hd__fill_1
XFILLER_15_481 VGND VGND VPWR VPWR sky130_fd_sc_hd__fill_1
X_2962_ _1142_ _1143_ VGND VGND VPWR VPWR _1144_ sky130_fd_sc_hd__and2_1
X_4701_ clknet_leaf_38_clk _0232_ VGND VGND VPWR VPWR array\[11\]\[2\] sky130_fd_sc_hd__dfxtp_1
X_2893_ net586 net271 _1095_ net384 net268 VGND VGND VPWR VPWR _1096_ sky130_fd_sc_hd__a221o_1
X_4632_ clknet_leaf_51_clk _0163_ VGND VGND VPWR VPWR array\[14\]\[29\] sky130_fd_sc_hd__dfxtp_1
X_4563_ clknet_leaf_37_clk _0094_ VGND VGND VPWR VPWR array\[0\]\[24\] sky130_fd_sc_hd__dfxtp_1
X_3514_ net703 net245 VGND VGND VPWR VPWR _1529_ sky130_fd_sc_hd__and2_1
X_4494_ clknet_leaf_54_clk _0025_ VGND VGND VPWR VPWR array\[5\]\[19\] sky130_fd_sc_hd__dfxtp_1
XFILLER_89_429 VGND VGND VPWR VPWR sky130_fd_sc_hd__decap_3
X_3445_ net1106 net260 _1480_ VGND VGND VPWR VPWR _0248_ sky130_fd_sc_hd__o21a_1
X_3376_ net576 net484 net369 net646 net179 VGND VGND VPWR VPWR _1432_ sky130_fd_sc_hd__a221o_1
X_2327_ net645 net575 net523 VGND VGND VPWR VPWR _0703_ sky130_fd_sc_hd__mux2_1
X_2258_ net633 net762 net522 VGND VGND VPWR VPWR _0657_ sky130_fd_sc_hd__mux2_1
XFILLER_57_337 VGND VGND VPWR VPWR sky130_fd_sc_hd__decap_8
XTAP_TAPCELL_ROW_68_888 VGND VPWR sky130_fd_sc_hd__tapvpwrvgnd_1
X_2189_ _0592_ _0599_ VGND VGND VPWR VPWR _0600_ sky130_fd_sc_hd__nor2_1
XTAP_TAPCELL_ROW_51_711 VGND VPWR sky130_fd_sc_hd__tapvpwrvgnd_1
XTAP_TAPCELL_ROW_23_435 VGND VPWR sky130_fd_sc_hd__tapvpwrvgnd_1
XFILLER_4_127 VPWR VGND VPWR VGND sky130_ef_sc_hd__decap_12
XTAP_TAPCELL_ROW_91_1117 VGND VPWR sky130_fd_sc_hd__tapvpwrvgnd_1
XFILLER_0_300 VGND VGND VPWR VPWR sky130_fd_sc_hd__decap_4
XFILLER_75_145 VGND VGND VPWR VPWR sky130_fd_sc_hd__decap_3
XFILLER_75_167 VGND VGND VPWR VPWR sky130_fd_sc_hd__fill_1
XFILLER_84_77 VGND VGND VPWR VPWR sky130_fd_sc_hd__decap_6
XTAP_TAPCELL_ROW_39_590 VGND VPWR sky130_fd_sc_hd__tapvpwrvgnd_1
XFILLER_8_433 VPWR VGND VPWR VGND sky130_ef_sc_hd__decap_12
XFILLER_8_477 VPWR VGND VPWR VGND sky130_ef_sc_hd__decap_12
XFILLER_3_193 VPWR VGND VPWR VGND sky130_ef_sc_hd__decap_12
X_3230_ net614 net488 net184 net750 _1332_ VGND VGND VPWR VPWR _1333_ sky130_fd_sc_hd__a221o_1
X_3161_ net724 net187 _1283_ net191 VGND VGND VPWR VPWR _1284_ sky130_fd_sc_hd__a211o_1
XFILLER_94_421 VPWR VGND VPWR VGND sky130_ef_sc_hd__decap_12
XFILLER_12_3 VPWR VGND VPWR VGND sky130_ef_sc_hd__decap_12
X_3092_ net710 net186 _1237_ net190 VGND VGND VPWR VPWR _1238_ sky130_fd_sc_hd__a211o_1
XTAP_TAPCELL_ROW_65_858 VGND VPWR sky130_fd_sc_hd__tapvpwrvgnd_1
X_3994_ array\[10\]\[20\] net459 net442 array\[8\]\[20\] VGND VGND VPWR VPWR _1913_
+ sky130_fd_sc_hd__a22o_1
XTAP_TAPCELL_ROW_20_405 VGND VPWR sky130_fd_sc_hd__tapvpwrvgnd_1
X_2945_ net1170 net200 _1130_ VGND VGND VPWR VPWR _0098_ sky130_fd_sc_hd__o21a_1
X_2876_ net1152 net201 _1084_ VGND VGND VPWR VPWR _0075_ sky130_fd_sc_hd__o21a_1
X_4615_ clknet_leaf_15_clk _0146_ VGND VGND VPWR VPWR array\[14\]\[12\] sky130_fd_sc_hd__dfxtp_1
Xhold400 array\[14\]\[18\] VGND VGND VPWR VPWR net1166 sky130_fd_sc_hd__dlygate4sd3_1
Xhold411 array\[0\]\[12\] VGND VGND VPWR VPWR net1177 sky130_fd_sc_hd__dlygate4sd3_1
X_4546_ clknet_leaf_57_clk _0077_ VGND VGND VPWR VPWR array\[0\]\[7\] sky130_fd_sc_hd__dfxtp_1
Xhold433 array\[7\]\[18\] VGND VGND VPWR VPWR net1199 sky130_fd_sc_hd__dlygate4sd3_1
Xhold444 array\[4\]\[21\] VGND VGND VPWR VPWR net1210 sky130_fd_sc_hd__dlygate4sd3_1
Xhold422 array\[11\]\[30\] VGND VGND VPWR VPWR net1188 sky130_fd_sc_hd__dlygate4sd3_1
Xhold477 array\[0\]\[18\] VGND VGND VPWR VPWR net1243 sky130_fd_sc_hd__dlygate4sd3_1
XFILLER_1_108 VGND VGND VPWR VPWR sky130_fd_sc_hd__decap_4
Xhold466 array\[4\]\[29\] VGND VGND VPWR VPWR net1232 sky130_fd_sc_hd__dlygate4sd3_1
X_4477_ clknet_leaf_39_clk _0008_ VGND VGND VPWR VPWR array\[5\]\[2\] sky130_fd_sc_hd__dfxtp_1
Xhold455 array\[8\]\[12\] VGND VGND VPWR VPWR net1221 sky130_fd_sc_hd__dlygate4sd3_1
X_3428_ net618 net478 net364 net690 VGND VGND VPWR VPWR _1469_ sky130_fd_sc_hd__a22o_1
Xhold488 array\[4\]\[31\] VGND VGND VPWR VPWR net1254 sky130_fd_sc_hd__dlygate4sd3_1
Xhold499 array\[0\]\[4\] VGND VGND VPWR VPWR net1265 sky130_fd_sc_hd__dlygate4sd3_1
X_3359_ net1240 net155 _1419_ _1420_ VGND VGND VPWR VPWR _0222_ sky130_fd_sc_hd__o22a_1
XFILLER_85_487 VGND VGND VPWR VPWR sky130_fd_sc_hd__fill_1
XFILLER_85_476 VGND VGND VPWR VPWR sky130_fd_sc_hd__fill_2
XFILLER_38_381 VGND VGND VPWR VPWR sky130_fd_sc_hd__decap_3
XFILLER_38_392 VGND VGND VPWR VPWR sky130_fd_sc_hd__decap_4
XTAP_TAPCELL_ROW_0_196 VGND VPWR sky130_fd_sc_hd__tapvpwrvgnd_1
XTAP_TAPCELL_ROW_36_560 VGND VPWR sky130_fd_sc_hd__tapvpwrvgnd_1
XFILLER_9_208 VPWR VGND VPWR VGND sky130_ef_sc_hd__decap_12
XFILLER_21_281 VGND VGND VPWR VPWR sky130_fd_sc_hd__decap_3
XTAP_TAPCELL_ROW_8_285 VGND VPWR sky130_fd_sc_hd__tapvpwrvgnd_1
XFILLER_0_141 VGND VGND VPWR VPWR sky130_fd_sc_hd__fill_2
XFILLER_17_554 VGND VGND VPWR VPWR sky130_fd_sc_hd__decap_3
XTAP_TAPCELL_ROW_62_828 VGND VPWR sky130_fd_sc_hd__tapvpwrvgnd_1
XFILLER_71_181 VGND VGND VPWR VPWR sky130_fd_sc_hd__fill_1
XFILLER_12_270 VGND VGND VPWR VPWR sky130_fd_sc_hd__decap_4
X_2730_ net793 _0984_ net295 VGND VGND VPWR VPWR _0029_ sky130_fd_sc_hd__mux2_1
X_2661_ net929 _0938_ net293 VGND VGND VPWR VPWR _0006_ sky130_fd_sc_hd__mux2_1
X_4400_ clknet_leaf_0_clk _0511_ VGND VGND VPWR VPWR array\[2\]\[21\] sky130_fd_sc_hd__dfxtp_1
X_2592_ net621 net510 net396 net693 net300 VGND VGND VPWR VPWR _0891_ sky130_fd_sc_hd__a221o_1
X_4331_ net1057 net218 _2167_ _2168_ VGND VGND VPWR VPWR _0450_ sky130_fd_sc_hd__o22a_1
X_4262_ net1081 net223 net338 net707 _2124_ VGND VGND VPWR VPWR _0425_ sky130_fd_sc_hd__a221o_1
Xfanout209 net210 VGND VGND VPWR VPWR net209 sky130_fd_sc_hd__buf_4
X_3213_ net784 _1321_ net157 VGND VGND VPWR VPWR _0175_ sky130_fd_sc_hd__mux2_1
X_4193_ net614 net434 net343 net686 net232 VGND VGND VPWR VPWR _2078_ sky130_fd_sc_hd__a221o_1
XFILLER_67_476 VGND VGND VPWR VPWR sky130_fd_sc_hd__decap_6
X_3144_ net1217 net161 _1272_ VGND VGND VPWR VPWR _0155_ sky130_fd_sc_hd__o21a_1
XTAP_TAPCELL_ROW_78_983 VGND VPWR sky130_fd_sc_hd__tapvpwrvgnd_1
X_3075_ net525 net267 _1218_ _1224_ net653 VGND VGND VPWR VPWR _1225_ sky130_fd_sc_hd__a311oi_2
XFILLER_27_318 VGND VGND VPWR VPWR sky130_fd_sc_hd__decap_4
XFILLER_23_513 VGND VGND VPWR VPWR sky130_fd_sc_hd__decap_3
XTAP_TAPCELL_ROW_33_530 VGND VPWR sky130_fd_sc_hd__tapvpwrvgnd_1
X_3977_ net416 _1891_ _1895_ net437 VGND VGND VPWR VPWR _1898_ sky130_fd_sc_hd__a22o_1
XFILLER_50_365 VGND VGND VPWR VPWR sky130_fd_sc_hd__fill_2
X_2928_ net593 net667 net499 VGND VGND VPWR VPWR _1119_ sky130_fd_sc_hd__mux2_1
X_2859_ net653 _1071_ VGND VGND VPWR VPWR _1073_ sky130_fd_sc_hd__or2_1
Xhold241 array\[12\]\[11\] VGND VGND VPWR VPWR net1007 sky130_fd_sc_hd__dlygate4sd3_1
Xhold252 array\[8\]\[17\] VGND VGND VPWR VPWR net1018 sky130_fd_sc_hd__dlygate4sd3_1
X_4529_ clknet_leaf_57_clk _0060_ VGND VGND VPWR VPWR array\[8\]\[22\] sky130_fd_sc_hd__dfxtp_1
Xhold230 array\[0\]\[9\] VGND VGND VPWR VPWR net996 sky130_fd_sc_hd__dlygate4sd3_1
Xhold296 array\[12\]\[8\] VGND VGND VPWR VPWR net1062 sky130_fd_sc_hd__dlygate4sd3_1
Xhold263 array\[6\]\[8\] VGND VGND VPWR VPWR net1029 sky130_fd_sc_hd__dlygate4sd3_1
Xhold274 array\[5\]\[31\] VGND VGND VPWR VPWR net1040 sky130_fd_sc_hd__dlygate4sd3_1
Xhold285 array\[7\]\[2\] VGND VGND VPWR VPWR net1051 sky130_fd_sc_hd__dlygate4sd3_1
Xfanout721 net27 VGND VGND VPWR VPWR net721 sky130_fd_sc_hd__buf_2
Xfanout710 net33 VGND VGND VPWR VPWR net710 sky130_fd_sc_hd__dlymetal6s2s_1
Xfanout732 net22 VGND VGND VPWR VPWR net732 sky130_fd_sc_hd__clkbuf_2
Xfanout765 net10 VGND VGND VPWR VPWR net765 sky130_fd_sc_hd__dlymetal6s2s_1
Xfanout743 net16 VGND VGND VPWR VPWR net743 sky130_fd_sc_hd__buf_2
Xfanout754 net11 VGND VGND VPWR VPWR net754 sky130_fd_sc_hd__buf_2
XTAP_TAPCELL_ROW_5_255 VGND VPWR sky130_fd_sc_hd__tapvpwrvgnd_1
XFILLER_85_240 VGND VGND VPWR VPWR sky130_fd_sc_hd__decap_8
XFILLER_18_307 VGND VGND VPWR VPWR sky130_fd_sc_hd__fill_1
XFILLER_73_413 VGND VGND VPWR VPWR sky130_fd_sc_hd__fill_1
XFILLER_73_457 VGND VGND VPWR VPWR sky130_fd_sc_hd__fill_2
XANTENNA_125 _0613_ VGND VGND VPWR VPWR sky130_fd_sc_hd__diode_2
XANTENNA_103 net401 VGND VGND VPWR VPWR sky130_fd_sc_hd__diode_2
XANTENNA_114 net435 VGND VGND VPWR VPWR sky130_fd_sc_hd__diode_2
XANTENNA_136 net156 VGND VGND VPWR VPWR sky130_fd_sc_hd__diode_2
XANTENNA_147 net330 VGND VGND VPWR VPWR sky130_fd_sc_hd__diode_2
XFILLER_14_513 VPWR VGND VPWR VGND sky130_ef_sc_hd__decap_12
XANTENNA_158 net508 VGND VGND VPWR VPWR sky130_fd_sc_hd__diode_2
XFILLER_14_557 VGND VGND VPWR VPWR sky130_fd_sc_hd__fill_2
XANTENNA_169 _0869_ VGND VGND VPWR VPWR sky130_fd_sc_hd__diode_2
XFILLER_41_354 VPWR VGND VPWR VGND sky130_ef_sc_hd__decap_12
XFILLER_1_461 VPWR VGND VPWR VGND sky130_ef_sc_hd__decap_12
Xinput9 value0[11] VGND VGND VPWR VPWR net9 sky130_fd_sc_hd__clkbuf_1
XTAP_TAPCELL_ROW_75_953 VGND VPWR sky130_fd_sc_hd__tapvpwrvgnd_1
XFILLER_17_373 VGND VGND VPWR VPWR sky130_fd_sc_hd__decap_3
XTAP_TAPCELL_ROW_47_677 VGND VPWR sky130_fd_sc_hd__tapvpwrvgnd_1
X_3900_ net353 _1822_ _1826_ net415 net214 VGND VGND VPWR VPWR _1828_ sky130_fd_sc_hd__a221o_1
X_4880_ clknet_leaf_35_clk _0411_ VGND VGND VPWR VPWR array\[7\]\[23\] sky130_fd_sc_hd__dfxtp_1
XFILLER_51_129 VGND VGND VPWR VPWR sky130_fd_sc_hd__fill_1
X_3831_ net357 _1759_ _1763_ net353 net216 VGND VGND VPWR VPWR _1765_ sky130_fd_sc_hd__a221o_1
X_3762_ net713 net349 net421 VGND VGND VPWR VPWR _1702_ sky130_fd_sc_hd__and3_1
XTAP_TAPCELL_ROW_30_500 VGND VPWR sky130_fd_sc_hd__tapvpwrvgnd_1
XFILLER_9_561 VGND VGND VPWR VPWR sky130_fd_sc_hd__fill_1
X_2713_ net679 net605 net392 VGND VGND VPWR VPWR _0973_ sky130_fd_sc_hd__mux2_1
X_3693_ net704 net348 net419 VGND VGND VPWR VPWR _1657_ sky130_fd_sc_hd__and3_1
X_2644_ net720 _0868_ _0924_ net302 VGND VGND VPWR VPWR _0925_ sky130_fd_sc_hd__a211o_1
X_2575_ net567 net511 net397 net637 net302 VGND VGND VPWR VPWR _0880_ sky130_fd_sc_hd__a221o_1
X_4314_ net592 net430 net334 net665 net224 VGND VGND VPWR VPWR _2158_ sky130_fd_sc_hd__a221o_1
XFILLER_87_505 VPWR VGND VPWR VGND sky130_ef_sc_hd__decap_12
X_4245_ net427 _1620_ _1618_ VGND VGND VPWR VPWR _2113_ sky130_fd_sc_hd__nor3b_1
X_4176_ net700 net235 VGND VGND VPWR VPWR _2067_ sky130_fd_sc_hd__and2_1
X_3127_ net612 net491 net377 net684 VGND VGND VPWR VPWR _1261_ sky130_fd_sc_hd__a22o_1
XTAP_TAPCELL_ROW_2_225 VGND VPWR sky130_fd_sc_hd__tapvpwrvgnd_1
XFILLER_55_402 VGND VGND VPWR VPWR sky130_fd_sc_hd__fill_1
XFILLER_70_427 VGND VGND VPWR VPWR sky130_fd_sc_hd__decap_4
XFILLER_70_416 VGND VGND VPWR VPWR sky130_fd_sc_hd__decap_4
X_3058_ net851 _1211_ net166 VGND VGND VPWR VPWR _0130_ sky130_fd_sc_hd__mux2_1
XFILLER_35_49 VGND VGND VPWR VPWR sky130_fd_sc_hd__fill_1
XFILLER_42_118 VGND VGND VPWR VPWR sky130_fd_sc_hd__decap_3
Xclkbuf_leaf_62_clk clknet_3_0__leaf_clk VGND VGND VPWR VPWR clknet_leaf_62_clk sky130_fd_sc_hd__clkbuf_8
XFILLER_35_181 VGND VGND VPWR VPWR sky130_fd_sc_hd__decap_3
XFILLER_42_129 VGND VGND VPWR VPWR sky130_fd_sc_hd__decap_3
XFILLER_11_505 VPWR VGND VPWR VGND sky130_ef_sc_hd__decap_12
XFILLER_23_365 VGND VGND VPWR VPWR sky130_fd_sc_hd__decap_3
Xfanout540 net542 VGND VGND VPWR VPWR net540 sky130_fd_sc_hd__clkbuf_4
Xfanout551 net558 VGND VGND VPWR VPWR net551 sky130_fd_sc_hd__clkbuf_4
Xfanout584 net90 VGND VGND VPWR VPWR net584 sky130_fd_sc_hd__dlymetal6s2s_1
Xfanout562 _0587_ VGND VGND VPWR VPWR net562 sky130_fd_sc_hd__buf_2
Xfanout573 net95 VGND VGND VPWR VPWR net573 sky130_fd_sc_hd__buf_2
Xfanout595 net85 VGND VGND VPWR VPWR net595 sky130_fd_sc_hd__buf_2
XFILLER_18_148 VGND VGND VPWR VPWR sky130_fd_sc_hd__decap_4
XTAP_TAPCELL_ROW_72_923 VGND VPWR sky130_fd_sc_hd__tapvpwrvgnd_1
XFILLER_92_77 VGND VGND VPWR VPWR sky130_fd_sc_hd__decap_6
Xclkbuf_leaf_53_clk clknet_3_3__leaf_clk VGND VGND VPWR VPWR clknet_leaf_53_clk sky130_fd_sc_hd__clkbuf_8
XTAP_TAPCELL_ROW_44_647 VGND VPWR sky130_fd_sc_hd__tapvpwrvgnd_1
XFILLER_14_365 VGND VGND VPWR VPWR sky130_fd_sc_hd__fill_1
XFILLER_25_82 VGND VGND VPWR VPWR sky130_fd_sc_hd__decap_6
XFILLER_6_531 VGND VGND VPWR VPWR sky130_fd_sc_hd__fill_1
XFILLER_69_505 VGND VGND VPWR VPWR sky130_fd_sc_hd__fill_1
X_2360_ net565 net635 net517 VGND VGND VPWR VPWR _0728_ sky130_fd_sc_hd__mux2_1
X_2291_ net680 net606 net523 VGND VGND VPWR VPWR _0679_ sky130_fd_sc_hd__mux2_1
XPHY_EDGE_ROW_10_Right_10 VGND VGND VPWR VPWR sky130_fd_sc_hd__decap_3
X_4030_ array\[6\]\[23\] net466 net449 array\[4\]\[23\] VGND VGND VPWR VPWR _1946_
+ sky130_fd_sc_hd__a22o_1
XFILLER_37_446 VGND VGND VPWR VPWR sky130_fd_sc_hd__fill_2
XFILLER_64_265 VGND VGND VPWR VPWR sky130_fd_sc_hd__decap_4
Xclkbuf_leaf_44_clk clknet_3_3__leaf_clk VGND VGND VPWR VPWR clknet_leaf_44_clk sky130_fd_sc_hd__clkbuf_8
XANTENNA_14 _1149_ VGND VGND VPWR VPWR sky130_fd_sc_hd__diode_2
X_4863_ clknet_leaf_6_clk _0394_ VGND VGND VPWR VPWR array\[7\]\[6\] sky130_fd_sc_hd__dfxtp_1
X_3814_ array\[5\]\[4\] net552 net532 array\[7\]\[4\] _1748_ VGND VGND VPWR VPWR _1749_
+ sky130_fd_sc_hd__a221o_1
XANTENNA_36 _1439_ VGND VGND VPWR VPWR sky130_fd_sc_hd__diode_2
XANTENNA_25 _1296_ VGND VGND VPWR VPWR sky130_fd_sc_hd__diode_2
XANTENNA_47 _1616_ VGND VGND VPWR VPWR sky130_fd_sc_hd__diode_2
X_4794_ clknet_leaf_19_clk _0325_ VGND VGND VPWR VPWR array\[9\]\[12\] sky130_fd_sc_hd__dfxtp_1
XANTENNA_69 net178 VGND VGND VPWR VPWR sky130_fd_sc_hd__diode_2
XANTENNA_58 _2112_ VGND VGND VPWR VPWR sky130_fd_sc_hd__diode_2
XFILLER_21_18 VGND VGND VPWR VPWR sky130_fd_sc_hd__decap_8
X_3745_ net589 net425 net346 net663 net243 VGND VGND VPWR VPWR _1691_ sky130_fd_sc_hd__a221o_1
X_3676_ net601 net423 net344 net675 net241 VGND VGND VPWR VPWR _1646_ sky130_fd_sc_hd__a221o_1
Xoutput143 net143 VGND VGND VPWR VPWR out[30] sky130_fd_sc_hd__buf_2
Xoutput132 net132 VGND VGND VPWR VPWR out[20] sky130_fd_sc_hd__buf_2
Xoutput121 net121 VGND VGND VPWR VPWR out[10] sky130_fd_sc_hd__buf_2
X_2627_ net593 net511 net397 net667 VGND VGND VPWR VPWR _0914_ sky130_fd_sc_hd__a22o_1
X_2558_ net399 net506 VGND VGND VPWR VPWR _0868_ sky130_fd_sc_hd__and2_4
X_2489_ net1088 net205 _0817_ VGND VGND VPWR VPWR _0535_ sky130_fd_sc_hd__o21a_1
X_4228_ net723 net236 VGND VGND VPWR VPWR _2101_ sky130_fd_sc_hd__and2_1
XFILLER_68_560 VGND VGND VPWR VPWR sky130_fd_sc_hd__fill_2
XFILLER_55_210 VGND VGND VPWR VPWR sky130_fd_sc_hd__fill_1
X_4159_ net712 net233 net229 _2055_ VGND VGND VPWR VPWR _2056_ sky130_fd_sc_hd__a211o_1
Xclkbuf_leaf_35_clk clknet_3_6__leaf_clk VGND VGND VPWR VPWR clknet_leaf_35_clk sky130_fd_sc_hd__clkbuf_8
XFILLER_23_151 VGND VGND VPWR VPWR sky130_fd_sc_hd__decap_8
XTAP_TAPCELL_ROW_41_617 VGND VPWR sky130_fd_sc_hd__tapvpwrvgnd_1
XTAP_TAPCELL_ROW_94_1159 VGND VPWR sky130_fd_sc_hd__tapvpwrvgnd_1
XTAP_TAPCELL_ROW_94_1148 VGND VPWR sky130_fd_sc_hd__tapvpwrvgnd_1
XFILLER_87_55 VGND VGND VPWR VPWR sky130_fd_sc_hd__fill_1
XFILLER_78_324 VGND VGND VPWR VPWR sky130_fd_sc_hd__fill_2
Xfanout370 _1373_ VGND VGND VPWR VPWR net370 sky130_fd_sc_hd__buf_4
Xfanout392 net394 VGND VGND VPWR VPWR net392 sky130_fd_sc_hd__clkbuf_4
Xfanout381 _1151_ VGND VGND VPWR VPWR net381 sky130_fd_sc_hd__clkbuf_4
XFILLER_19_446 VGND VGND VPWR VPWR sky130_fd_sc_hd__fill_2
XTAP_TAPCELL_ROW_57_772 VGND VPWR sky130_fd_sc_hd__tapvpwrvgnd_1
XTAP_TAPCELL_ROW_29_496 VGND VPWR sky130_fd_sc_hd__tapvpwrvgnd_1
XFILLER_36_81 VGND VGND VPWR VPWR sky130_fd_sc_hd__decap_3
Xclkbuf_leaf_26_clk clknet_3_7__leaf_clk VGND VGND VPWR VPWR clknet_leaf_26_clk sky130_fd_sc_hd__clkbuf_8
XFILLER_61_279 VGND VGND VPWR VPWR sky130_fd_sc_hd__fill_1
Xinput12 value0[14] VGND VGND VPWR VPWR net12 sky130_fd_sc_hd__clkbuf_1
Xinput34 value0[5] VGND VGND VPWR VPWR net34 sky130_fd_sc_hd__buf_1
Xinput45 value1[15] VGND VGND VPWR VPWR net45 sky130_fd_sc_hd__buf_1
X_3530_ net951 net250 _1538_ _1539_ VGND VGND VPWR VPWR _0274_ sky130_fd_sc_hd__o22a_1
Xinput23 value0[24] VGND VGND VPWR VPWR net23 sky130_fd_sc_hd__clkbuf_1
Xinput78 value2[16] VGND VGND VPWR VPWR net78 sky130_fd_sc_hd__buf_1
Xinput89 value2[26] VGND VGND VPWR VPWR net89 sky130_fd_sc_hd__buf_1
Xinput56 value1[25] VGND VGND VPWR VPWR net56 sky130_fd_sc_hd__buf_1
Xinput67 value1[6] VGND VGND VPWR VPWR net67 sky130_fd_sc_hd__buf_1
X_3461_ net729 net258 VGND VGND VPWR VPWR _1491_ sky130_fd_sc_hd__and2_1
X_3392_ net602 net477 net363 net676 VGND VGND VPWR VPWR _1445_ sky130_fd_sc_hd__a22o_1
XFILLER_42_3 VGND VGND VPWR VPWR sky130_fd_sc_hd__fill_1
X_2412_ net731 net317 _0762_ net409 net313 VGND VGND VPWR VPWR _0763_ sky130_fd_sc_hd__a221o_1
X_2343_ net629 net315 _0713_ net406 VGND VGND VPWR VPWR _0717_ sky130_fd_sc_hd__a22o_1
X_2274_ net764 net321 _0667_ net412 net329 VGND VGND VPWR VPWR _0668_ sky130_fd_sc_hd__a221o_1
X_4013_ net213 _1929_ _1930_ VGND VGND VPWR VPWR _1931_ sky130_fd_sc_hd__or3_1
XFILLER_80_533 VPWR VGND VPWR VGND sky130_ef_sc_hd__decap_12
XFILLER_80_511 VGND VGND VPWR VPWR sky130_fd_sc_hd__fill_1
XFILLER_52_224 VPWR VGND VPWR VGND sky130_ef_sc_hd__decap_12
Xclkbuf_leaf_17_clk clknet_3_5__leaf_clk VGND VGND VPWR VPWR clknet_leaf_17_clk sky130_fd_sc_hd__clkbuf_8
X_4915_ clknet_leaf_16_clk _0446_ VGND VGND VPWR VPWR array\[6\]\[26\] sky130_fd_sc_hd__dfxtp_1
XFILLER_40_419 VGND VGND VPWR VPWR sky130_fd_sc_hd__fill_1
X_4846_ clknet_leaf_63_clk _0377_ VGND VGND VPWR VPWR head\[0\] sky130_fd_sc_hd__dfxtp_1
X_4777_ clknet_leaf_60_clk _0308_ VGND VGND VPWR VPWR ready_check\[4\] sky130_fd_sc_hd__dfxtp_1
XFILLER_4_309 VGND VGND VPWR VPWR sky130_fd_sc_hd__decap_4
X_3728_ net915 net237 _1678_ _1679_ VGND VGND VPWR VPWR _0332_ sky130_fd_sc_hd__o22a_1
X_3659_ _1293_ _1604_ ready_check\[1\] VGND VGND VPWR VPWR _1632_ sky130_fd_sc_hd__a21boi_1
XFILLER_87_187 VGND VGND VPWR VPWR sky130_fd_sc_hd__fill_2
XFILLER_83_393 VPWR VGND VPWR VGND sky130_ef_sc_hd__decap_12
XFILLER_16_416 VGND VGND VPWR VPWR sky130_fd_sc_hd__decap_4
XFILLER_73_57 VGND VGND VPWR VPWR sky130_fd_sc_hd__fill_2
XFILLER_43_257 VGND VGND VPWR VPWR sky130_fd_sc_hd__decap_4
XTAP_TAPCELL_ROW_54_742 VGND VPWR sky130_fd_sc_hd__tapvpwrvgnd_1
XTAP_TAPCELL_ROW_26_466 VGND VPWR sky130_fd_sc_hd__tapvpwrvgnd_1
XFILLER_11_132 VGND VGND VPWR VPWR sky130_fd_sc_hd__decap_4
XFILLER_51_290 VGND VGND VPWR VPWR sky130_fd_sc_hd__decap_6
XFILLER_7_147 VGND VGND VPWR VPWR sky130_fd_sc_hd__fill_1
XFILLER_78_110 VGND VGND VPWR VPWR sky130_fd_sc_hd__decap_8
XFILLER_93_113 VPWR VGND VPWR VGND sky130_ef_sc_hd__decap_12
XFILLER_66_305 VGND VGND VPWR VPWR sky130_fd_sc_hd__decap_3
XFILLER_15_460 VGND VGND VPWR VPWR sky130_fd_sc_hd__fill_1
X_2961_ tail\[3\] net106 net525 VGND VGND VPWR VPWR _1143_ sky130_fd_sc_hd__mux2_1
X_4700_ clknet_leaf_55_clk _0231_ VGND VGND VPWR VPWR array\[11\]\[1\] sky130_fd_sc_hd__dfxtp_1
X_2892_ net622 net694 net497 VGND VGND VPWR VPWR _1095_ sky130_fd_sc_hd__mux2_1
X_4631_ clknet_leaf_50_clk _0162_ VGND VGND VPWR VPWR array\[14\]\[28\] sky130_fd_sc_hd__dfxtp_1
XFILLER_8_41 VGND VGND VPWR VPWR sky130_fd_sc_hd__decap_6
XFILLER_8_85 VGND VGND VPWR VPWR sky130_fd_sc_hd__decap_8
X_4562_ clknet_leaf_38_clk _0093_ VGND VGND VPWR VPWR array\[0\]\[23\] sky130_fd_sc_hd__dfxtp_1
X_4493_ clknet_leaf_13_clk _0024_ VGND VGND VPWR VPWR array\[5\]\[18\] sky130_fd_sc_hd__dfxtp_1
X_3513_ net983 net250 _1528_ VGND VGND VPWR VPWR _0268_ sky130_fd_sc_hd__o21a_1
X_3444_ net743 net256 _1479_ net264 VGND VGND VPWR VPWR _1480_ sky130_fd_sc_hd__a211o_1
Xclkbuf_leaf_6_clk clknet_3_4__leaf_clk VGND VGND VPWR VPWR clknet_leaf_6_clk sky130_fd_sc_hd__clkbuf_8
X_3375_ net716 net175 VGND VGND VPWR VPWR _1431_ sky130_fd_sc_hd__and2_1
XFILLER_69_121 VGND VGND VPWR VPWR sky130_fd_sc_hd__fill_1
X_2326_ net1266 net323 _0702_ VGND VGND VPWR VPWR _0487_ sky130_fd_sc_hd__o21a_1
X_2257_ net1185 net324 _0656_ VGND VGND VPWR VPWR _0464_ sky130_fd_sc_hd__o21a_1
XTAP_TAPCELL_ROW_68_889 VGND VPWR sky130_fd_sc_hd__tapvpwrvgnd_1
X_2188_ ready_check\[4\] ready_check\[5\] ready_check\[6\] ready_check\[7\] _0000_
+ _0001_ VGND VGND VPWR VPWR _0599_ sky130_fd_sc_hd__mux4_1
XFILLER_25_268 VGND VGND VPWR VPWR sky130_fd_sc_hd__decap_4
XFILLER_25_279 VGND VGND VPWR VPWR sky130_fd_sc_hd__fill_1
XFILLER_40_205 VGND VGND VPWR VPWR sky130_fd_sc_hd__decap_3
XTAP_TAPCELL_ROW_51_712 VGND VPWR sky130_fd_sc_hd__tapvpwrvgnd_1
XTAP_TAPCELL_ROW_23_436 VGND VPWR sky130_fd_sc_hd__tapvpwrvgnd_1
X_4829_ clknet_leaf_33_clk _0360_ VGND VGND VPWR VPWR net126 sky130_fd_sc_hd__dfxtp_1
XFILLER_4_139 VGND VGND VPWR VPWR sky130_fd_sc_hd__fill_1
XTAP_TAPCELL_ROW_91_1118 VGND VPWR sky130_fd_sc_hd__tapvpwrvgnd_1
XFILLER_88_441 VGND VGND VPWR VPWR sky130_fd_sc_hd__fill_1
XFILLER_0_345 VGND VGND VPWR VPWR sky130_fd_sc_hd__fill_1
XFILLER_0_356 VGND VGND VPWR VPWR sky130_fd_sc_hd__decap_4
XFILLER_44_511 VGND VGND VPWR VPWR sky130_fd_sc_hd__fill_1
XTAP_TAPCELL_ROW_39_591 VGND VPWR sky130_fd_sc_hd__tapvpwrvgnd_1
XFILLER_8_412 VGND VGND VPWR VPWR sky130_fd_sc_hd__decap_8
XFILLER_8_445 VPWR VGND VPWR VGND sky130_ef_sc_hd__decap_12
XFILLER_8_489 VPWR VGND VPWR VGND sky130_ef_sc_hd__decap_12
X_3160_ net584 net492 net377 net660 VGND VGND VPWR VPWR _1283_ sky130_fd_sc_hd__a22o_1
XFILLER_39_305 VGND VGND VPWR VPWR sky130_fd_sc_hd__fill_2
XFILLER_94_433 VGND VGND VPWR VPWR sky130_fd_sc_hd__decap_8
XFILLER_79_496 VGND VGND VPWR VPWR sky130_fd_sc_hd__fill_1
Xhold1 net150 VGND VGND VPWR VPWR net767 sky130_fd_sc_hd__dlygate4sd3_1
X_3091_ net570 net491 net376 net640 VGND VGND VPWR VPWR _1237_ sky130_fd_sc_hd__a22o_1
XFILLER_94_477 VPWR VGND VPWR VGND sky130_ef_sc_hd__decap_12
XFILLER_94_455 VGND VGND VPWR VPWR sky130_fd_sc_hd__decap_3
XFILLER_47_360 VGND VGND VPWR VPWR sky130_fd_sc_hd__fill_1
XTAP_TAPCELL_ROW_65_859 VGND VPWR sky130_fd_sc_hd__tapvpwrvgnd_1
XPHY_EDGE_ROW_8_Right_8 VGND VGND VPWR VPWR sky130_fd_sc_hd__decap_3
XFILLER_62_363 VGND VGND VPWR VPWR sky130_fd_sc_hd__fill_1
XFILLER_22_227 VGND VGND VPWR VPWR sky130_fd_sc_hd__fill_1
X_3993_ array\[5\]\[20\] net546 net534 array\[7\]\[20\] _1911_ VGND VGND VPWR VPWR
+ _1912_ sky130_fd_sc_hd__a221o_1
X_2944_ net722 net272 _1129_ net385 net269 VGND VGND VPWR VPWR _1130_ sky130_fd_sc_hd__a221o_1
X_2875_ net708 net273 _1083_ net386 net270 VGND VGND VPWR VPWR _1084_ sky130_fd_sc_hd__a221o_1
XTAP_TAPCELL_ROW_20_406 VGND VPWR sky130_fd_sc_hd__tapvpwrvgnd_1
X_4614_ clknet_leaf_14_clk _0145_ VGND VGND VPWR VPWR array\[14\]\[11\] sky130_fd_sc_hd__dfxtp_1
Xhold401 array\[7\]\[19\] VGND VGND VPWR VPWR net1167 sky130_fd_sc_hd__dlygate4sd3_1
X_4545_ clknet_leaf_7_clk _0076_ VGND VGND VPWR VPWR array\[0\]\[6\] sky130_fd_sc_hd__dfxtp_1
Xhold445 array\[12\]\[18\] VGND VGND VPWR VPWR net1211 sky130_fd_sc_hd__dlygate4sd3_1
Xhold434 array\[8\]\[19\] VGND VGND VPWR VPWR net1200 sky130_fd_sc_hd__dlygate4sd3_1
Xhold412 array\[4\]\[28\] VGND VGND VPWR VPWR net1178 sky130_fd_sc_hd__dlygate4sd3_1
Xhold423 array\[0\]\[15\] VGND VGND VPWR VPWR net1189 sky130_fd_sc_hd__dlygate4sd3_1
Xhold467 array\[4\]\[17\] VGND VGND VPWR VPWR net1233 sky130_fd_sc_hd__dlygate4sd3_1
Xhold456 array\[11\]\[0\] VGND VGND VPWR VPWR net1222 sky130_fd_sc_hd__dlygate4sd3_1
Xhold478 array\[2\]\[28\] VGND VGND VPWR VPWR net1244 sky130_fd_sc_hd__dlygate4sd3_1
X_4476_ clknet_leaf_55_clk _0007_ VGND VGND VPWR VPWR array\[5\]\[1\] sky130_fd_sc_hd__dfxtp_1
X_3427_ net1136 net260 _1468_ VGND VGND VPWR VPWR _0242_ sky130_fd_sc_hd__o21a_1
XPHY_EDGE_ROW_39_Right_39 VGND VGND VPWR VPWR sky130_fd_sc_hd__decap_3
Xhold489 array\[6\]\[14\] VGND VGND VPWR VPWR net1255 sky130_fd_sc_hd__dlygate4sd3_1
X_3358_ net592 net484 net369 net666 net179 VGND VGND VPWR VPWR _1420_ sky130_fd_sc_hd__a221o_1
XFILLER_57_113 VGND VGND VPWR VPWR sky130_fd_sc_hd__decap_3
X_2309_ net665 net591 net524 VGND VGND VPWR VPWR _0691_ sky130_fd_sc_hd__mux2_1
X_3289_ net629 net173 _1374_ net177 VGND VGND VPWR VPWR _1375_ sky130_fd_sc_hd__a211o_1
XTAP_TAPCELL_ROW_88_1080 VGND VPWR sky130_fd_sc_hd__tapvpwrvgnd_1
XFILLER_26_533 VGND VGND VPWR VPWR sky130_fd_sc_hd__decap_4
XFILLER_54_26 VGND VGND VPWR VPWR sky130_fd_sc_hd__fill_2
XTAP_TAPCELL_ROW_0_197 VGND VPWR sky130_fd_sc_hd__tapvpwrvgnd_1
XTAP_TAPCELL_ROW_36_561 VGND VPWR sky130_fd_sc_hd__tapvpwrvgnd_1
XFILLER_13_238 VGND VGND VPWR VPWR sky130_fd_sc_hd__decap_4
XPHY_EDGE_ROW_48_Right_48 VGND VGND VPWR VPWR sky130_fd_sc_hd__decap_3
XPHY_EDGE_ROW_57_Right_57 VGND VGND VPWR VPWR sky130_fd_sc_hd__decap_3
XTAP_TAPCELL_ROW_8_286 VGND VPWR sky130_fd_sc_hd__tapvpwrvgnd_1
XFILLER_0_153 VPWR VGND VPWR VGND sky130_ef_sc_hd__decap_12
XFILLER_88_293 VGND VGND VPWR VPWR sky130_fd_sc_hd__fill_1
XFILLER_0_197 VGND VGND VPWR VPWR sky130_fd_sc_hd__fill_2
XFILLER_76_477 VGND VGND VPWR VPWR sky130_fd_sc_hd__decap_3
XFILLER_28_60 VGND VGND VPWR VPWR sky130_fd_sc_hd__decap_6
XFILLER_29_393 VPWR VGND VPWR VGND sky130_ef_sc_hd__decap_12
XFILLER_63_149 VGND VGND VPWR VPWR sky130_fd_sc_hd__decap_3
XPHY_EDGE_ROW_66_Right_66 VGND VGND VPWR VPWR sky130_fd_sc_hd__decap_3
XTAP_TAPCELL_ROW_62_829 VGND VPWR sky130_fd_sc_hd__tapvpwrvgnd_1
XFILLER_44_396 VGND VGND VPWR VPWR sky130_fd_sc_hd__decap_6
XFILLER_8_253 VGND VGND VPWR VPWR sky130_fd_sc_hd__decap_6
X_2660_ net387 _0934_ net289 net630 VGND VGND VPWR VPWR _0938_ sky130_fd_sc_hd__a22o_1
XPHY_EDGE_ROW_75_Right_75 VGND VGND VPWR VPWR sky130_fd_sc_hd__decap_3
X_2591_ net585 net399 net506 VGND VGND VPWR VPWR _0890_ sky130_fd_sc_hd__and3_1
X_4330_ net575 net428 net331 net645 net221 VGND VGND VPWR VPWR _2168_ sky130_fd_sc_hd__a221o_1
X_4261_ net567 net430 net334 net637 VGND VGND VPWR VPWR _2124_ sky130_fd_sc_hd__a22o_1
X_3212_ net758 net486 net181 net699 _1320_ VGND VGND VPWR VPWR _1321_ sky130_fd_sc_hd__a221o_1
XFILLER_39_113 VPWR VGND VPWR VGND sky130_ef_sc_hd__decap_12
X_4192_ net750 net236 VGND VGND VPWR VPWR _2077_ sky130_fd_sc_hd__and2_1
XPHY_EDGE_ROW_19_Left_114 VGND VGND VPWR VPWR sky130_fd_sc_hd__decap_3
X_3143_ net735 net185 _1271_ net189 VGND VGND VPWR VPWR _1272_ sky130_fd_sc_hd__a211o_1
XPHY_EDGE_ROW_84_Right_84 VGND VGND VPWR VPWR sky130_fd_sc_hd__decap_3
XTAP_TAPCELL_ROW_78_984 VGND VPWR sky130_fd_sc_hd__tapvpwrvgnd_1
X_3074_ _1150_ _1222_ net489 VGND VGND VPWR VPWR _1224_ sky130_fd_sc_hd__a21o_1
XFILLER_23_503 VGND VGND VPWR VPWR sky130_fd_sc_hd__fill_1
XFILLER_35_374 VGND VGND VPWR VPWR sky130_fd_sc_hd__decap_6
X_3976_ array\[9\]\[18\] net548 net536 array\[11\]\[18\] _1896_ VGND VGND VPWR VPWR
+ _1897_ sky130_fd_sc_hd__a221o_1
XTAP_TAPCELL_ROW_33_531 VGND VPWR sky130_fd_sc_hd__tapvpwrvgnd_1
X_2927_ net1241 net199 _1118_ VGND VGND VPWR VPWR _0092_ sky130_fd_sc_hd__o21a_1
XPHY_EDGE_ROW_28_Left_123 VGND VGND VPWR VPWR sky130_fd_sc_hd__decap_3
XPHY_EDGE_ROW_93_Right_93 VGND VGND VPWR VPWR sky130_fd_sc_hd__decap_3
X_2858_ net383 _1068_ net564 VGND VGND VPWR VPWR _1072_ sky130_fd_sc_hd__and3b_2
X_2789_ net1226 net287 net281 net701 _1026_ VGND VGND VPWR VPWR _0046_ sky130_fd_sc_hd__a221o_1
Xhold220 array\[11\]\[20\] VGND VGND VPWR VPWR net986 sky130_fd_sc_hd__dlygate4sd3_1
Xhold242 array\[4\]\[8\] VGND VGND VPWR VPWR net1008 sky130_fd_sc_hd__dlygate4sd3_1
Xhold231 array\[2\]\[19\] VGND VGND VPWR VPWR net997 sky130_fd_sc_hd__dlygate4sd3_1
X_4528_ clknet_leaf_2_clk _0059_ VGND VGND VPWR VPWR array\[8\]\[21\] sky130_fd_sc_hd__dfxtp_1
Xhold253 array\[6\]\[24\] VGND VGND VPWR VPWR net1019 sky130_fd_sc_hd__dlygate4sd3_1
Xhold275 array\[3\]\[27\] VGND VGND VPWR VPWR net1041 sky130_fd_sc_hd__dlygate4sd3_1
X_4459_ clknet_leaf_23_clk _0570_ VGND VGND VPWR VPWR array\[4\]\[16\] sky130_fd_sc_hd__dfxtp_1
Xhold286 array\[6\]\[12\] VGND VGND VPWR VPWR net1052 sky130_fd_sc_hd__dlygate4sd3_1
Xfanout700 net38 VGND VGND VPWR VPWR net700 sky130_fd_sc_hd__dlymetal6s2s_1
Xhold264 array\[6\]\[10\] VGND VGND VPWR VPWR net1030 sky130_fd_sc_hd__dlygate4sd3_1
Xfanout711 net32 VGND VGND VPWR VPWR net711 sky130_fd_sc_hd__buf_2
Xfanout733 net21 VGND VGND VPWR VPWR net733 sky130_fd_sc_hd__buf_2
Xfanout722 net27 VGND VGND VPWR VPWR net722 sky130_fd_sc_hd__dlymetal6s2s_1
Xhold297 array\[5\]\[21\] VGND VGND VPWR VPWR net1063 sky130_fd_sc_hd__dlygate4sd3_1
Xfanout744 net16 VGND VGND VPWR VPWR net744 sky130_fd_sc_hd__clkbuf_2
Xfanout755 net11 VGND VGND VPWR VPWR net755 sky130_fd_sc_hd__dlymetal6s2s_1
Xfanout766 net1 VGND VGND VPWR VPWR net766 sky130_fd_sc_hd__buf_2
XPHY_EDGE_ROW_37_Left_132 VGND VGND VPWR VPWR sky130_fd_sc_hd__decap_3
XTAP_TAPCELL_ROW_5_256 VGND VPWR sky130_fd_sc_hd__tapvpwrvgnd_1
XFILLER_73_447 VGND VGND VPWR VPWR sky130_fd_sc_hd__fill_1
XANTENNA_104 net401 VGND VGND VPWR VPWR sky130_fd_sc_hd__diode_2
XANTENNA_115 net446 VGND VGND VPWR VPWR sky130_fd_sc_hd__diode_2
XANTENNA_126 _0787_ VGND VGND VPWR VPWR sky130_fd_sc_hd__diode_2
XANTENNA_137 net180 VGND VGND VPWR VPWR sky130_fd_sc_hd__diode_2
XANTENNA_148 net330 VGND VGND VPWR VPWR sky130_fd_sc_hd__diode_2
XFILLER_14_525 VGND VGND VPWR VPWR sky130_fd_sc_hd__decap_6
XANTENNA_159 net508 VGND VGND VPWR VPWR sky130_fd_sc_hd__diode_2
XFILLER_41_300 VGND VGND VPWR VPWR sky130_fd_sc_hd__fill_1
XFILLER_81_57 VPWR VGND VPWR VGND sky130_ef_sc_hd__decap_12
XFILLER_41_366 VGND VGND VPWR VPWR sky130_fd_sc_hd__decap_4
XPHY_EDGE_ROW_46_Left_141 VGND VGND VPWR VPWR sky130_fd_sc_hd__decap_3
XFILLER_41_388 VGND VGND VPWR VPWR sky130_fd_sc_hd__decap_4
XFILLER_5_223 VGND VGND VPWR VPWR sky130_fd_sc_hd__fill_1
XPHY_EDGE_ROW_55_Left_150 VGND VGND VPWR VPWR sky130_fd_sc_hd__decap_3
XFILLER_1_473 VPWR VGND VPWR VGND sky130_ef_sc_hd__decap_12
XFILLER_39_70 VGND VGND VPWR VPWR sky130_fd_sc_hd__fill_1
XTAP_TAPCELL_ROW_75_954 VGND VPWR sky130_fd_sc_hd__tapvpwrvgnd_1
XTAP_TAPCELL_ROW_47_678 VGND VPWR sky130_fd_sc_hd__tapvpwrvgnd_1
X_3830_ net417 _1757_ _1761_ net437 VGND VGND VPWR VPWR _1764_ sky130_fd_sc_hd__a22o_1
XTAP_TAPCELL_ROW_30_501 VGND VPWR sky130_fd_sc_hd__tapvpwrvgnd_1
X_3761_ net1269 net239 _1700_ _1701_ VGND VGND VPWR VPWR _0343_ sky130_fd_sc_hd__o22a_1
X_2712_ net789 _0972_ net293 VGND VGND VPWR VPWR _0023_ sky130_fd_sc_hd__mux2_1
X_3692_ net962 net237 _1655_ _1656_ VGND VGND VPWR VPWR _0319_ sky130_fd_sc_hd__o22a_1
X_2643_ net580 net511 net397 net650 VGND VGND VPWR VPWR _0924_ sky130_fd_sc_hd__a22o_1
X_2574_ net707 net401 net508 VGND VGND VPWR VPWR _0879_ sky130_fd_sc_hd__and3_1
X_4313_ net730 net338 VGND VGND VPWR VPWR _2157_ sky130_fd_sc_hd__and2_1
XFILLER_87_517 VPWR VGND VPWR VGND sky130_ef_sc_hd__decap_12
XFILLER_19_18 VGND VGND VPWR VPWR sky130_fd_sc_hd__decap_6
X_4244_ net654 _1621_ VGND VGND VPWR VPWR _2112_ sky130_fd_sc_hd__or2_2
X_4175_ net1084 net227 _2065_ _2066_ VGND VGND VPWR VPWR _0396_ sky130_fd_sc_hd__o22a_1
XFILLER_67_241 VGND VGND VPWR VPWR sky130_fd_sc_hd__fill_1
XTAP_TAPCELL_ROW_2_226 VGND VPWR sky130_fd_sc_hd__tapvpwrvgnd_1
X_3126_ net1122 net163 _1260_ VGND VGND VPWR VPWR _0149_ sky130_fd_sc_hd__o21a_1
XFILLER_27_149 VGND VGND VPWR VPWR sky130_fd_sc_hd__fill_2
XTAP_TAPCELL_ROW_85_1050 VGND VPWR sky130_fd_sc_hd__tapvpwrvgnd_1
X_3057_ net721 net194 _1210_ net380 VGND VGND VPWR VPWR _1211_ sky130_fd_sc_hd__a22o_1
XFILLER_63_480 VGND VGND VPWR VPWR sky130_fd_sc_hd__decap_4
XTAP_TAPCELL_ROW_18_380 VGND VPWR sky130_fd_sc_hd__tapvpwrvgnd_1
XFILLER_50_141 VPWR VGND VPWR VGND sky130_ef_sc_hd__decap_12
XFILLER_11_517 VPWR VGND VPWR VGND sky130_ef_sc_hd__decap_12
X_3959_ array\[5\]\[17\] net555 net540 array\[7\]\[17\] _1880_ VGND VGND VPWR VPWR
+ _1881_ sky130_fd_sc_hd__a221o_1
XFILLER_78_517 VPWR VGND VPWR VGND sky130_ef_sc_hd__decap_12
Xfanout541 net542 VGND VGND VPWR VPWR net541 sky130_fd_sc_hd__buf_2
Xfanout530 net533 VGND VGND VPWR VPWR net530 sky130_fd_sc_hd__buf_2
Xfanout552 net558 VGND VGND VPWR VPWR net552 sky130_fd_sc_hd__clkbuf_4
Xfanout574 net95 VGND VGND VPWR VPWR net574 sky130_fd_sc_hd__clkbuf_2
Xfanout563 net564 VGND VGND VPWR VPWR net563 sky130_fd_sc_hd__buf_2
XFILLER_86_561 VGND VGND VPWR VPWR sky130_fd_sc_hd__fill_1
Xfanout585 net9 VGND VGND VPWR VPWR net585 sky130_fd_sc_hd__buf_2
Xfanout596 net85 VGND VGND VPWR VPWR net596 sky130_fd_sc_hd__dlymetal6s2s_1
XFILLER_73_277 VGND VGND VPWR VPWR sky130_fd_sc_hd__decap_3
XFILLER_73_288 VGND VGND VPWR VPWR sky130_fd_sc_hd__decap_3
XTAP_TAPCELL_ROW_72_924 VGND VPWR sky130_fd_sc_hd__tapvpwrvgnd_1
XTAP_TAPCELL_ROW_44_648 VGND VPWR sky130_fd_sc_hd__tapvpwrvgnd_1
XFILLER_14_344 VGND VGND VPWR VPWR sky130_fd_sc_hd__decap_4
XFILLER_25_94 VGND VGND VPWR VPWR sky130_fd_sc_hd__fill_2
XFILLER_10_561 VGND VGND VPWR VPWR sky130_fd_sc_hd__fill_1
X_2290_ net902 net326 _0678_ VGND VGND VPWR VPWR _0475_ sky130_fd_sc_hd__o21a_1
XFILLER_37_6 VPWR VGND VPWR VGND sky130_ef_sc_hd__decap_12
XFILLER_1_281 VPWR VGND VPWR VGND sky130_ef_sc_hd__decap_12
XFILLER_77_561 VGND VGND VPWR VPWR sky130_fd_sc_hd__fill_1
XFILLER_92_531 VGND VGND VPWR VPWR sky130_fd_sc_hd__fill_1
XFILLER_37_458 VGND VGND VPWR VPWR sky130_fd_sc_hd__decap_4
XFILLER_64_277 VGND VGND VPWR VPWR sky130_fd_sc_hd__decap_4
X_4862_ clknet_leaf_31_clk _0393_ VGND VGND VPWR VPWR array\[7\]\[5\] sky130_fd_sc_hd__dfxtp_1
XFILLER_32_141 VGND VGND VPWR VPWR sky130_fd_sc_hd__decap_4
XTAP_TAPCELL_ROW_15_350 VGND VPWR sky130_fd_sc_hd__tapvpwrvgnd_1
X_3813_ array\[6\]\[4\] net466 net449 array\[4\]\[4\] VGND VGND VPWR VPWR _1748_ sky130_fd_sc_hd__a22o_1
X_4793_ clknet_leaf_18_clk _0324_ VGND VGND VPWR VPWR array\[9\]\[11\] sky130_fd_sc_hd__dfxtp_1
XANTENNA_26 _1299_ VGND VGND VPWR VPWR sky130_fd_sc_hd__diode_2
XANTENNA_15 _1151_ VGND VGND VPWR VPWR sky130_fd_sc_hd__diode_2
XANTENNA_48 _1635_ VGND VGND VPWR VPWR sky130_fd_sc_hd__diode_2
XANTENNA_37 _1442_ VGND VGND VPWR VPWR sky130_fd_sc_hd__diode_2
XANTENNA_59 _2112_ VGND VGND VPWR VPWR sky130_fd_sc_hd__diode_2
X_3744_ net727 net349 net421 VGND VGND VPWR VPWR _1690_ sky130_fd_sc_hd__and3_1
XFILLER_9_381 VGND VGND VPWR VPWR sky130_fd_sc_hd__decap_4
X_3675_ net739 net348 net419 VGND VGND VPWR VPWR _1645_ sky130_fd_sc_hd__and3_1
X_2626_ net1274 net297 _0912_ _0913_ VGND VGND VPWR VPWR _0576_ sky130_fd_sc_hd__o22a_1
Xoutput122 net122 VGND VGND VPWR VPWR out[11] sky130_fd_sc_hd__buf_2
Xoutput133 net133 VGND VGND VPWR VPWR out[21] sky130_fd_sc_hd__buf_2
X_2557_ net655 _0865_ VGND VGND VPWR VPWR _0867_ sky130_fd_sc_hd__or2_2
Xoutput144 net144 VGND VGND VPWR VPWR out[31] sky130_fd_sc_hd__buf_2
X_2488_ net754 net306 _0816_ net404 net310 VGND VGND VPWR VPWR _0817_ sky130_fd_sc_hd__a221o_1
X_4227_ net1227 net228 _2100_ VGND VGND VPWR VPWR _0414_ sky130_fd_sc_hd__o21a_1
XFILLER_28_447 VGND VGND VPWR VPWR sky130_fd_sc_hd__fill_2
X_4158_ net572 net432 net340 net642 VGND VGND VPWR VPWR _2055_ sky130_fd_sc_hd__a22o_1
X_3109_ net608 net186 VGND VGND VPWR VPWR _1249_ sky130_fd_sc_hd__and2_1
X_4089_ net352 _1993_ _1997_ net436 VGND VGND VPWR VPWR _2000_ sky130_fd_sc_hd__a22o_1
XFILLER_43_417 VGND VGND VPWR VPWR sky130_fd_sc_hd__decap_3
XFILLER_55_266 VGND VGND VPWR VPWR sky130_fd_sc_hd__decap_6
XFILLER_43_428 VGND VGND VPWR VPWR sky130_fd_sc_hd__fill_2
XTAP_TAPCELL_ROW_41_618 VGND VPWR sky130_fd_sc_hd__tapvpwrvgnd_1
XFILLER_23_185 VGND VGND VPWR VPWR sky130_fd_sc_hd__fill_2
XTAP_TAPCELL_ROW_94_1149 VGND VPWR sky130_fd_sc_hd__tapvpwrvgnd_1
XFILLER_2_3 VPWR VGND VPWR VGND sky130_ef_sc_hd__decap_12
Xfanout382 _1151_ VGND VGND VPWR VPWR net382 sky130_fd_sc_hd__clkbuf_4
Xfanout393 net394 VGND VGND VPWR VPWR net393 sky130_fd_sc_hd__buf_4
Xfanout371 _1301_ VGND VGND VPWR VPWR net371 sky130_fd_sc_hd__buf_4
Xfanout360 net361 VGND VGND VPWR VPWR net360 sky130_fd_sc_hd__clkbuf_4
XFILLER_59_561 VGND VGND VPWR VPWR sky130_fd_sc_hd__fill_1
XTAP_TAPCELL_ROW_29_497 VGND VPWR sky130_fd_sc_hd__tapvpwrvgnd_1
XTAP_TAPCELL_ROW_57_773 VGND VPWR sky130_fd_sc_hd__tapvpwrvgnd_1
XFILLER_14_130 VGND VGND VPWR VPWR sky130_fd_sc_hd__fill_1
XFILLER_14_141 VGND VGND VPWR VPWR sky130_fd_sc_hd__decap_6
XTAP_TAPCELL_ROW_12_320 VGND VPWR sky130_fd_sc_hd__tapvpwrvgnd_1
Xinput13 value0[15] VGND VGND VPWR VPWR net13 sky130_fd_sc_hd__buf_1
Xinput46 value1[16] VGND VGND VPWR VPWR net46 sky130_fd_sc_hd__buf_1
Xinput24 value0[25] VGND VGND VPWR VPWR net24 sky130_fd_sc_hd__buf_1
Xinput35 value0[6] VGND VGND VPWR VPWR net35 sky130_fd_sc_hd__buf_1
Xinput79 value2[17] VGND VGND VPWR VPWR net79 sky130_fd_sc_hd__buf_1
Xinput57 value1[26] VGND VGND VPWR VPWR net57 sky130_fd_sc_hd__buf_1
Xinput68 value1[7] VGND VGND VPWR VPWR net68 sky130_fd_sc_hd__buf_1
X_3460_ net898 net262 _1489_ _1490_ VGND VGND VPWR VPWR _0253_ sky130_fd_sc_hd__o22a_1
X_3391_ net1222 net259 _1443_ _1444_ VGND VGND VPWR VPWR _0230_ sky130_fd_sc_hd__o22a_1
X_2411_ net593 net667 net519 VGND VGND VPWR VPWR _0762_ sky130_fd_sc_hd__mux2_1
X_2342_ net654 _0714_ VGND VGND VPWR VPWR _0716_ sky130_fd_sc_hd__or2_1
X_2273_ net691 net619 net523 VGND VGND VPWR VPWR _0667_ sky130_fd_sc_hd__mux2_1
X_4012_ net415 _1924_ _1928_ net355 VGND VGND VPWR VPWR _1930_ sky130_fd_sc_hd__a22o_1
XFILLER_77_391 VGND VGND VPWR VPWR sky130_fd_sc_hd__fill_1
XFILLER_37_233 VGND VGND VPWR VPWR sky130_fd_sc_hd__decap_8
XFILLER_37_277 VGND VGND VPWR VPWR sky130_fd_sc_hd__decap_3
XTAP_TAPCELL_ROW_82_1020 VGND VPWR sky130_fd_sc_hd__tapvpwrvgnd_1
XFILLER_80_545 VPWR VGND VPWR VGND sky130_ef_sc_hd__decap_12
X_4914_ clknet_leaf_41_clk _0445_ VGND VGND VPWR VPWR array\[6\]\[25\] sky130_fd_sc_hd__dfxtp_1
XFILLER_52_236 VGND VGND VPWR VPWR sky130_fd_sc_hd__decap_8
X_4845_ clknet_leaf_44_clk _0376_ VGND VGND VPWR VPWR net144 sky130_fd_sc_hd__dfxtp_1
XFILLER_32_18 VGND VGND VPWR VPWR sky130_fd_sc_hd__decap_8
XFILLER_32_29 VPWR VGND VPWR VGND sky130_ef_sc_hd__decap_12
X_4776_ clknet_leaf_61_clk _0307_ VGND VGND VPWR VPWR ready_check\[5\] sky130_fd_sc_hd__dfxtp_1
X_3727_ net604 net423 net344 net678 net241 VGND VGND VPWR VPWR _1679_ sky130_fd_sc_hd__a221o_1
X_3658_ net211 _1589_ _1607_ _1631_ VGND VGND VPWR VPWR _0310_ sky130_fd_sc_hd__o31a_1
X_2609_ net745 net399 net506 VGND VGND VPWR VPWR _0902_ sky130_fd_sc_hd__and3_1
X_3589_ tail\[0\] _1578_ net562 VGND VGND VPWR VPWR _1579_ sky130_fd_sc_hd__o21ai_1
XFILLER_87_111 VGND VGND VPWR VPWR sky130_fd_sc_hd__fill_1
XFILLER_0_505 VPWR VGND VPWR VGND sky130_ef_sc_hd__decap_12
XFILLER_57_15 VPWR VGND VPWR VGND sky130_ef_sc_hd__decap_12
XFILLER_43_225 VPWR VGND VPWR VGND sky130_ef_sc_hd__decap_12
XTAP_TAPCELL_ROW_54_743 VGND VPWR sky130_fd_sc_hd__tapvpwrvgnd_1
XTAP_TAPCELL_ROW_26_467 VGND VPWR sky130_fd_sc_hd__tapvpwrvgnd_1
XFILLER_43_269 VGND VGND VPWR VPWR sky130_fd_sc_hd__decap_3
XFILLER_93_125 VPWR VGND VPWR VGND sky130_ef_sc_hd__decap_12
Xfanout190 net192 VGND VGND VPWR VPWR net190 sky130_fd_sc_hd__buf_4
XFILLER_93_169 VGND VGND VPWR VPWR sky130_fd_sc_hd__decap_8
XFILLER_74_361 VGND VGND VPWR VPWR sky130_fd_sc_hd__decap_3
X_2960_ tail\[2\] net105 net525 VGND VGND VPWR VPWR _1142_ sky130_fd_sc_hd__mux2_1
X_2891_ net1161 net200 _1094_ VGND VGND VPWR VPWR _0080_ sky130_fd_sc_hd__o21a_1
X_4630_ clknet_leaf_29_clk _0161_ VGND VGND VPWR VPWR array\[14\]\[27\] sky130_fd_sc_hd__dfxtp_1
X_4561_ clknet_leaf_57_clk _0092_ VGND VGND VPWR VPWR array\[0\]\[22\] sky130_fd_sc_hd__dfxtp_1
X_4492_ clknet_leaf_23_clk _0023_ VGND VGND VPWR VPWR array\[5\]\[17\] sky130_fd_sc_hd__dfxtp_1
X_3512_ net706 net246 _1527_ net252 VGND VGND VPWR VPWR _1528_ sky130_fd_sc_hd__a211o_1
X_3443_ net605 net478 net364 net679 VGND VGND VPWR VPWR _1479_ sky130_fd_sc_hd__a22o_1
X_3374_ net804 net154 _1429_ _1430_ VGND VGND VPWR VPWR _0227_ sky130_fd_sc_hd__o22a_1
X_2325_ net719 net319 _0701_ net410 net327 VGND VGND VPWR VPWR _0702_ sky130_fd_sc_hd__a221o_1
XFILLER_57_306 VGND VGND VPWR VPWR sky130_fd_sc_hd__decap_4
XFILLER_69_188 VGND VGND VPWR VPWR sky130_fd_sc_hd__decap_8
XFILLER_27_18 VPWR VGND VPWR VGND sky130_ef_sc_hd__decap_12
X_2256_ net705 net320 _0655_ net411 net328 VGND VGND VPWR VPWR _0656_ sky130_fd_sc_hd__a221o_1
X_2187_ _0002_ _0597_ VGND VGND VPWR VPWR _0598_ sky130_fd_sc_hd__nor2_1
XFILLER_53_501 VGND VGND VPWR VPWR sky130_fd_sc_hd__fill_1
XFILLER_80_353 VGND VGND VPWR VPWR sky130_fd_sc_hd__decap_8
XTAP_TAPCELL_ROW_51_713 VGND VPWR sky130_fd_sc_hd__tapvpwrvgnd_1
XTAP_TAPCELL_ROW_23_437 VGND VPWR sky130_fd_sc_hd__tapvpwrvgnd_1
X_4828_ clknet_leaf_0_clk _0359_ VGND VGND VPWR VPWR net125 sky130_fd_sc_hd__dfxtp_1
X_4759_ clknet_leaf_52_clk _0290_ VGND VGND VPWR VPWR array\[10\]\[28\] sky130_fd_sc_hd__dfxtp_1
XTAP_TAPCELL_ROW_91_1119 VGND VPWR sky130_fd_sc_hd__tapvpwrvgnd_1
XFILLER_75_169 VGND VGND VPWR VPWR sky130_fd_sc_hd__decap_4
XFILLER_90_139 VGND VGND VPWR VPWR sky130_fd_sc_hd__fill_1
XTAP_TAPCELL_ROW_39_592 VGND VPWR sky130_fd_sc_hd__tapvpwrvgnd_1
XFILLER_56_394 VPWR VGND VPWR VGND sky130_ef_sc_hd__decap_12
XFILLER_12_475 VGND VGND VPWR VPWR sky130_fd_sc_hd__fill_1
XFILLER_33_72 VGND VGND VPWR VPWR sky130_fd_sc_hd__fill_1
XFILLER_8_457 VPWR VGND VPWR VGND sky130_ef_sc_hd__decap_12
Xhold2 net139 VGND VGND VPWR VPWR net768 sky130_fd_sc_hd__dlygate4sd3_1
X_3090_ net1022 net161 _1236_ VGND VGND VPWR VPWR _0137_ sky130_fd_sc_hd__o21a_1
XFILLER_94_489 VGND VGND VPWR VPWR sky130_fd_sc_hd__decap_4
XFILLER_35_545 VGND VGND VPWR VPWR sky130_fd_sc_hd__fill_2
XFILLER_62_342 VGND VGND VPWR VPWR sky130_fd_sc_hd__fill_1
X_3992_ array\[6\]\[20\] net459 net442 array\[4\]\[20\] VGND VGND VPWR VPWR _1911_
+ sky130_fd_sc_hd__a22o_1
X_2943_ net582 net658 net498 VGND VGND VPWR VPWR _1129_ sky130_fd_sc_hd__mux2_1
X_2874_ net568 net638 net499 VGND VGND VPWR VPWR _1083_ sky130_fd_sc_hd__mux2_1
XTAP_TAPCELL_ROW_20_407 VGND VPWR sky130_fd_sc_hd__tapvpwrvgnd_1
X_4613_ clknet_leaf_46_clk _0144_ VGND VGND VPWR VPWR array\[14\]\[10\] sky130_fd_sc_hd__dfxtp_1
X_4544_ clknet_leaf_27_clk _0075_ VGND VGND VPWR VPWR array\[0\]\[5\] sky130_fd_sc_hd__dfxtp_1
Xhold402 array\[6\]\[13\] VGND VGND VPWR VPWR net1168 sky130_fd_sc_hd__dlygate4sd3_1
Xhold413 array\[6\]\[18\] VGND VGND VPWR VPWR net1179 sky130_fd_sc_hd__dlygate4sd3_1
Xhold435 array\[9\]\[29\] VGND VGND VPWR VPWR net1201 sky130_fd_sc_hd__dlygate4sd3_1
Xhold424 array\[7\]\[0\] VGND VGND VPWR VPWR net1190 sky130_fd_sc_hd__dlygate4sd3_1
Xhold457 array\[14\]\[12\] VGND VGND VPWR VPWR net1223 sky130_fd_sc_hd__dlygate4sd3_1
Xhold468 array\[7\]\[25\] VGND VGND VPWR VPWR net1234 sky130_fd_sc_hd__dlygate4sd3_1
X_4475_ clknet_leaf_55_clk _0006_ VGND VGND VPWR VPWR array\[5\]\[0\] sky130_fd_sc_hd__dfxtp_1
Xhold446 array\[14\]\[14\] VGND VGND VPWR VPWR net1212 sky130_fd_sc_hd__dlygate4sd3_1
Xmax_cap198 _1153_ VGND VGND VPWR VPWR net198 sky130_fd_sc_hd__clkbuf_2
Xhold479 array\[15\]\[4\] VGND VGND VPWR VPWR net1245 sky130_fd_sc_hd__dlygate4sd3_1
X_3426_ net764 net256 _1467_ net264 VGND VGND VPWR VPWR _1468_ sky130_fd_sc_hd__a211o_1
X_3357_ net730 net175 VGND VGND VPWR VPWR _1419_ sky130_fd_sc_hd__and2_1
X_2308_ net1056 net324 _0690_ VGND VGND VPWR VPWR _0481_ sky130_fd_sc_hd__o21a_1
X_3288_ net625 net481 net367 net697 VGND VGND VPWR VPWR _1374_ sky130_fd_sc_hd__a22o_1
XFILLER_57_169 VGND VGND VPWR VPWR sky130_fd_sc_hd__decap_3
X_2239_ net858 _0644_ net324 VGND VGND VPWR VPWR _0458_ sky130_fd_sc_hd__mux2_1
XTAP_TAPCELL_ROW_88_1081 VGND VPWR sky130_fd_sc_hd__tapvpwrvgnd_1
XFILLER_72_139 VGND VGND VPWR VPWR sky130_fd_sc_hd__fill_1
XFILLER_26_545 VGND VGND VPWR VPWR sky130_fd_sc_hd__fill_2
XTAP_TAPCELL_ROW_36_562 VGND VPWR sky130_fd_sc_hd__tapvpwrvgnd_1
XFILLER_80_194 VGND VGND VPWR VPWR sky130_fd_sc_hd__fill_2
XTAP_TAPCELL_ROW_0_198 VGND VPWR sky130_fd_sc_hd__tapvpwrvgnd_1
XFILLER_70_15 VPWR VGND VPWR VGND sky130_ef_sc_hd__decap_12
XFILLER_5_449 VPWR VGND VPWR VGND sky130_ef_sc_hd__decap_12
XFILLER_79_57 VPWR VGND VPWR VGND sky130_ef_sc_hd__decap_12
XTAP_TAPCELL_ROW_8_287 VGND VPWR sky130_fd_sc_hd__tapvpwrvgnd_1
XFILLER_76_412 VGND VGND VPWR VPWR sky130_fd_sc_hd__decap_8
XFILLER_0_165 VGND VGND VPWR VPWR sky130_fd_sc_hd__decap_3
XFILLER_36_309 VGND VGND VPWR VPWR sky130_fd_sc_hd__fill_1
XFILLER_32_504 VGND VGND VPWR VPWR sky130_fd_sc_hd__decap_4
XFILLER_44_353 VGND VGND VPWR VPWR sky130_fd_sc_hd__decap_3
XFILLER_8_243 VGND VGND VPWR VPWR sky130_fd_sc_hd__decap_8
XFILLER_8_276 VGND VGND VPWR VPWR sky130_fd_sc_hd__decap_3
X_2590_ net1311 net302 _0868_ net607 _0889_ VGND VGND VPWR VPWR _0564_ sky130_fd_sc_hd__a221o_1
X_4260_ net954 net220 _2122_ _2123_ VGND VGND VPWR VPWR _0424_ sky130_fd_sc_hd__o22a_1
X_3211_ net627 net371 VGND VGND VPWR VPWR _1320_ sky130_fd_sc_hd__and2_1
X_4191_ net752 net233 net229 net1228 _2076_ VGND VGND VPWR VPWR _0402_ sky130_fd_sc_hd__a221o_1
X_3142_ net597 net489 net375 net671 VGND VGND VPWR VPWR _1271_ sky130_fd_sc_hd__a22o_1
XFILLER_39_125 VGND VGND VPWR VPWR sky130_fd_sc_hd__decap_6
XTAP_TAPCELL_ROW_78_985 VGND VPWR sky130_fd_sc_hd__tapvpwrvgnd_1
X_3073_ _1150_ _1222_ net489 VGND VGND VPWR VPWR _1223_ sky130_fd_sc_hd__a21oi_1
XFILLER_27_309 VGND VGND VPWR VPWR sky130_fd_sc_hd__fill_1
XFILLER_35_364 VGND VGND VPWR VPWR sky130_fd_sc_hd__fill_1
XFILLER_24_19 VGND VGND VPWR VPWR sky130_fd_sc_hd__decap_8
X_3975_ array\[10\]\[18\] net462 net445 array\[8\]\[18\] VGND VGND VPWR VPWR _1896_
+ sky130_fd_sc_hd__a22o_1
XTAP_TAPCELL_ROW_33_532 VGND VPWR sky130_fd_sc_hd__tapvpwrvgnd_1
X_2926_ net734 net271 _1117_ net383 net268 VGND VGND VPWR VPWR _1118_ sky130_fd_sc_hd__a221o_1
X_2857_ net383 _1068_ VGND VGND VPWR VPWR _1071_ sky130_fd_sc_hd__nand2b_1
XFILLER_40_29 VPWR VGND VPWR VGND sky130_ef_sc_hd__decap_12
Xhold210 array\[1\]\[8\] VGND VGND VPWR VPWR net976 sky130_fd_sc_hd__dlygate4sd3_1
X_2788_ net760 net503 net277 net631 VGND VGND VPWR VPWR _1026_ sky130_fd_sc_hd__a22o_1
Xhold221 array\[3\]\[16\] VGND VGND VPWR VPWR net987 sky130_fd_sc_hd__dlygate4sd3_1
Xhold243 array\[11\]\[11\] VGND VGND VPWR VPWR net1009 sky130_fd_sc_hd__dlygate4sd3_1
XFILLER_2_408 VPWR VGND VPWR VGND sky130_ef_sc_hd__decap_12
X_4527_ clknet_leaf_4_clk _0058_ VGND VGND VPWR VPWR array\[8\]\[20\] sky130_fd_sc_hd__dfxtp_1
Xhold232 array\[8\]\[13\] VGND VGND VPWR VPWR net998 sky130_fd_sc_hd__dlygate4sd3_1
Xhold254 array\[14\]\[25\] VGND VGND VPWR VPWR net1020 sky130_fd_sc_hd__dlygate4sd3_1
Xhold265 array\[8\]\[25\] VGND VGND VPWR VPWR net1031 sky130_fd_sc_hd__dlygate4sd3_1
X_4458_ clknet_leaf_35_clk _0569_ VGND VGND VPWR VPWR array\[4\]\[15\] sky130_fd_sc_hd__dfxtp_1
Xhold276 array\[1\]\[15\] VGND VGND VPWR VPWR net1042 sky130_fd_sc_hd__dlygate4sd3_1
Xhold287 array\[9\]\[15\] VGND VGND VPWR VPWR net1053 sky130_fd_sc_hd__dlygate4sd3_1
Xfanout723 net26 VGND VGND VPWR VPWR net723 sky130_fd_sc_hd__buf_2
Xfanout701 net37 VGND VGND VPWR VPWR net701 sky130_fd_sc_hd__buf_2
Xhold298 array\[2\]\[14\] VGND VGND VPWR VPWR net1064 sky130_fd_sc_hd__dlygate4sd3_1
X_3409_ net1023 net259 _1456_ VGND VGND VPWR VPWR _0236_ sky130_fd_sc_hd__o21a_1
Xfanout712 net32 VGND VGND VPWR VPWR net712 sky130_fd_sc_hd__buf_1
Xfanout745 net15 VGND VGND VPWR VPWR net745 sky130_fd_sc_hd__clkbuf_2
Xfanout734 net21 VGND VGND VPWR VPWR net734 sky130_fd_sc_hd__dlymetal6s2s_1
X_4389_ clknet_leaf_53_clk _0500_ VGND VGND VPWR VPWR array\[2\]\[10\] sky130_fd_sc_hd__dfxtp_1
Xfanout756 net108 VGND VGND VPWR VPWR net756 sky130_fd_sc_hd__clkbuf_4
XTAP_TAPCELL_ROW_5_257 VGND VPWR sky130_fd_sc_hd__tapvpwrvgnd_1
XFILLER_18_309 VGND VGND VPWR VPWR sky130_fd_sc_hd__fill_1
XANTENNA_116 net463 VGND VGND VPWR VPWR sky130_fd_sc_hd__diode_2
XANTENNA_105 net401 VGND VGND VPWR VPWR sky130_fd_sc_hd__diode_2
XANTENNA_149 net330 VGND VGND VPWR VPWR sky130_fd_sc_hd__diode_2
XANTENNA_138 net233 VGND VGND VPWR VPWR sky130_fd_sc_hd__diode_2
XANTENNA_127 _1300_ VGND VGND VPWR VPWR sky130_fd_sc_hd__diode_2
XFILLER_81_492 VGND VGND VPWR VPWR sky130_fd_sc_hd__fill_1
XFILLER_26_397 VGND VGND VPWR VPWR sky130_fd_sc_hd__decap_3
XFILLER_81_69 VGND VGND VPWR VPWR sky130_fd_sc_hd__decap_8
XFILLER_14_52 VPWR VGND VPWR VGND sky130_ef_sc_hd__decap_12
XFILLER_14_85 VPWR VGND VPWR VGND sky130_ef_sc_hd__decap_12
XFILLER_1_441 VGND VGND VPWR VPWR sky130_fd_sc_hd__decap_6
XFILLER_1_485 VPWR VGND VPWR VGND sky130_ef_sc_hd__decap_12
XFILLER_76_253 VGND VGND VPWR VPWR sky130_fd_sc_hd__decap_3
XFILLER_36_106 VGND VGND VPWR VPWR sky130_fd_sc_hd__fill_1
XTAP_TAPCELL_ROW_75_955 VGND VPWR sky130_fd_sc_hd__tapvpwrvgnd_1
XTAP_TAPCELL_ROW_47_679 VGND VPWR sky130_fd_sc_hd__tapvpwrvgnd_1
XTAP_TAPCELL_ROW_30_502 VGND VPWR sky130_fd_sc_hd__tapvpwrvgnd_1
X_3760_ net575 net426 net347 net645 net244 VGND VGND VPWR VPWR _1701_ sky130_fd_sc_hd__a221o_1
XFILLER_71_91 VGND VGND VPWR VPWR sky130_fd_sc_hd__decap_6
X_2711_ net745 net290 _0971_ net390 VGND VGND VPWR VPWR _0972_ sky130_fd_sc_hd__a22o_1
XFILLER_9_541 VPWR VGND VPWR VGND sky130_ef_sc_hd__decap_12
X_3691_ net566 net424 net344 net636 net241 VGND VGND VPWR VPWR _1656_ sky130_fd_sc_hd__a221o_1
X_2642_ net1178 _0867_ _0922_ _0923_ VGND VGND VPWR VPWR _0582_ sky130_fd_sc_hd__o22a_1
X_2573_ net1176 net299 _0877_ _0878_ VGND VGND VPWR VPWR _0558_ sky130_fd_sc_hd__o22a_1
X_4312_ net1224 net223 net337 net731 _2156_ VGND VGND VPWR VPWR _0443_ sky130_fd_sc_hd__a221o_1
X_4243_ net655 _1621_ VGND VGND VPWR VPWR _2111_ sky130_fd_sc_hd__nor2_2
XFILLER_87_529 VPWR VGND VPWR VGND sky130_ef_sc_hd__decap_12
X_4174_ net761 net434 net343 net632 net232 VGND VGND VPWR VPWR _2066_ sky130_fd_sc_hd__a221o_1
XTAP_TAPCELL_ROW_2_227 VGND VPWR sky130_fd_sc_hd__tapvpwrvgnd_1
XFILLER_27_106 VGND VGND VPWR VPWR sky130_fd_sc_hd__decap_6
X_3125_ net750 net187 _1259_ net191 VGND VGND VPWR VPWR _1260_ sky130_fd_sc_hd__a211o_1
XFILLER_82_223 VGND VGND VPWR VPWR sky130_fd_sc_hd__fill_1
X_3056_ net657 net581 net494 VGND VGND VPWR VPWR _1210_ sky130_fd_sc_hd__mux2_1
XTAP_TAPCELL_ROW_85_1051 VGND VPWR sky130_fd_sc_hd__tapvpwrvgnd_1
XFILLER_23_323 VGND VGND VPWR VPWR sky130_fd_sc_hd__fill_2
XTAP_TAPCELL_ROW_18_381 VGND VPWR sky130_fd_sc_hd__tapvpwrvgnd_1
XFILLER_11_529 VPWR VGND VPWR VGND sky130_ef_sc_hd__decap_12
X_3958_ array\[6\]\[17\] net469 net452 array\[4\]\[17\] VGND VGND VPWR VPWR _1880_
+ sky130_fd_sc_hd__a22o_1
X_2909_ net960 net201 _1106_ VGND VGND VPWR VPWR _0086_ sky130_fd_sc_hd__o21a_1
X_3889_ net352 _1812_ _1816_ net436 net215 VGND VGND VPWR VPWR _1818_ sky130_fd_sc_hd__a221o_1
XFILLER_2_205 VGND VGND VPWR VPWR sky130_fd_sc_hd__decap_3
XFILLER_78_529 VGND VGND VPWR VPWR sky130_fd_sc_hd__decap_3
Xfanout520 _0708_ VGND VGND VPWR VPWR net520 sky130_fd_sc_hd__clkbuf_4
Xfanout531 net533 VGND VGND VPWR VPWR net531 sky130_fd_sc_hd__clkbuf_4
Xfanout542 _0608_ VGND VGND VPWR VPWR net542 sky130_fd_sc_hd__buf_4
Xfanout575 net94 VGND VGND VPWR VPWR net575 sky130_fd_sc_hd__buf_2
Xfanout564 _0587_ VGND VGND VPWR VPWR net564 sky130_fd_sc_hd__clkbuf_2
Xfanout553 net558 VGND VGND VPWR VPWR net553 sky130_fd_sc_hd__buf_2
Xfanout586 net9 VGND VGND VPWR VPWR net586 sky130_fd_sc_hd__dlymetal6s2s_1
Xfanout597 net84 VGND VGND VPWR VPWR net597 sky130_fd_sc_hd__buf_2
XFILLER_73_223 VGND VGND VPWR VPWR sky130_fd_sc_hd__fill_1
XFILLER_46_448 VPWR VGND VPWR VGND sky130_ef_sc_hd__decap_12
XTAP_TAPCELL_ROW_72_925 VGND VPWR sky130_fd_sc_hd__tapvpwrvgnd_1
XTAP_TAPCELL_ROW_44_649 VGND VPWR sky130_fd_sc_hd__tapvpwrvgnd_1
XFILLER_6_533 VPWR VGND VPWR VGND sky130_ef_sc_hd__decap_12
XFILLER_41_94 VGND VGND VPWR VPWR sky130_fd_sc_hd__fill_2
XFILLER_1_293 VGND VGND VPWR VPWR sky130_fd_sc_hd__decap_4
XFILLER_49_242 VGND VGND VPWR VPWR sky130_fd_sc_hd__decap_6
XFILLER_37_437 VGND VGND VPWR VPWR sky130_fd_sc_hd__fill_1
X_4861_ clknet_leaf_42_clk _0392_ VGND VGND VPWR VPWR array\[7\]\[4\] sky130_fd_sc_hd__dfxtp_1
XTAP_TAPCELL_ROW_15_351 VGND VPWR sky130_fd_sc_hd__tapvpwrvgnd_1
X_3812_ array\[13\]\[4\] net552 net532 array\[15\]\[4\] _1746_ VGND VGND VPWR VPWR
+ _1747_ sky130_fd_sc_hd__a221o_1
XANTENNA_16 _1151_ VGND VGND VPWR VPWR sky130_fd_sc_hd__diode_2
X_4792_ clknet_leaf_46_clk _0323_ VGND VGND VPWR VPWR array\[9\]\[10\] sky130_fd_sc_hd__dfxtp_1
XFILLER_32_197 VGND VGND VPWR VPWR sky130_fd_sc_hd__fill_1
XANTENNA_27 _1299_ VGND VGND VPWR VPWR sky130_fd_sc_hd__diode_2
XANTENNA_38 _1442_ VGND VGND VPWR VPWR sky130_fd_sc_hd__diode_2
XANTENNA_49 _1639_ VGND VGND VPWR VPWR sky130_fd_sc_hd__diode_2
X_3743_ net945 net239 _1688_ _1689_ VGND VGND VPWR VPWR _0337_ sky130_fd_sc_hd__o22a_1
XFILLER_9_393 VGND VGND VPWR VPWR sky130_fd_sc_hd__decap_4
X_3674_ net1012 net237 _1642_ _1644_ VGND VGND VPWR VPWR _0313_ sky130_fd_sc_hd__o22a_1
X_2625_ net596 net509 net395 net670 net300 VGND VGND VPWR VPWR _0913_ sky130_fd_sc_hd__a221o_1
Xoutput123 net123 VGND VGND VPWR VPWR out[12] sky130_fd_sc_hd__buf_2
Xoutput134 net134 VGND VGND VPWR VPWR out[22] sky130_fd_sc_hd__buf_2
Xoutput145 net145 VGND VGND VPWR VPWR out[3] sky130_fd_sc_hd__buf_2
X_2556_ net655 _0865_ VGND VGND VPWR VPWR _0866_ sky130_fd_sc_hd__nor2_2
X_2487_ net689 net617 net515 VGND VGND VPWR VPWR _0816_ sky130_fd_sc_hd__mux2_1
X_4226_ net725 net234 net230 _2099_ VGND VGND VPWR VPWR _2100_ sky130_fd_sc_hd__a211o_1
XFILLER_68_540 VGND VGND VPWR VPWR sky130_fd_sc_hd__fill_1
X_4157_ net1051 net226 _2054_ VGND VGND VPWR VPWR _0390_ sky130_fd_sc_hd__o21a_1
XPHY_EDGE_ROW_74_Left_169 VGND VGND VPWR VPWR sky130_fd_sc_hd__decap_3
X_3108_ net819 net162 _1248_ VGND VGND VPWR VPWR _0143_ sky130_fd_sc_hd__o21a_1
X_4088_ array\[9\]\[28\] net550 net529 array\[11\]\[28\] _1998_ VGND VGND VPWR VPWR
+ _1999_ sky130_fd_sc_hd__a221o_1
XFILLER_70_204 VPWR VGND VPWR VGND sky130_ef_sc_hd__decap_12
X_3039_ net733 net193 _1198_ net379 VGND VGND VPWR VPWR _1199_ sky130_fd_sc_hd__a22o_1
XFILLER_70_248 VGND VGND VPWR VPWR sky130_fd_sc_hd__decap_4
XTAP_TAPCELL_ROW_41_619 VGND VPWR sky130_fd_sc_hd__tapvpwrvgnd_1
XFILLER_11_337 VGND VGND VPWR VPWR sky130_fd_sc_hd__decap_4
XPHY_EDGE_ROW_83_Left_178 VGND VGND VPWR VPWR sky130_fd_sc_hd__decap_3
XFILLER_3_503 VGND VGND VPWR VPWR sky130_fd_sc_hd__fill_1
XFILLER_11_64 VGND VGND VPWR VPWR sky130_fd_sc_hd__decap_3
XFILLER_11_97 VGND VGND VPWR VPWR sky130_fd_sc_hd__fill_2
XFILLER_87_57 VPWR VGND VPWR VGND sky130_ef_sc_hd__decap_12
Xfanout350 _1636_ VGND VGND VPWR VPWR net350 sky130_fd_sc_hd__buf_4
XPHY_EDGE_ROW_92_Left_187 VGND VGND VPWR VPWR sky130_fd_sc_hd__decap_3
Xfanout372 _1301_ VGND VGND VPWR VPWR net372 sky130_fd_sc_hd__clkbuf_2
Xfanout383 _1067_ VGND VGND VPWR VPWR net383 sky130_fd_sc_hd__clkbuf_4
Xfanout361 net362 VGND VGND VPWR VPWR net361 sky130_fd_sc_hd__clkbuf_4
XFILLER_59_551 VGND VGND VPWR VPWR sky130_fd_sc_hd__fill_1
Xfanout394 _0930_ VGND VGND VPWR VPWR net394 sky130_fd_sc_hd__buf_4
XFILLER_74_554 VGND VGND VPWR VPWR sky130_fd_sc_hd__decap_8
XTAP_TAPCELL_ROW_57_774 VGND VPWR sky130_fd_sc_hd__tapvpwrvgnd_1
XPHY_EDGE_ROW_1_Left_96 VGND VGND VPWR VPWR sky130_fd_sc_hd__decap_3
XTAP_TAPCELL_ROW_29_498 VGND VPWR sky130_fd_sc_hd__tapvpwrvgnd_1
XTAP_TAPCELL_ROW_12_321 VGND VPWR sky130_fd_sc_hd__tapvpwrvgnd_1
Xinput14 value0[16] VGND VGND VPWR VPWR net14 sky130_fd_sc_hd__buf_1
Xinput25 value0[26] VGND VGND VPWR VPWR net25 sky130_fd_sc_hd__buf_1
Xinput36 value0[7] VGND VGND VPWR VPWR net36 sky130_fd_sc_hd__buf_1
Xinput58 value1[27] VGND VGND VPWR VPWR net58 sky130_fd_sc_hd__buf_1
Xinput47 value1[17] VGND VGND VPWR VPWR net47 sky130_fd_sc_hd__buf_1
Xinput69 value1[8] VGND VGND VPWR VPWR net69 sky130_fd_sc_hd__buf_1
X_2410_ net1150 net207 _0761_ VGND VGND VPWR VPWR _0512_ sky130_fd_sc_hd__o21a_1
X_3390_ net626 net477 net255 net630 net263 VGND VGND VPWR VPWR _1444_ sky130_fd_sc_hd__a221o_1
X_2341_ net406 _0711_ net563 VGND VGND VPWR VPWR _0715_ sky130_fd_sc_hd__and3b_2
X_2272_ net931 net325 _0666_ VGND VGND VPWR VPWR _0469_ sky130_fd_sc_hd__o21a_1
XFILLER_69_359 VPWR VGND VPWR VGND sky130_ef_sc_hd__decap_12
XFILLER_69_337 VGND VGND VPWR VPWR sky130_fd_sc_hd__fill_1
XFILLER_77_90 VGND VGND VPWR VPWR sky130_fd_sc_hd__decap_6
XFILLER_28_3 VGND VGND VPWR VPWR sky130_fd_sc_hd__decap_4
X_4011_ net435 _1922_ _1926_ net351 VGND VGND VPWR VPWR _1929_ sky130_fd_sc_hd__a22o_1
XFILLER_65_532 VGND VGND VPWR VPWR sky130_fd_sc_hd__decap_3
XFILLER_37_223 VGND VGND VPWR VPWR sky130_fd_sc_hd__fill_1
XTAP_TAPCELL_ROW_82_1021 VGND VPWR sky130_fd_sc_hd__tapvpwrvgnd_1
XFILLER_80_557 VGND VGND VPWR VPWR sky130_fd_sc_hd__decap_4
X_4913_ clknet_leaf_36_clk _0444_ VGND VGND VPWR VPWR array\[6\]\[24\] sky130_fd_sc_hd__dfxtp_1
X_4844_ clknet_leaf_25_clk _0375_ VGND VGND VPWR VPWR net143 sky130_fd_sc_hd__dfxtp_1
X_4775_ clknet_leaf_64_clk _0306_ VGND VGND VPWR VPWR ready_check\[6\] sky130_fd_sc_hd__dfxtp_1
X_3726_ net742 net348 net419 VGND VGND VPWR VPWR _1678_ sky130_fd_sc_hd__and3_1
X_3657_ net563 ready_check\[2\] _1630_ _0714_ VGND VGND VPWR VPWR _1631_ sky130_fd_sc_hd__a31o_1
X_2608_ net1075 net299 _0900_ _0901_ VGND VGND VPWR VPWR _0570_ sky130_fd_sc_hd__o22a_1
X_3588_ net766 _0588_ net2 VGND VGND VPWR VPWR _1578_ sky130_fd_sc_hd__o21a_2
X_2539_ net716 net307 _0850_ net404 net311 VGND VGND VPWR VPWR _0851_ sky130_fd_sc_hd__a221o_1
XFILLER_0_517 VPWR VGND VPWR VGND sky130_ef_sc_hd__decap_12
XFILLER_57_27 VGND VGND VPWR VPWR sky130_fd_sc_hd__decap_8
XFILLER_68_392 VGND VGND VPWR VPWR sky130_fd_sc_hd__fill_1
X_4209_ net1110 net228 _2088_ VGND VGND VPWR VPWR _0408_ sky130_fd_sc_hd__o21a_1
XFILLER_43_237 VGND VGND VPWR VPWR sky130_fd_sc_hd__decap_4
XTAP_TAPCELL_ROW_54_744 VGND VPWR sky130_fd_sc_hd__tapvpwrvgnd_1
XTAP_TAPCELL_ROW_26_468 VGND VPWR sky130_fd_sc_hd__tapvpwrvgnd_1
XFILLER_51_281 VGND VGND VPWR VPWR sky130_fd_sc_hd__fill_1
XFILLER_11_167 VGND VGND VPWR VPWR sky130_fd_sc_hd__fill_1
XFILLER_78_134 VGND VGND VPWR VPWR sky130_fd_sc_hd__decap_6
Xfanout180 _1370_ VGND VGND VPWR VPWR net180 sky130_fd_sc_hd__clkbuf_8
Xfanout191 net192 VGND VGND VPWR VPWR net191 sky130_fd_sc_hd__buf_2
XFILLER_34_215 VGND VGND VPWR VPWR sky130_fd_sc_hd__decap_3
X_2890_ net607 net272 _1093_ net385 net269 VGND VGND VPWR VPWR _1094_ sky130_fd_sc_hd__a221o_1
XFILLER_30_421 VGND VGND VPWR VPWR sky130_fd_sc_hd__fill_2
XFILLER_42_270 VPWR VGND VPWR VGND sky130_ef_sc_hd__decap_12
X_4560_ clknet_leaf_0_clk _0091_ VGND VGND VPWR VPWR array\[0\]\[21\] sky130_fd_sc_hd__dfxtp_1
X_4491_ clknet_leaf_22_clk _0022_ VGND VGND VPWR VPWR array\[5\]\[16\] sky130_fd_sc_hd__dfxtp_1
X_3511_ net566 net475 net360 net636 VGND VGND VPWR VPWR _1527_ sky130_fd_sc_hd__a22o_1
X_3442_ net1078 net261 _1478_ VGND VGND VPWR VPWR _0247_ sky130_fd_sc_hd__o21a_1
X_3373_ net579 net483 net368 net649 net178 VGND VGND VPWR VPWR _1430_ sky130_fd_sc_hd__a221o_1
X_2324_ net649 net579 net521 VGND VGND VPWR VPWR _0701_ sky130_fd_sc_hd__mux2_1
XFILLER_38_521 VGND VGND VPWR VPWR sky130_fd_sc_hd__decap_8
X_2255_ net635 net565 net522 VGND VGND VPWR VPWR _0655_ sky130_fd_sc_hd__mux2_1
X_2186_ ready_check\[0\] ready_check\[1\] ready_check\[2\] ready_check\[3\] _0000_
+ _0001_ VGND VGND VPWR VPWR _0597_ sky130_fd_sc_hd__mux4_1
XFILLER_80_365 VGND VGND VPWR VPWR sky130_fd_sc_hd__fill_1
XTAP_TAPCELL_ROW_23_438 VGND VPWR sky130_fd_sc_hd__tapvpwrvgnd_1
XTAP_TAPCELL_ROW_51_714 VGND VPWR sky130_fd_sc_hd__tapvpwrvgnd_1
X_4827_ clknet_leaf_11_clk _0358_ VGND VGND VPWR VPWR net124 sky130_fd_sc_hd__dfxtp_1
XFILLER_21_443 VGND VGND VPWR VPWR sky130_fd_sc_hd__fill_1
X_4758_ clknet_leaf_21_clk _0289_ VGND VGND VPWR VPWR array\[10\]\[27\] sky130_fd_sc_hd__dfxtp_1
X_4689_ clknet_leaf_60_clk _0220_ VGND VGND VPWR VPWR array\[12\]\[22\] sky130_fd_sc_hd__dfxtp_1
X_3709_ net619 net424 net344 net691 net241 VGND VGND VPWR VPWR _1668_ sky130_fd_sc_hd__a221o_1
XFILLER_68_15 VPWR VGND VPWR VGND sky130_ef_sc_hd__decap_12
XFILLER_88_421 VPWR VGND VPWR VGND sky130_ef_sc_hd__decap_12
XFILLER_71_321 VGND VGND VPWR VPWR sky130_fd_sc_hd__fill_1
XTAP_TAPCELL_ROW_39_593 VGND VPWR sky130_fd_sc_hd__tapvpwrvgnd_1
XFILLER_12_421 VPWR VGND VPWR VGND sky130_ef_sc_hd__decap_12
XFILLER_8_403 VGND VGND VPWR VPWR sky130_fd_sc_hd__fill_1
XFILLER_8_469 VGND VGND VPWR VPWR sky130_fd_sc_hd__decap_6
XFILLER_3_130 VPWR VGND VPWR VGND sky130_ef_sc_hd__decap_12
XFILLER_94_413 VGND VGND VPWR VPWR sky130_fd_sc_hd__decap_6
Xhold3 net140 VGND VGND VPWR VPWR net769 sky130_fd_sc_hd__dlygate4sd3_1
XFILLER_94_468 VGND VGND VPWR VPWR sky130_fd_sc_hd__decap_4
XFILLER_74_192 VGND VGND VPWR VPWR sky130_fd_sc_hd__decap_4
X_3991_ net773 net171 _1910_ VGND VGND VPWR VPWR _0364_ sky130_fd_sc_hd__o21a_1
X_2942_ net994 net201 _1128_ VGND VGND VPWR VPWR _0097_ sky130_fd_sc_hd__o21a_1
XFILLER_30_240 VGND VGND VPWR VPWR sky130_fd_sc_hd__fill_1
XTAP_TAPCELL_ROW_20_408 VGND VPWR sky130_fd_sc_hd__tapvpwrvgnd_1
X_2873_ net1265 net200 _1082_ VGND VGND VPWR VPWR _0074_ sky130_fd_sc_hd__o21a_1
X_4612_ clknet_leaf_50_clk _0143_ VGND VGND VPWR VPWR array\[14\]\[9\] sky130_fd_sc_hd__dfxtp_1
X_4543_ clknet_leaf_40_clk _0074_ VGND VGND VPWR VPWR array\[0\]\[4\] sky130_fd_sc_hd__dfxtp_1
Xhold414 array\[14\]\[0\] VGND VGND VPWR VPWR net1180 sky130_fd_sc_hd__dlygate4sd3_1
Xhold436 array\[1\]\[22\] VGND VGND VPWR VPWR net1202 sky130_fd_sc_hd__dlygate4sd3_1
Xhold403 array\[4\]\[9\] VGND VGND VPWR VPWR net1169 sky130_fd_sc_hd__dlygate4sd3_1
Xhold425 array\[9\]\[21\] VGND VGND VPWR VPWR net1191 sky130_fd_sc_hd__dlygate4sd3_1
Xhold447 array\[4\]\[27\] VGND VGND VPWR VPWR net1213 sky130_fd_sc_hd__dlygate4sd3_1
Xhold469 array\[0\]\[3\] VGND VGND VPWR VPWR net1235 sky130_fd_sc_hd__dlygate4sd3_1
X_4474_ clknet_leaf_45_clk _0005_ VGND VGND VPWR VPWR array\[4\]\[31\] sky130_fd_sc_hd__dfxtp_1
Xhold458 array\[6\]\[23\] VGND VGND VPWR VPWR net1224 sky130_fd_sc_hd__dlygate4sd3_1
X_3425_ net619 net478 net364 net691 VGND VGND VPWR VPWR _1467_ sky130_fd_sc_hd__a22o_1
X_3356_ _1417_ _1418_ VGND VGND VPWR VPWR _0221_ sky130_fd_sc_hd__or2_1
X_3287_ net481 _1150_ _0861_ VGND VGND VPWR VPWR _1373_ sky130_fd_sc_hd__and3b_1
X_2307_ net731 net320 _0689_ net410 net328 VGND VGND VPWR VPWR _0690_ sky130_fd_sc_hd__a221o_1
X_2238_ net629 net320 _0643_ net411 VGND VGND VPWR VPWR _0644_ sky130_fd_sc_hd__a22o_1
XFILLER_38_362 VGND VGND VPWR VPWR sky130_fd_sc_hd__fill_2
XTAP_TAPCELL_ROW_88_1082 VGND VPWR sky130_fd_sc_hd__tapvpwrvgnd_1
XFILLER_26_524 VGND VGND VPWR VPWR sky130_fd_sc_hd__decap_8
XTAP_TAPCELL_ROW_36_563 VGND VPWR sky130_fd_sc_hd__tapvpwrvgnd_1
XTAP_TAPCELL_ROW_0_199 VGND VPWR sky130_fd_sc_hd__tapvpwrvgnd_1
XFILLER_70_27 VGND VGND VPWR VPWR sky130_fd_sc_hd__fill_1
XFILLER_21_240 VGND VGND VPWR VPWR sky130_fd_sc_hd__fill_1
XFILLER_79_69 VGND VGND VPWR VPWR sky130_fd_sc_hd__fill_1
XTAP_TAPCELL_ROW_8_288 VGND VPWR sky130_fd_sc_hd__tapvpwrvgnd_1
XFILLER_0_188 VGND VGND VPWR VPWR sky130_fd_sc_hd__decap_4
XFILLER_0_177 VGND VGND VPWR VPWR sky130_fd_sc_hd__fill_1
XFILLER_44_365 VGND VGND VPWR VPWR sky130_fd_sc_hd__decap_4
XFILLER_32_538 VGND VGND VPWR VPWR sky130_fd_sc_hd__fill_1
XFILLER_12_251 VGND VGND VPWR VPWR sky130_fd_sc_hd__fill_1
XFILLER_8_211 VPWR VGND VPWR VGND sky130_ef_sc_hd__decap_12
XFILLER_8_266 VGND VGND VPWR VPWR sky130_fd_sc_hd__fill_2
X_3210_ net880 _1319_ net160 VGND VGND VPWR VPWR _0174_ sky130_fd_sc_hd__mux2_1
X_4190_ net616 net431 net340 net688 VGND VGND VPWR VPWR _2076_ sky130_fd_sc_hd__a22o_1
X_3141_ net1149 net164 _1270_ VGND VGND VPWR VPWR _0154_ sky130_fd_sc_hd__o21a_1
XFILLER_79_295 VGND VGND VPWR VPWR sky130_fd_sc_hd__decap_3
XFILLER_10_3 VGND VGND VPWR VPWR sky130_fd_sc_hd__fill_1
XTAP_TAPCELL_ROW_78_986 VGND VPWR sky130_fd_sc_hd__tapvpwrvgnd_1
X_3072_ net757 net756 VGND VGND VPWR VPWR _1222_ sky130_fd_sc_hd__and2b_2
XFILLER_23_505 VGND VGND VPWR VPWR sky130_fd_sc_hd__decap_8
XFILLER_90_471 VGND VGND VPWR VPWR sky130_fd_sc_hd__decap_4
XFILLER_35_387 VGND VGND VPWR VPWR sky130_fd_sc_hd__decap_4
X_3974_ array\[1\]\[18\] net547 net536 array\[3\]\[18\] _1894_ VGND VGND VPWR VPWR
+ _1895_ sky130_fd_sc_hd__a221o_1
XTAP_TAPCELL_ROW_33_533 VGND VPWR sky130_fd_sc_hd__tapvpwrvgnd_1
XFILLER_62_195 VGND VGND VPWR VPWR sky130_fd_sc_hd__fill_1
X_2925_ net596 net670 net497 VGND VGND VPWR VPWR _1117_ sky130_fd_sc_hd__mux2_1
X_2856_ net626 net698 net497 VGND VGND VPWR VPWR _1070_ sky130_fd_sc_hd__mux2_1
X_2787_ net1292 net284 _1024_ _1025_ VGND VGND VPWR VPWR _0045_ sky130_fd_sc_hd__o22a_1
Xhold200 array\[5\]\[19\] VGND VGND VPWR VPWR net966 sky130_fd_sc_hd__dlygate4sd3_1
Xhold211 net131 VGND VGND VPWR VPWR net977 sky130_fd_sc_hd__dlygate4sd3_1
Xhold244 array\[15\]\[18\] VGND VGND VPWR VPWR net1010 sky130_fd_sc_hd__dlygate4sd3_1
Xhold233 array\[6\]\[11\] VGND VGND VPWR VPWR net999 sky130_fd_sc_hd__dlygate4sd3_1
Xhold222 array\[14\]\[24\] VGND VGND VPWR VPWR net988 sky130_fd_sc_hd__dlygate4sd3_1
X_4526_ clknet_leaf_58_clk _0057_ VGND VGND VPWR VPWR array\[8\]\[19\] sky130_fd_sc_hd__dfxtp_1
Xhold266 array\[15\]\[0\] VGND VGND VPWR VPWR net1032 sky130_fd_sc_hd__dlygate4sd3_1
Xhold255 array\[1\]\[31\] VGND VGND VPWR VPWR net1021 sky130_fd_sc_hd__dlygate4sd3_1
X_4457_ clknet_leaf_2_clk _0568_ VGND VGND VPWR VPWR array\[4\]\[14\] sky130_fd_sc_hd__dfxtp_1
Xhold277 array\[9\]\[12\] VGND VGND VPWR VPWR net1043 sky130_fd_sc_hd__dlygate4sd3_1
Xfanout724 net26 VGND VGND VPWR VPWR net724 sky130_fd_sc_hd__clkbuf_2
Xfanout702 net37 VGND VGND VPWR VPWR net702 sky130_fd_sc_hd__dlymetal6s2s_1
Xhold288 array\[10\]\[13\] VGND VGND VPWR VPWR net1054 sky130_fd_sc_hd__dlygate4sd3_1
Xfanout713 net31 VGND VGND VPWR VPWR net713 sky130_fd_sc_hd__buf_2
Xhold299 array\[11\]\[14\] VGND VGND VPWR VPWR net1065 sky130_fd_sc_hd__dlygate4sd3_1
X_3408_ net706 net255 _1455_ net263 VGND VGND VPWR VPWR _1456_ sky130_fd_sc_hd__a211o_1
Xfanout746 net15 VGND VGND VPWR VPWR net746 sky130_fd_sc_hd__dlymetal6s2s_1
X_4388_ clknet_leaf_53_clk _0499_ VGND VGND VPWR VPWR array\[2\]\[9\] sky130_fd_sc_hd__dfxtp_1
Xfanout757 net107 VGND VGND VPWR VPWR net757 sky130_fd_sc_hd__buf_2
Xfanout735 net20 VGND VGND VPWR VPWR net735 sky130_fd_sc_hd__buf_2
X_3339_ net899 net154 _1406_ _1407_ VGND VGND VPWR VPWR _0215_ sky130_fd_sc_hd__o22a_1
XFILLER_85_232 VGND VGND VPWR VPWR sky130_fd_sc_hd__fill_2
XTAP_TAPCELL_ROW_5_258 VGND VPWR sky130_fd_sc_hd__tapvpwrvgnd_1
XANTENNA_106 net401 VGND VGND VPWR VPWR sky130_fd_sc_hd__diode_2
XANTENNA_117 net472 VGND VGND VPWR VPWR sky130_fd_sc_hd__diode_2
XANTENNA_139 net261 VGND VGND VPWR VPWR sky130_fd_sc_hd__diode_2
XANTENNA_128 _1300_ VGND VGND VPWR VPWR sky130_fd_sc_hd__diode_2
XFILLER_81_15 VPWR VGND VPWR VGND sky130_ef_sc_hd__decap_12
XFILLER_22_560 VGND VGND VPWR VPWR sky130_fd_sc_hd__fill_2
XFILLER_14_64 VPWR VGND VPWR VGND sky130_ef_sc_hd__decap_12
XFILLER_5_203 VGND VGND VPWR VPWR sky130_fd_sc_hd__decap_3
XFILLER_5_214 VGND VGND VPWR VPWR sky130_fd_sc_hd__fill_2
XFILLER_30_41 VGND VGND VPWR VPWR sky130_fd_sc_hd__decap_4
XFILLER_76_210 VGND VGND VPWR VPWR sky130_fd_sc_hd__fill_1
XFILLER_1_497 VGND VGND VPWR VPWR sky130_fd_sc_hd__decap_6
XTAP_TAPCELL_ROW_75_956 VGND VPWR sky130_fd_sc_hd__tapvpwrvgnd_1
XFILLER_17_310 VGND VGND VPWR VPWR sky130_fd_sc_hd__decap_6
Xclkbuf_leaf_56_clk clknet_3_1__leaf_clk VGND VGND VPWR VPWR clknet_leaf_56_clk sky130_fd_sc_hd__clkbuf_8
XFILLER_36_118 VGND VGND VPWR VPWR sky130_fd_sc_hd__fill_1
XFILLER_32_302 VGND VGND VPWR VPWR sky130_fd_sc_hd__decap_6
XFILLER_44_195 VGND VGND VPWR VPWR sky130_fd_sc_hd__fill_1
XTAP_TAPCELL_ROW_30_503 VGND VPWR sky130_fd_sc_hd__tapvpwrvgnd_1
X_2710_ net681 net609 net392 VGND VGND VPWR VPWR _0971_ sky130_fd_sc_hd__mux2_1
XFILLER_9_553 VGND VGND VPWR VPWR sky130_fd_sc_hd__decap_6
X_3690_ net706 net348 net419 VGND VGND VPWR VPWR _1655_ sky130_fd_sc_hd__and3_1
X_2641_ net582 net511 net397 net658 net302 VGND VGND VPWR VPWR _0923_ sky130_fd_sc_hd__a221o_1
X_2572_ net569 net511 net397 net639 net302 VGND VGND VPWR VPWR _0878_ sky130_fd_sc_hd__a221o_1
XFILLER_58_3 VPWR VGND VPWR VGND sky130_ef_sc_hd__decap_12
X_4311_ net593 net429 net333 net668 VGND VGND VPWR VPWR _2156_ sky130_fd_sc_hd__a22o_1
X_4242_ net1083 net226 _2109_ _2110_ VGND VGND VPWR VPWR _0419_ sky130_fd_sc_hd__o22a_1
X_4173_ net702 net236 VGND VGND VPWR VPWR _2065_ sky130_fd_sc_hd__and2_1
XTAP_TAPCELL_ROW_2_228 VGND VPWR sky130_fd_sc_hd__tapvpwrvgnd_1
X_3124_ net614 net492 net377 net686 VGND VGND VPWR VPWR _1259_ sky130_fd_sc_hd__a22o_1
X_3055_ net1104 _1209_ net168 VGND VGND VPWR VPWR _0129_ sky130_fd_sc_hd__mux2_1
XFILLER_67_298 VGND VGND VPWR VPWR sky130_fd_sc_hd__fill_1
XFILLER_55_449 VGND VGND VPWR VPWR sky130_fd_sc_hd__decap_4
Xclkbuf_leaf_47_clk clknet_3_2__leaf_clk VGND VGND VPWR VPWR clknet_leaf_47_clk sky130_fd_sc_hd__clkbuf_8
XTAP_TAPCELL_ROW_85_1052 VGND VPWR sky130_fd_sc_hd__tapvpwrvgnd_1
XFILLER_23_302 VGND VGND VPWR VPWR sky130_fd_sc_hd__fill_2
XFILLER_35_151 VGND VGND VPWR VPWR sky130_fd_sc_hd__decap_4
XTAP_TAPCELL_ROW_18_382 VGND VPWR sky130_fd_sc_hd__tapvpwrvgnd_1
XFILLER_23_335 VGND VGND VPWR VPWR sky130_fd_sc_hd__fill_1
X_3957_ net791 net172 _1878_ _1879_ VGND VGND VPWR VPWR _0361_ sky130_fd_sc_hd__o22a_1
X_2908_ net747 net273 _1105_ net386 net270 VGND VGND VPWR VPWR _1106_ sky130_fd_sc_hd__a221o_1
X_3888_ net357 _1810_ _1814_ net417 VGND VGND VPWR VPWR _1817_ sky130_fd_sc_hd__a22o_1
X_2839_ net583 net505 net277 net659 VGND VGND VPWR VPWR _1058_ sky130_fd_sc_hd__a22o_1
X_4509_ clknet_leaf_39_clk _0040_ VGND VGND VPWR VPWR array\[8\]\[2\] sky130_fd_sc_hd__dfxtp_1
XFILLER_76_15 VPWR VGND VPWR VGND sky130_ef_sc_hd__decap_12
Xfanout521 net522 VGND VGND VPWR VPWR net521 sky130_fd_sc_hd__buf_4
Xfanout510 _0858_ VGND VGND VPWR VPWR net510 sky130_fd_sc_hd__clkbuf_4
Xfanout532 net533 VGND VGND VPWR VPWR net532 sky130_fd_sc_hd__clkbuf_2
Xfanout543 net545 VGND VGND VPWR VPWR net543 sky130_fd_sc_hd__clkbuf_4
Xfanout554 net558 VGND VGND VPWR VPWR net554 sky130_fd_sc_hd__clkbuf_4
Xfanout565 net99 VGND VGND VPWR VPWR net565 sky130_fd_sc_hd__buf_2
Xfanout576 net94 VGND VGND VPWR VPWR net576 sky130_fd_sc_hd__dlymetal6s2s_1
Xfanout587 net89 VGND VGND VPWR VPWR net587 sky130_fd_sc_hd__buf_2
Xfanout598 net84 VGND VGND VPWR VPWR net598 sky130_fd_sc_hd__clkbuf_2
XFILLER_73_202 VGND VGND VPWR VPWR sky130_fd_sc_hd__fill_2
XFILLER_18_118 VGND VGND VPWR VPWR sky130_fd_sc_hd__fill_1
XFILLER_58_298 VGND VGND VPWR VPWR sky130_fd_sc_hd__decap_3
Xclkbuf_leaf_38_clk clknet_3_6__leaf_clk VGND VGND VPWR VPWR clknet_leaf_38_clk sky130_fd_sc_hd__clkbuf_8
XTAP_TAPCELL_ROW_72_926 VGND VPWR sky130_fd_sc_hd__tapvpwrvgnd_1
XFILLER_54_471 VGND VGND VPWR VPWR sky130_fd_sc_hd__decap_4
XFILLER_54_493 VGND VGND VPWR VPWR sky130_fd_sc_hd__decap_4
XFILLER_6_501 VPWR VGND VPWR VGND sky130_ef_sc_hd__decap_12
XFILLER_6_545 VPWR VGND VPWR VGND sky130_ef_sc_hd__decap_12
XFILLER_1_261 VPWR VGND VPWR VGND sky130_ef_sc_hd__decap_12
XFILLER_77_530 VPWR VGND VPWR VGND sky130_ef_sc_hd__decap_12
XFILLER_49_265 VGND VGND VPWR VPWR sky130_fd_sc_hd__decap_3
XFILLER_92_533 VPWR VGND VPWR VGND sky130_ef_sc_hd__decap_12
XFILLER_66_70 VGND VGND VPWR VPWR sky130_fd_sc_hd__decap_3
Xclkbuf_leaf_29_clk clknet_3_7__leaf_clk VGND VGND VPWR VPWR clknet_leaf_29_clk sky130_fd_sc_hd__clkbuf_8
XFILLER_52_419 VGND VGND VPWR VPWR sky130_fd_sc_hd__fill_1
X_4860_ clknet_leaf_5_clk _0391_ VGND VGND VPWR VPWR array\[7\]\[3\] sky130_fd_sc_hd__dfxtp_1
XTAP_TAPCELL_ROW_15_352 VGND VPWR sky130_fd_sc_hd__tapvpwrvgnd_1
X_3811_ array\[14\]\[4\] net466 net449 array\[12\]\[4\] VGND VGND VPWR VPWR _1746_
+ sky130_fd_sc_hd__a22o_1
XANTENNA_17 _1152_ VGND VGND VPWR VPWR sky130_fd_sc_hd__diode_2
X_4791_ clknet_leaf_49_clk _0322_ VGND VGND VPWR VPWR array\[9\]\[9\] sky130_fd_sc_hd__dfxtp_1
XANTENNA_39 _1606_ VGND VGND VPWR VPWR sky130_fd_sc_hd__diode_2
XANTENNA_28 _1299_ VGND VGND VPWR VPWR sky130_fd_sc_hd__diode_2
X_3742_ net591 net426 net347 net665 net244 VGND VGND VPWR VPWR _1689_ sky130_fd_sc_hd__a221o_1
X_3673_ net626 net423 net344 net698 net241 VGND VGND VPWR VPWR _1644_ sky130_fd_sc_hd__a221o_1
X_2624_ net734 net399 net506 VGND VGND VPWR VPWR _0912_ sky130_fd_sc_hd__and3_1
Xoutput124 net124 VGND VGND VPWR VPWR out[13] sky130_fd_sc_hd__buf_2
X_2555_ _0860_ _0861_ net506 net509 VGND VGND VPWR VPWR _0865_ sky130_fd_sc_hd__a211o_1
Xoutput146 net146 VGND VGND VPWR VPWR out[4] sky130_fd_sc_hd__buf_2
Xoutput135 net135 VGND VGND VPWR VPWR out[23] sky130_fd_sc_hd__buf_2
X_2486_ net1028 net205 _0815_ VGND VGND VPWR VPWR _0534_ sky130_fd_sc_hd__o21a_1
X_4225_ net587 net432 net341 net661 VGND VGND VPWR VPWR _2099_ sky130_fd_sc_hd__a22o_1
X_4156_ net717 net235 net231 _2053_ VGND VGND VPWR VPWR _2054_ sky130_fd_sc_hd__a211o_1
X_3107_ net699 net186 _1247_ net190 VGND VGND VPWR VPWR _1248_ sky130_fd_sc_hd__a211o_1
XFILLER_46_18 VGND VGND VPWR VPWR sky130_fd_sc_hd__decap_3
X_4087_ array\[10\]\[28\] net464 net447 array\[8\]\[28\] VGND VGND VPWR VPWR _1998_
+ sky130_fd_sc_hd__a22o_1
X_3038_ net669 net595 net493 VGND VGND VPWR VPWR _1198_ sky130_fd_sc_hd__mux2_1
XFILLER_23_110 VGND VGND VPWR VPWR sky130_fd_sc_hd__fill_2
XFILLER_23_121 VGND VGND VPWR VPWR sky130_fd_sc_hd__fill_1
XFILLER_23_143 VGND VGND VPWR VPWR sky130_fd_sc_hd__decap_3
XFILLER_3_559 VGND VGND VPWR VPWR sky130_fd_sc_hd__fill_1
XFILLER_87_69 VPWR VGND VPWR VGND sky130_ef_sc_hd__decap_12
Xfanout340 _2049_ VGND VGND VPWR VPWR net340 sky130_fd_sc_hd__clkbuf_4
Xfanout362 _1514_ VGND VGND VPWR VPWR net362 sky130_fd_sc_hd__clkbuf_4
Xfanout351 _1616_ VGND VGND VPWR VPWR net351 sky130_fd_sc_hd__buf_4
Xfanout373 _1301_ VGND VGND VPWR VPWR net373 sky130_fd_sc_hd__clkbuf_4
Xfanout384 _1067_ VGND VGND VPWR VPWR net384 sky130_fd_sc_hd__clkbuf_2
XFILLER_74_533 VGND VGND VPWR VPWR sky130_fd_sc_hd__decap_4
XFILLER_19_416 VGND VGND VPWR VPWR sky130_fd_sc_hd__decap_4
Xfanout395 _0869_ VGND VGND VPWR VPWR net395 sky130_fd_sc_hd__buf_4
XTAP_TAPCELL_ROW_57_775 VGND VPWR sky130_fd_sc_hd__tapvpwrvgnd_1
XTAP_TAPCELL_ROW_29_499 VGND VPWR sky130_fd_sc_hd__tapvpwrvgnd_1
XTAP_TAPCELL_ROW_12_322 VGND VPWR sky130_fd_sc_hd__tapvpwrvgnd_1
XFILLER_52_94 VGND VGND VPWR VPWR sky130_fd_sc_hd__decap_6
Xinput26 value0[27] VGND VGND VPWR VPWR net26 sky130_fd_sc_hd__buf_1
Xinput15 value0[17] VGND VGND VPWR VPWR net15 sky130_fd_sc_hd__buf_1
Xinput37 value0[8] VGND VGND VPWR VPWR net37 sky130_fd_sc_hd__buf_1
Xinput48 value1[18] VGND VGND VPWR VPWR net48 sky130_fd_sc_hd__buf_1
Xinput59 value1[28] VGND VGND VPWR VPWR net59 sky130_fd_sc_hd__buf_1
XFILLER_69_316 VPWR VGND VPWR VGND sky130_ef_sc_hd__decap_12
XFILLER_69_305 VGND VGND VPWR VPWR sky130_fd_sc_hd__decap_4
X_2340_ net406 _0711_ VGND VGND VPWR VPWR _0714_ sky130_fd_sc_hd__nand2b_1
X_2271_ net585 net321 _0665_ net412 net329 VGND VGND VPWR VPWR _0666_ sky130_fd_sc_hd__a221o_1
X_4010_ array\[9\]\[21\] net544 net527 array\[11\]\[21\] _1927_ VGND VGND VPWR VPWR
+ _1928_ sky130_fd_sc_hd__a221o_1
XFILLER_77_393 VGND VGND VPWR VPWR sky130_fd_sc_hd__decap_4
XFILLER_77_360 VGND VGND VPWR VPWR sky130_fd_sc_hd__decap_3
XFILLER_37_202 VGND VGND VPWR VPWR sky130_fd_sc_hd__decap_4
XTAP_TAPCELL_ROW_82_1022 VGND VPWR sky130_fd_sc_hd__tapvpwrvgnd_1
X_4912_ clknet_leaf_35_clk _0443_ VGND VGND VPWR VPWR array\[6\]\[23\] sky130_fd_sc_hd__dfxtp_1
X_4843_ clknet_leaf_51_clk _0374_ VGND VGND VPWR VPWR net141 sky130_fd_sc_hd__dfxtp_1
XFILLER_60_271 VGND VGND VPWR VPWR sky130_fd_sc_hd__fill_1
X_4774_ clknet_leaf_64_clk _0305_ VGND VGND VPWR VPWR ready_check\[7\] sky130_fd_sc_hd__dfxtp_1
X_3725_ net823 net240 _1676_ _1677_ VGND VGND VPWR VPWR _0331_ sky130_fd_sc_hd__o22a_1
Xclkbuf_leaf_9_clk clknet_3_4__leaf_clk VGND VGND VPWR VPWR clknet_leaf_9_clk sky130_fd_sc_hd__clkbuf_8
X_3656_ _1218_ _1604_ VGND VGND VPWR VPWR _1630_ sky130_fd_sc_hd__nand2_1
X_2607_ net611 net512 net398 net683 net303 VGND VGND VPWR VPWR _0901_ sky130_fd_sc_hd__a221o_1
X_3587_ net889 net249 _1577_ VGND VGND VPWR VPWR _0293_ sky130_fd_sc_hd__o21a_1
X_2538_ net646 net576 net515 VGND VGND VPWR VPWR _0850_ sky130_fd_sc_hd__mux2_1
XFILLER_0_529 VGND VGND VPWR VPWR sky130_fd_sc_hd__decap_3
XFILLER_87_113 VPWR VGND VPWR VGND sky130_ef_sc_hd__decap_12
XFILLER_75_308 VGND VGND VPWR VPWR sky130_fd_sc_hd__fill_1
X_2469_ net633 net762 net514 VGND VGND VPWR VPWR _0804_ sky130_fd_sc_hd__mux2_1
X_4208_ net738 net234 net230 _2087_ VGND VGND VPWR VPWR _2088_ sky130_fd_sc_hd__a211o_1
XFILLER_68_382 VGND VGND VPWR VPWR sky130_fd_sc_hd__decap_3
X_4139_ _1585_ _2036_ _2039_ _0624_ VGND VGND VPWR VPWR _2042_ sky130_fd_sc_hd__a31o_1
XFILLER_73_27 VGND VGND VPWR VPWR sky130_fd_sc_hd__decap_4
XTAP_TAPCELL_ROW_54_745 VGND VPWR sky130_fd_sc_hd__tapvpwrvgnd_1
XTAP_TAPCELL_ROW_26_469 VGND VPWR sky130_fd_sc_hd__tapvpwrvgnd_1
XFILLER_7_117 VPWR VGND VPWR VGND sky130_ef_sc_hd__decap_12
XFILLER_3_323 VPWR VGND VPWR VGND sky130_ef_sc_hd__decap_12
XFILLER_78_168 VGND VGND VPWR VPWR sky130_fd_sc_hd__decap_4
XFILLER_93_105 VGND VGND VPWR VPWR sky130_fd_sc_hd__decap_6
Xfanout170 _0604_ VGND VGND VPWR VPWR net170 sky130_fd_sc_hd__buf_2
Xfanout181 _1300_ VGND VGND VPWR VPWR net181 sky130_fd_sc_hd__buf_4
Xfanout192 _1225_ VGND VGND VPWR VPWR net192 sky130_fd_sc_hd__clkbuf_8
XFILLER_47_50 VGND VGND VPWR VPWR sky130_fd_sc_hd__decap_6
XFILLER_74_385 VGND VGND VPWR VPWR sky130_fd_sc_hd__fill_2
XFILLER_42_282 VPWR VGND VPWR VGND sky130_ef_sc_hd__decap_12
Xclkbuf_3_4__f_clk clknet_0_clk VGND VGND VPWR VPWR clknet_3_4__leaf_clk sky130_fd_sc_hd__clkbuf_16
XFILLER_63_93 VGND VGND VPWR VPWR sky130_fd_sc_hd__fill_1
XFILLER_8_55 VGND VGND VPWR VPWR sky130_fd_sc_hd__fill_2
X_3510_ net1101 net251 _1525_ _1526_ VGND VGND VPWR VPWR _0267_ sky130_fd_sc_hd__o22a_1
X_4490_ clknet_leaf_34_clk _0021_ VGND VGND VPWR VPWR array\[5\]\[15\] sky130_fd_sc_hd__dfxtp_1
X_3441_ net745 net257 _1477_ net265 VGND VGND VPWR VPWR _1478_ sky130_fd_sc_hd__a211o_1
X_3372_ net719 net174 VGND VGND VPWR VPWR _1429_ sky130_fd_sc_hd__and2_1
X_2323_ net1282 net323 _0700_ VGND VGND VPWR VPWR _0486_ sky130_fd_sc_hd__o21a_1
X_2254_ net813 net325 _0654_ VGND VGND VPWR VPWR _0463_ sky130_fd_sc_hd__o21a_1
XFILLER_65_330 VGND VGND VPWR VPWR sky130_fd_sc_hd__fill_1
X_2185_ _0002_ _0593_ _0003_ VGND VGND VPWR VPWR _0596_ sky130_fd_sc_hd__o21ai_1
XFILLER_25_216 VGND VGND VPWR VPWR sky130_fd_sc_hd__fill_2
XFILLER_53_547 VGND VGND VPWR VPWR sky130_fd_sc_hd__fill_2
XFILLER_80_388 VGND VGND VPWR VPWR sky130_fd_sc_hd__decap_4
XTAP_TAPCELL_ROW_51_715 VGND VPWR sky130_fd_sc_hd__tapvpwrvgnd_1
X_4826_ clknet_leaf_15_clk _0357_ VGND VGND VPWR VPWR net123 sky130_fd_sc_hd__dfxtp_1
XTAP_TAPCELL_ROW_23_439 VGND VPWR sky130_fd_sc_hd__tapvpwrvgnd_1
X_4757_ clknet_leaf_18_clk _0288_ VGND VGND VPWR VPWR array\[10\]\[26\] sky130_fd_sc_hd__dfxtp_1
X_3708_ net764 net350 net420 VGND VGND VPWR VPWR _1667_ sky130_fd_sc_hd__and3_1
X_4688_ clknet_leaf_0_clk _0219_ VGND VGND VPWR VPWR array\[12\]\[21\] sky130_fd_sc_hd__dfxtp_1
X_3639_ net212 _0609_ _1617_ _1615_ VGND VGND VPWR VPWR _0305_ sky130_fd_sc_hd__o31a_1
XFILLER_88_433 VGND VGND VPWR VPWR sky130_fd_sc_hd__decap_8
XFILLER_68_27 VGND VGND VPWR VPWR sky130_fd_sc_hd__fill_1
XFILLER_0_315 VGND VGND VPWR VPWR sky130_fd_sc_hd__decap_3
XFILLER_0_337 VGND VGND VPWR VPWR sky130_fd_sc_hd__decap_8
XFILLER_88_477 VPWR VGND VPWR VGND sky130_ef_sc_hd__decap_12
XFILLER_84_15 VPWR VGND VPWR VGND sky130_ef_sc_hd__decap_12
XFILLER_68_190 VGND VGND VPWR VPWR sky130_fd_sc_hd__decap_6
XTAP_TAPCELL_ROW_67_870 VGND VPWR sky130_fd_sc_hd__tapvpwrvgnd_1
XFILLER_56_363 VGND VGND VPWR VPWR sky130_fd_sc_hd__fill_1
XTAP_TAPCELL_ROW_39_594 VGND VPWR sky130_fd_sc_hd__tapvpwrvgnd_1
XFILLER_12_433 VPWR VGND VPWR VGND sky130_ef_sc_hd__decap_12
XFILLER_12_477 VPWR VGND VPWR VGND sky130_ef_sc_hd__decap_12
XFILLER_33_63 VGND VGND VPWR VPWR sky130_fd_sc_hd__fill_1
XFILLER_3_142 VPWR VGND VPWR VGND sky130_ef_sc_hd__decap_12
XFILLER_79_466 VGND VGND VPWR VPWR sky130_fd_sc_hd__fill_2
Xhold4 array\[13\]\[30\] VGND VGND VPWR VPWR net770 sky130_fd_sc_hd__dlygate4sd3_1
XFILLER_62_322 VGND VGND VPWR VPWR sky130_fd_sc_hd__fill_2
X_3990_ net215 _1908_ _1909_ VGND VGND VPWR VPWR _1910_ sky130_fd_sc_hd__or3_1
X_2941_ net724 net273 _1127_ net386 net270 VGND VGND VPWR VPWR _1128_ sky130_fd_sc_hd__a221o_1
XFILLER_88_3 VPWR VGND VPWR VGND sky130_ef_sc_hd__decap_12
X_4611_ clknet_leaf_31_clk _0142_ VGND VGND VPWR VPWR array\[14\]\[8\] sky130_fd_sc_hd__dfxtp_1
XTAP_TAPCELL_ROW_20_409 VGND VPWR sky130_fd_sc_hd__tapvpwrvgnd_1
X_2872_ net709 net272 _1081_ net385 net269 VGND VGND VPWR VPWR _1082_ sky130_fd_sc_hd__a221o_1
X_4542_ clknet_leaf_9_clk _0073_ VGND VGND VPWR VPWR array\[0\]\[3\] sky130_fd_sc_hd__dfxtp_1
Xhold404 array\[0\]\[28\] VGND VGND VPWR VPWR net1170 sky130_fd_sc_hd__dlygate4sd3_1
Xhold426 array\[9\]\[4\] VGND VGND VPWR VPWR net1192 sky130_fd_sc_hd__dlygate4sd3_1
Xhold415 array\[12\]\[14\] VGND VGND VPWR VPWR net1181 sky130_fd_sc_hd__dlygate4sd3_1
X_4473_ clknet_leaf_19_clk _0004_ VGND VGND VPWR VPWR array\[4\]\[30\] sky130_fd_sc_hd__dfxtp_1
X_3424_ net1009 net259 _1466_ VGND VGND VPWR VPWR _0241_ sky130_fd_sc_hd__o21a_1
Xhold437 array\[9\]\[7\] VGND VGND VPWR VPWR net1203 sky130_fd_sc_hd__dlygate4sd3_1
Xhold459 array\[1\]\[21\] VGND VGND VPWR VPWR net1225 sky130_fd_sc_hd__dlygate4sd3_1
Xhold448 array\[4\]\[3\] VGND VGND VPWR VPWR net1214 sky130_fd_sc_hd__dlygate4sd3_1
X_3355_ net594 net484 net179 net1319 VGND VGND VPWR VPWR _1418_ sky130_fd_sc_hd__a22o_1
X_3286_ _1366_ net525 net267 _1369_ VGND VGND VPWR VPWR _1372_ sky130_fd_sc_hd__and4b_1
X_2306_ net667 net593 net521 VGND VGND VPWR VPWR _0689_ sky130_fd_sc_hd__mux2_1
XFILLER_85_447 VGND VGND VPWR VPWR sky130_fd_sc_hd__fill_1
X_2237_ net697 net625 net522 VGND VGND VPWR VPWR _0643_ sky130_fd_sc_hd__mux2_1
XFILLER_38_352 VGND VGND VPWR VPWR sky130_fd_sc_hd__fill_2
XTAP_TAPCELL_ROW_88_1083 VGND VPWR sky130_fd_sc_hd__tapvpwrvgnd_1
XFILLER_53_300 VGND VGND VPWR VPWR sky130_fd_sc_hd__decap_3
XFILLER_54_18 VGND VGND VPWR VPWR sky130_fd_sc_hd__decap_8
XFILLER_54_29 VGND VGND VPWR VPWR sky130_fd_sc_hd__decap_4
XTAP_TAPCELL_ROW_64_840 VGND VPWR sky130_fd_sc_hd__tapvpwrvgnd_1
XTAP_TAPCELL_ROW_36_564 VGND VPWR sky130_fd_sc_hd__tapvpwrvgnd_1
XFILLER_53_399 VGND VGND VPWR VPWR sky130_fd_sc_hd__fill_1
X_4809_ clknet_leaf_21_clk _0340_ VGND VGND VPWR VPWR array\[9\]\[27\] sky130_fd_sc_hd__dfxtp_1
XPHY_EDGE_ROW_17_Right_17 VGND VGND VPWR VPWR sky130_fd_sc_hd__decap_3
XFILLER_88_241 VGND VGND VPWR VPWR sky130_fd_sc_hd__decap_8
XFILLER_0_134 VGND VGND VPWR VPWR sky130_fd_sc_hd__fill_2
XTAP_TAPCELL_ROW_8_289 VGND VPWR sky130_fd_sc_hd__tapvpwrvgnd_1
XPHY_EDGE_ROW_26_Right_26 VGND VGND VPWR VPWR sky130_fd_sc_hd__decap_3
XFILLER_28_41 VPWR VGND VPWR VGND sky130_ef_sc_hd__decap_12
XFILLER_63_119 VGND VGND VPWR VPWR sky130_fd_sc_hd__decap_4
XFILLER_29_385 VGND VGND VPWR VPWR sky130_fd_sc_hd__decap_6
XFILLER_12_241 VGND VGND VPWR VPWR sky130_fd_sc_hd__fill_2
XPHY_EDGE_ROW_35_Right_35 VGND VGND VPWR VPWR sky130_fd_sc_hd__decap_3
XFILLER_8_234 VGND VGND VPWR VPWR sky130_fd_sc_hd__fill_1
XFILLER_8_223 VGND VGND VPWR VPWR sky130_fd_sc_hd__decap_6
XFILLER_60_83 VGND VGND VPWR VPWR sky130_fd_sc_hd__fill_1
XPHY_EDGE_ROW_44_Right_44 VGND VGND VPWR VPWR sky130_fd_sc_hd__decap_3
X_3140_ net737 net188 _1269_ net192 VGND VGND VPWR VPWR _1270_ sky130_fd_sc_hd__a211o_1
XFILLER_67_447 VGND VGND VPWR VPWR sky130_fd_sc_hd__fill_1
XFILLER_67_436 VGND VGND VPWR VPWR sky130_fd_sc_hd__decap_3
XTAP_TAPCELL_ROW_78_987 VGND VPWR sky130_fd_sc_hd__tapvpwrvgnd_1
X_3071_ net753 _0707_ _0854_ VGND VGND VPWR VPWR _1221_ sky130_fd_sc_hd__and3_4
XFILLER_62_141 VGND VGND VPWR VPWR sky130_fd_sc_hd__decap_3
XTAP_TAPCELL_ROW_61_810 VGND VPWR sky130_fd_sc_hd__tapvpwrvgnd_1
X_3973_ array\[2\]\[18\] net460 net443 array\[0\]\[18\] VGND VGND VPWR VPWR _1894_
+ sky130_fd_sc_hd__a22o_1
XTAP_TAPCELL_ROW_33_534 VGND VPWR sky130_fd_sc_hd__tapvpwrvgnd_1
XPHY_EDGE_ROW_53_Right_53 VGND VGND VPWR VPWR sky130_fd_sc_hd__decap_3
XFILLER_31_561 VGND VGND VPWR VPWR sky130_fd_sc_hd__fill_1
X_2924_ net1297 net199 _1116_ VGND VGND VPWR VPWR _0091_ sky130_fd_sc_hd__o21a_1
X_2855_ net383 _1068_ VGND VGND VPWR VPWR _1069_ sky130_fd_sc_hd__nor2_1
X_4525_ clknet_leaf_17_clk _0056_ VGND VGND VPWR VPWR array\[8\]\[18\] sky130_fd_sc_hd__dfxtp_1
X_2786_ net762 net502 net275 net633 net285 VGND VGND VPWR VPWR _1025_ sky130_fd_sc_hd__a221o_1
Xhold201 array\[10\]\[2\] VGND VGND VPWR VPWR net967 sky130_fd_sc_hd__dlygate4sd3_1
Xhold223 array\[3\]\[24\] VGND VGND VPWR VPWR net989 sky130_fd_sc_hd__dlygate4sd3_1
Xhold234 array\[10\]\[3\] VGND VGND VPWR VPWR net1000 sky130_fd_sc_hd__dlygate4sd3_1
Xhold212 array\[8\]\[24\] VGND VGND VPWR VPWR net978 sky130_fd_sc_hd__dlygate4sd3_1
X_4456_ clknet_leaf_13_clk _0567_ VGND VGND VPWR VPWR array\[4\]\[13\] sky130_fd_sc_hd__dfxtp_1
Xhold245 array\[14\]\[29\] VGND VGND VPWR VPWR net1011 sky130_fd_sc_hd__dlygate4sd3_1
Xhold278 array\[11\]\[29\] VGND VGND VPWR VPWR net1044 sky130_fd_sc_hd__dlygate4sd3_1
Xhold267 array\[7\]\[1\] VGND VGND VPWR VPWR net1033 sky130_fd_sc_hd__dlygate4sd3_1
XPHY_EDGE_ROW_62_Right_62 VGND VGND VPWR VPWR sky130_fd_sc_hd__decap_3
Xhold256 array\[14\]\[3\] VGND VGND VPWR VPWR net1022 sky130_fd_sc_hd__dlygate4sd3_1
X_4387_ clknet_leaf_27_clk _0498_ VGND VGND VPWR VPWR array\[2\]\[8\] sky130_fd_sc_hd__dfxtp_1
Xhold289 array\[4\]\[26\] VGND VGND VPWR VPWR net1055 sky130_fd_sc_hd__dlygate4sd3_1
Xfanout703 net36 VGND VGND VPWR VPWR net703 sky130_fd_sc_hd__buf_2
Xfanout714 net31 VGND VGND VPWR VPWR net714 sky130_fd_sc_hd__clkbuf_2
X_3407_ net566 net478 net363 net636 VGND VGND VPWR VPWR _1455_ sky130_fd_sc_hd__a22o_1
X_3338_ net610 net483 net368 net682 net178 VGND VGND VPWR VPWR _1407_ sky130_fd_sc_hd__a221o_1
XFILLER_85_200 VGND VGND VPWR VPWR sky130_fd_sc_hd__fill_2
Xfanout725 net25 VGND VGND VPWR VPWR net725 sky130_fd_sc_hd__clkbuf_2
Xfanout747 net14 VGND VGND VPWR VPWR net747 sky130_fd_sc_hd__buf_2
Xfanout758 net102 VGND VGND VPWR VPWR net758 sky130_fd_sc_hd__buf_2
Xfanout736 net20 VGND VGND VPWR VPWR net736 sky130_fd_sc_hd__dlymetal6s2s_1
XTAP_TAPCELL_ROW_5_259 VGND VPWR sky130_fd_sc_hd__tapvpwrvgnd_1
XFILLER_85_266 VGND VGND VPWR VPWR sky130_fd_sc_hd__decap_6
X_3269_ net581 net486 net182 net721 _1358_ VGND VGND VPWR VPWR _1359_ sky130_fd_sc_hd__a221o_1
XANTENNA_107 net401 VGND VGND VPWR VPWR sky130_fd_sc_hd__diode_2
XANTENNA_129 _1368_ VGND VGND VPWR VPWR sky130_fd_sc_hd__diode_2
XFILLER_26_344 VGND VGND VPWR VPWR sky130_fd_sc_hd__decap_3
XANTENNA_118 net476 VGND VGND VPWR VPWR sky130_fd_sc_hd__diode_2
XFILLER_81_27 VPWR VGND VPWR VGND sky130_ef_sc_hd__decap_12
XPHY_EDGE_ROW_71_Right_71 VGND VGND VPWR VPWR sky130_fd_sc_hd__decap_3
XFILLER_14_76 VGND VGND VPWR VPWR sky130_fd_sc_hd__decap_8
XPHY_EDGE_ROW_15_Left_110 VGND VGND VPWR VPWR sky130_fd_sc_hd__decap_3
XPHY_EDGE_ROW_80_Right_80 VGND VGND VPWR VPWR sky130_fd_sc_hd__decap_3
XFILLER_89_561 VGND VGND VPWR VPWR sky130_fd_sc_hd__fill_1
XFILLER_91_225 VGND VGND VPWR VPWR sky130_fd_sc_hd__fill_1
XFILLER_64_439 VGND VGND VPWR VPWR sky130_fd_sc_hd__decap_6
XTAP_TAPCELL_ROW_75_957 VGND VPWR sky130_fd_sc_hd__tapvpwrvgnd_1
XFILLER_44_141 VGND VGND VPWR VPWR sky130_fd_sc_hd__fill_2
XFILLER_13_561 VGND VGND VPWR VPWR sky130_fd_sc_hd__fill_1
XTAP_TAPCELL_ROW_30_504 VGND VPWR sky130_fd_sc_hd__tapvpwrvgnd_1
XFILLER_32_358 VGND VGND VPWR VPWR sky130_fd_sc_hd__decap_4
X_2640_ net722 _0862_ _0864_ VGND VGND VPWR VPWR _0922_ sky130_fd_sc_hd__and3_1
X_2571_ net709 net401 net508 VGND VGND VPWR VPWR _0877_ sky130_fd_sc_hd__and3_1
X_4310_ net1304 net218 _2154_ _2155_ VGND VGND VPWR VPWR _0442_ sky130_fd_sc_hd__o22a_1
XFILLER_4_270 VGND VGND VPWR VPWR sky130_fd_sc_hd__fill_1
X_4241_ net574 net433 net342 net644 net231 VGND VGND VPWR VPWR _2110_ sky130_fd_sc_hd__a221o_1
X_4172_ net1312 net225 _2064_ VGND VGND VPWR VPWR _0395_ sky130_fd_sc_hd__o21a_1
XFILLER_67_266 VGND VGND VPWR VPWR sky130_fd_sc_hd__decap_4
XTAP_TAPCELL_ROW_2_229 VGND VPWR sky130_fd_sc_hd__tapvpwrvgnd_1
X_3123_ net1212 net161 _1258_ VGND VGND VPWR VPWR _0148_ sky130_fd_sc_hd__o21a_1
X_3054_ net724 net196 _1208_ net382 VGND VGND VPWR VPWR _1209_ sky130_fd_sc_hd__a22o_1
XTAP_TAPCELL_ROW_85_1053 VGND VPWR sky130_fd_sc_hd__tapvpwrvgnd_1
XTAP_TAPCELL_ROW_18_383 VGND VPWR sky130_fd_sc_hd__tapvpwrvgnd_1
XFILLER_35_196 VGND VGND VPWR VPWR sky130_fd_sc_hd__fill_1
X_3956_ net438 _1873_ _1877_ net358 net216 VGND VGND VPWR VPWR _1879_ sky130_fd_sc_hd__a221o_1
X_2907_ net611 net683 net499 VGND VGND VPWR VPWR _1105_ sky130_fd_sc_hd__mux2_1
X_3887_ array\[1\]\[10\] net552 net530 array\[3\]\[10\] _1815_ VGND VGND VPWR VPWR
+ _1816_ sky130_fd_sc_hd__a221o_1
X_2838_ net1105 net286 net280 net725 _1057_ VGND VGND VPWR VPWR _0064_ sky130_fd_sc_hd__a221o_1
X_2769_ net601 net502 net275 net675 net285 VGND VGND VPWR VPWR _1014_ sky130_fd_sc_hd__a221o_1
X_4508_ clknet_leaf_55_clk _0039_ VGND VGND VPWR VPWR array\[8\]\[1\] sky130_fd_sc_hd__dfxtp_1
X_4439_ clknet_leaf_54_clk _0550_ VGND VGND VPWR VPWR array\[3\]\[28\] sky130_fd_sc_hd__dfxtp_1
Xfanout533 _0608_ VGND VGND VPWR VPWR net533 sky130_fd_sc_hd__clkbuf_4
Xfanout500 _1066_ VGND VGND VPWR VPWR net500 sky130_fd_sc_hd__clkbuf_4
Xfanout522 _0631_ VGND VGND VPWR VPWR net522 sky130_fd_sc_hd__buf_4
Xfanout511 _0858_ VGND VGND VPWR VPWR net511 sky130_fd_sc_hd__clkbuf_4
XFILLER_76_27 VGND VGND VPWR VPWR sky130_fd_sc_hd__fill_1
Xfanout555 net558 VGND VGND VPWR VPWR net555 sky130_fd_sc_hd__buf_2
Xfanout544 net545 VGND VGND VPWR VPWR net544 sky130_fd_sc_hd__buf_2
Xfanout566 net99 VGND VGND VPWR VPWR net566 sky130_fd_sc_hd__clkbuf_2
Xfanout588 net89 VGND VGND VPWR VPWR net588 sky130_fd_sc_hd__dlymetal6s2s_1
Xfanout577 net578 VGND VGND VPWR VPWR net577 sky130_fd_sc_hd__buf_2
XFILLER_46_406 VGND VGND VPWR VPWR sky130_fd_sc_hd__decap_8
Xfanout599 net83 VGND VGND VPWR VPWR net599 sky130_fd_sc_hd__buf_2
XFILLER_73_225 VGND VGND VPWR VPWR sky130_fd_sc_hd__decap_3
XFILLER_92_15 VPWR VGND VPWR VGND sky130_ef_sc_hd__decap_12
XFILLER_61_409 VGND VGND VPWR VPWR sky130_fd_sc_hd__fill_2
XTAP_TAPCELL_ROW_72_927 VGND VPWR sky130_fd_sc_hd__tapvpwrvgnd_1
XFILLER_26_141 VGND VGND VPWR VPWR sky130_fd_sc_hd__fill_1
XFILLER_10_531 VGND VGND VPWR VPWR sky130_fd_sc_hd__fill_1
XFILLER_6_513 VPWR VGND VPWR VGND sky130_ef_sc_hd__decap_12
XFILLER_6_557 VGND VGND VPWR VPWR sky130_fd_sc_hd__decap_4
XFILLER_77_542 VPWR VGND VPWR VGND sky130_ef_sc_hd__decap_12
XFILLER_1_273 VGND VGND VPWR VPWR sky130_fd_sc_hd__decap_6
XFILLER_92_501 VPWR VGND VPWR VGND sky130_ef_sc_hd__decap_12
XFILLER_92_545 VPWR VGND VPWR VGND sky130_ef_sc_hd__decap_12
XFILLER_64_269 VGND VGND VPWR VPWR sky130_fd_sc_hd__fill_1
XFILLER_45_461 VGND VGND VPWR VPWR sky130_fd_sc_hd__decap_8
XFILLER_17_196 VGND VGND VPWR VPWR sky130_fd_sc_hd__decap_3
X_3810_ net775 net169 _1744_ _1745_ VGND VGND VPWR VPWR _0348_ sky130_fd_sc_hd__o22a_1
XTAP_TAPCELL_ROW_15_353 VGND VPWR sky130_fd_sc_hd__tapvpwrvgnd_1
X_4790_ clknet_leaf_36_clk _0321_ VGND VGND VPWR VPWR array\[9\]\[8\] sky130_fd_sc_hd__dfxtp_1
XANTENNA_29 _1300_ VGND VGND VPWR VPWR sky130_fd_sc_hd__diode_2
XANTENNA_18 _1152_ VGND VGND VPWR VPWR sky130_fd_sc_hd__diode_2
XFILLER_60_486 VGND VGND VPWR VPWR sky130_fd_sc_hd__decap_4
X_3741_ net729 net350 net422 VGND VGND VPWR VPWR _1688_ sky130_fd_sc_hd__and3_1
XFILLER_13_380 VPWR VGND VPWR VGND sky130_ef_sc_hd__decap_12
XFILLER_70_3 VPWR VGND VPWR VGND sky130_ef_sc_hd__decap_12
X_3672_ net423 _1002_ _0931_ VGND VGND VPWR VPWR _1643_ sky130_fd_sc_hd__and3b_2
X_2623_ net1210 net297 _0910_ _0911_ VGND VGND VPWR VPWR _0575_ sky130_fd_sc_hd__o22a_1
X_2554_ net105 _0636_ _0863_ VGND VGND VPWR VPWR _0864_ sky130_fd_sc_hd__and3_1
Xoutput125 net125 VGND VGND VPWR VPWR out[14] sky130_fd_sc_hd__buf_2
Xoutput147 net147 VGND VGND VPWR VPWR out[5] sky130_fd_sc_hd__buf_2
Xoutput136 net136 VGND VGND VPWR VPWR out[24] sky130_fd_sc_hd__buf_2
X_2485_ net765 net306 _0814_ net404 net310 VGND VGND VPWR VPWR _0815_ sky130_fd_sc_hd__a221o_1
XFILLER_68_520 VPWR VGND VPWR VGND sky130_ef_sc_hd__decap_12
X_4224_ net1234 net226 _2098_ VGND VGND VPWR VPWR _0413_ sky130_fd_sc_hd__o21a_1
X_4155_ net577 net433 net342 net647 VGND VGND VPWR VPWR _2053_ sky130_fd_sc_hd__a22o_1
X_3106_ net758 net491 net376 net627 VGND VGND VPWR VPWR _1247_ sky130_fd_sc_hd__a22o_1
XFILLER_55_225 VGND VGND VPWR VPWR sky130_fd_sc_hd__fill_2
X_4086_ array\[1\]\[28\] net550 net529 array\[3\]\[28\] _1996_ VGND VGND VPWR VPWR
+ _1997_ sky130_fd_sc_hd__a221o_1
XFILLER_55_258 VGND VGND VPWR VPWR sky130_fd_sc_hd__fill_1
X_3037_ net1293 _1197_ net165 VGND VGND VPWR VPWR _0123_ sky130_fd_sc_hd__mux2_1
X_3939_ array\[2\]\[15\] net468 net451 array\[0\]\[15\] VGND VGND VPWR VPWR _1863_
+ sky130_fd_sc_hd__a22o_1
XFILLER_11_11 VGND VGND VPWR VPWR sky130_fd_sc_hd__fill_2
XFILLER_3_505 VPWR VGND VPWR VGND sky130_ef_sc_hd__decap_12
XFILLER_87_15 VPWR VGND VPWR VGND sky130_ef_sc_hd__decap_12
Xfanout330 _0640_ VGND VGND VPWR VPWR net330 sky130_fd_sc_hd__clkbuf_4
Xfanout341 _2049_ VGND VGND VPWR VPWR net341 sky130_fd_sc_hd__buf_2
Xfanout352 _1616_ VGND VGND VPWR VPWR net352 sky130_fd_sc_hd__buf_2
Xfanout363 _1442_ VGND VGND VPWR VPWR net363 sky130_fd_sc_hd__clkbuf_4
Xfanout374 _1301_ VGND VGND VPWR VPWR net374 sky130_fd_sc_hd__buf_2
Xfanout385 net386 VGND VGND VPWR VPWR net385 sky130_fd_sc_hd__clkbuf_4
Xfanout396 _0869_ VGND VGND VPWR VPWR net396 sky130_fd_sc_hd__buf_2
XTAP_TAPCELL_ROW_57_776 VGND VPWR sky130_fd_sc_hd__tapvpwrvgnd_1
XFILLER_14_122 VGND VGND VPWR VPWR sky130_fd_sc_hd__fill_1
XTAP_TAPCELL_ROW_12_323 VGND VPWR sky130_fd_sc_hd__tapvpwrvgnd_1
Xinput16 value0[18] VGND VGND VPWR VPWR net16 sky130_fd_sc_hd__buf_1
Xinput27 value0[28] VGND VGND VPWR VPWR net27 sky130_fd_sc_hd__buf_1
Xinput49 value1[19] VGND VGND VPWR VPWR net49 sky130_fd_sc_hd__buf_1
Xinput38 value0[9] VGND VGND VPWR VPWR net38 sky130_fd_sc_hd__buf_1
X_2270_ net693 net621 net523 VGND VGND VPWR VPWR _0665_ sky130_fd_sc_hd__mux2_1
XFILLER_69_328 VGND VGND VPWR VPWR sky130_fd_sc_hd__fill_1
XFILLER_77_383 VGND VGND VPWR VPWR sky130_fd_sc_hd__decap_8
XFILLER_18_483 VPWR VGND VPWR VGND sky130_ef_sc_hd__decap_12
X_4911_ clknet_leaf_2_clk _0442_ VGND VGND VPWR VPWR array\[6\]\[22\] sky130_fd_sc_hd__dfxtp_1
XTAP_TAPCELL_ROW_82_1023 VGND VPWR sky130_fd_sc_hd__tapvpwrvgnd_1
X_4842_ clknet_leaf_50_clk _0373_ VGND VGND VPWR VPWR net140 sky130_fd_sc_hd__dfxtp_1
X_4773_ clknet_leaf_60_clk _0304_ VGND VGND VPWR VPWR ready_check\[8\] sky130_fd_sc_hd__dfxtp_1
X_3724_ net605 net424 net345 net679 net242 VGND VGND VPWR VPWR _1677_ sky130_fd_sc_hd__a221o_1
X_3655_ net211 _0609_ _1607_ _1629_ _0786_ VGND VGND VPWR VPWR _0309_ sky130_fd_sc_hd__o32a_1
X_2606_ net747 net401 net508 VGND VGND VPWR VPWR _0900_ sky130_fd_sc_hd__and3_1
XTAP_TAPCELL_ROW_93_1130 VGND VPWR sky130_fd_sc_hd__tapvpwrvgnd_1
X_3586_ net713 net245 _1576_ net254 VGND VGND VPWR VPWR _1577_ sky130_fd_sc_hd__a211o_1
X_2537_ net1120 net203 _0849_ VGND VGND VPWR VPWR _0551_ sky130_fd_sc_hd__o21a_1
XFILLER_87_125 VGND VGND VPWR VPWR sky130_fd_sc_hd__decap_6
X_2468_ net801 net204 _0803_ VGND VGND VPWR VPWR _0528_ sky130_fd_sc_hd__o21a_1
XFILLER_87_169 VGND VGND VPWR VPWR sky130_fd_sc_hd__fill_2
X_4207_ net600 net432 net341 net674 VGND VGND VPWR VPWR _2087_ sky130_fd_sc_hd__a22o_1
XFILLER_68_372 VGND VGND VPWR VPWR sky130_fd_sc_hd__decap_4
X_2399_ net603 net677 net518 VGND VGND VPWR VPWR _0754_ sky130_fd_sc_hd__mux2_1
X_4138_ net766 net1315 VGND VGND VPWR VPWR _2041_ sky130_fd_sc_hd__nand2_1
XFILLER_28_225 VGND VGND VPWR VPWR sky130_fd_sc_hd__decap_3
X_4069_ net788 net172 _1980_ _1981_ VGND VGND VPWR VPWR _0371_ sky130_fd_sc_hd__o22a_1
XTAP_TAPCELL_ROW_54_746 VGND VPWR sky130_fd_sc_hd__tapvpwrvgnd_1
XFILLER_24_475 VGND VGND VPWR VPWR sky130_fd_sc_hd__fill_1
XFILLER_11_136 VGND VGND VPWR VPWR sky130_fd_sc_hd__fill_1
XFILLER_7_129 VPWR VGND VPWR VGND sky130_ef_sc_hd__decap_12
XFILLER_3_335 VGND VGND VPWR VPWR sky130_fd_sc_hd__fill_1
XFILLER_0_3 VPWR VGND VPWR VGND sky130_ef_sc_hd__decap_12
XFILLER_78_158 VGND VGND VPWR VPWR sky130_fd_sc_hd__fill_1
Xfanout182 _1300_ VGND VGND VPWR VPWR net182 sky130_fd_sc_hd__buf_2
Xfanout171 _0604_ VGND VGND VPWR VPWR net171 sky130_fd_sc_hd__clkbuf_4
XFILLER_47_501 VGND VGND VPWR VPWR sky130_fd_sc_hd__decap_3
Xfanout160 _1299_ VGND VGND VPWR VPWR net160 sky130_fd_sc_hd__clkbuf_4
XFILLER_59_372 VGND VGND VPWR VPWR sky130_fd_sc_hd__decap_4
XFILLER_19_225 VGND VGND VPWR VPWR sky130_fd_sc_hd__fill_1
Xfanout193 net198 VGND VGND VPWR VPWR net193 sky130_fd_sc_hd__buf_4
XFILLER_47_73 VGND VGND VPWR VPWR sky130_fd_sc_hd__decap_4
XFILLER_47_95 VGND VGND VPWR VPWR sky130_fd_sc_hd__decap_4
XFILLER_30_401 VGND VGND VPWR VPWR sky130_fd_sc_hd__fill_1
XPHY_EDGE_ROW_7_Left_102 VGND VGND VPWR VPWR sky130_fd_sc_hd__decap_3
XFILLER_42_294 VGND VGND VPWR VPWR sky130_fd_sc_hd__decap_6
X_3440_ net609 net480 net365 net681 VGND VGND VPWR VPWR _1477_ sky130_fd_sc_hd__a22o_1
X_3371_ net1174 net154 _1427_ _1428_ VGND VGND VPWR VPWR _0226_ sky130_fd_sc_hd__o22a_1
XFILLER_69_103 VGND VGND VPWR VPWR sky130_fd_sc_hd__fill_1
X_2322_ net721 net319 _0699_ net410 net327 VGND VGND VPWR VPWR _0700_ sky130_fd_sc_hd__a221o_1
XFILLER_33_3 VPWR VGND VPWR VGND sky130_ef_sc_hd__decap_12
X_2253_ net707 net321 _0653_ net413 net329 VGND VGND VPWR VPWR _0654_ sky130_fd_sc_hd__a221o_1
XFILLER_69_169 VGND VGND VPWR VPWR sky130_fd_sc_hd__decap_4
X_2184_ _0592_ _0594_ VGND VGND VPWR VPWR _0595_ sky130_fd_sc_hd__nor2_1
XFILLER_92_194 VGND VGND VPWR VPWR sky130_fd_sc_hd__fill_2
XFILLER_80_378 VGND VGND VPWR VPWR sky130_fd_sc_hd__fill_2
XFILLER_33_261 VGND VGND VPWR VPWR sky130_fd_sc_hd__decap_3
XTAP_TAPCELL_ROW_51_716 VGND VPWR sky130_fd_sc_hd__tapvpwrvgnd_1
X_4825_ clknet_leaf_14_clk _0356_ VGND VGND VPWR VPWR net122 sky130_fd_sc_hd__dfxtp_1
X_4756_ clknet_leaf_41_clk _0287_ VGND VGND VPWR VPWR array\[10\]\[25\] sky130_fd_sc_hd__dfxtp_1
X_3707_ net991 net237 _1665_ _1666_ VGND VGND VPWR VPWR _0324_ sky130_fd_sc_hd__o22a_1
X_4687_ clknet_leaf_8_clk _0218_ VGND VGND VPWR VPWR array\[12\]\[20\] sky130_fd_sc_hd__dfxtp_1
X_3638_ _0584_ net559 VGND VGND VPWR VPWR _1617_ sky130_fd_sc_hd__nand2_1
X_3569_ net1275 net249 _1564_ _1565_ VGND VGND VPWR VPWR _0287_ sky130_fd_sc_hd__o22a_1
XFILLER_88_489 VPWR VGND VPWR VGND sky130_ef_sc_hd__decap_12
XFILLER_84_27 VGND VGND VPWR VPWR sky130_fd_sc_hd__fill_1
XFILLER_90_109 VPWR VGND VPWR VGND sky130_ef_sc_hd__decap_12
XTAP_TAPCELL_ROW_67_871 VGND VPWR sky130_fd_sc_hd__tapvpwrvgnd_1
XTAP_TAPCELL_ROW_39_595 VGND VPWR sky130_fd_sc_hd__tapvpwrvgnd_1
XFILLER_12_445 VPWR VGND VPWR VGND sky130_ef_sc_hd__decap_12
XFILLER_33_86 VGND VGND VPWR VPWR sky130_fd_sc_hd__fill_1
XFILLER_12_489 VPWR VGND VPWR VGND sky130_ef_sc_hd__decap_12
XPHY_EDGE_ROW_89_Left_184 VGND VGND VPWR VPWR sky130_fd_sc_hd__decap_3
XFILLER_3_154 VPWR VGND VPWR VGND sky130_ef_sc_hd__decap_12
XFILLER_79_445 VGND VGND VPWR VPWR sky130_fd_sc_hd__decap_3
Xhold5 net148 VGND VGND VPWR VPWR net771 sky130_fd_sc_hd__dlygate4sd3_1
X_2940_ net584 net660 net499 VGND VGND VPWR VPWR _1127_ sky130_fd_sc_hd__mux2_1
XFILLER_62_378 VGND VGND VPWR VPWR sky130_fd_sc_hd__decap_6
X_2871_ net569 net639 net498 VGND VGND VPWR VPWR _1081_ sky130_fd_sc_hd__mux2_1
X_4610_ clknet_leaf_60_clk _0141_ VGND VGND VPWR VPWR array\[14\]\[7\] sky130_fd_sc_hd__dfxtp_1
X_4541_ clknet_leaf_39_clk _0072_ VGND VGND VPWR VPWR array\[0\]\[2\] sky130_fd_sc_hd__dfxtp_1
Xhold416 array\[9\]\[27\] VGND VGND VPWR VPWR net1182 sky130_fd_sc_hd__dlygate4sd3_1
X_4472_ clknet_leaf_55_clk _0583_ VGND VGND VPWR VPWR array\[4\]\[29\] sky130_fd_sc_hd__dfxtp_1
Xhold405 array\[14\]\[2\] VGND VGND VPWR VPWR net1171 sky130_fd_sc_hd__dlygate4sd3_1
Xhold427 array\[7\]\[6\] VGND VGND VPWR VPWR net1193 sky130_fd_sc_hd__dlygate4sd3_1
Xhold438 array\[10\]\[16\] VGND VGND VPWR VPWR net1204 sky130_fd_sc_hd__dlygate4sd3_1
X_3423_ net585 net255 _1465_ net263 VGND VGND VPWR VPWR _1466_ sky130_fd_sc_hd__a211o_1
Xhold449 array\[1\]\[7\] VGND VGND VPWR VPWR net1215 sky130_fd_sc_hd__dlygate4sd3_1
XTAP_TAPCELL_ROW_90_1100 VGND VPWR sky130_fd_sc_hd__tapvpwrvgnd_1
X_3354_ net732 net175 net369 net668 VGND VGND VPWR VPWR _1417_ sky130_fd_sc_hd__a22o_1
X_3285_ net651 _1367_ _1369_ VGND VGND VPWR VPWR _1371_ sky130_fd_sc_hd__or3b_1
X_2305_ net1202 net324 _0688_ VGND VGND VPWR VPWR _0480_ sky130_fd_sc_hd__o21a_1
XFILLER_85_437 VGND VGND VPWR VPWR sky130_fd_sc_hd__fill_2
X_2236_ net411 _0639_ VGND VGND VPWR VPWR _0642_ sky130_fd_sc_hd__nor2_1
XFILLER_93_470 VPWR VGND VPWR VGND sky130_ef_sc_hd__decap_12
XTAP_TAPCELL_ROW_88_1084 VGND VPWR sky130_fd_sc_hd__tapvpwrvgnd_1
XTAP_TAPCELL_ROW_64_841 VGND VPWR sky130_fd_sc_hd__tapvpwrvgnd_1
XFILLER_80_164 VGND VGND VPWR VPWR sky130_fd_sc_hd__decap_8
XTAP_TAPCELL_ROW_36_565 VGND VPWR sky130_fd_sc_hd__tapvpwrvgnd_1
XFILLER_53_389 VGND VGND VPWR VPWR sky130_fd_sc_hd__decap_3
XFILLER_70_29 VPWR VGND VPWR VGND sky130_ef_sc_hd__decap_12
X_4808_ clknet_leaf_18_clk _0339_ VGND VGND VPWR VPWR array\[9\]\[26\] sky130_fd_sc_hd__dfxtp_1
X_4739_ clknet_leaf_36_clk _0270_ VGND VGND VPWR VPWR array\[10\]\[8\] sky130_fd_sc_hd__dfxtp_1
XFILLER_0_113 VGND VGND VPWR VPWR sky130_fd_sc_hd__fill_2
XFILLER_0_146 VGND VGND VPWR VPWR sky130_fd_sc_hd__decap_4
XFILLER_28_53 VGND VGND VPWR VPWR sky130_fd_sc_hd__fill_1
XFILLER_29_331 VGND VGND VPWR VPWR sky130_fd_sc_hd__decap_4
XFILLER_12_253 VGND VGND VPWR VPWR sky130_fd_sc_hd__fill_1
XFILLER_5_57 VGND VGND VPWR VPWR sky130_fd_sc_hd__fill_1
X_3070_ net525 net267 _1218_ VGND VGND VPWR VPWR _1220_ sky130_fd_sc_hd__and3_1
XFILLER_82_418 VGND VGND VPWR VPWR sky130_fd_sc_hd__fill_2
XTAP_TAPCELL_ROW_78_988 VGND VPWR sky130_fd_sc_hd__tapvpwrvgnd_1
XFILLER_85_81 VPWR VGND VPWR VGND sky130_ef_sc_hd__decap_12
XFILLER_35_334 VGND VGND VPWR VPWR sky130_fd_sc_hd__fill_2
XFILLER_47_183 VGND VGND VPWR VPWR sky130_fd_sc_hd__decap_8
XFILLER_50_304 VGND VGND VPWR VPWR sky130_fd_sc_hd__decap_4
XTAP_TAPCELL_ROW_61_811 VGND VPWR sky130_fd_sc_hd__tapvpwrvgnd_1
X_3972_ array\[5\]\[18\] net547 net536 array\[7\]\[18\] _1892_ VGND VGND VPWR VPWR
+ _1893_ sky130_fd_sc_hd__a221o_1
XTAP_TAPCELL_ROW_33_535 VGND VPWR sky130_fd_sc_hd__tapvpwrvgnd_1
XFILLER_62_197 VPWR VGND VPWR VGND sky130_ef_sc_hd__decap_12
X_2923_ net735 net271 _1115_ net383 net268 VGND VGND VPWR VPWR _1116_ sky130_fd_sc_hd__a221o_1
X_2854_ _0637_ _0863_ VGND VGND VPWR VPWR _1068_ sky130_fd_sc_hd__nand2_1
X_2785_ net703 net279 VGND VGND VPWR VPWR _1024_ sky130_fd_sc_hd__and2_1
X_4524_ clknet_leaf_20_clk _0055_ VGND VGND VPWR VPWR array\[8\]\[17\] sky130_fd_sc_hd__dfxtp_1
Xhold202 array\[13\]\[22\] VGND VGND VPWR VPWR net968 sky130_fd_sc_hd__dlygate4sd3_1
Xhold235 array\[15\]\[19\] VGND VGND VPWR VPWR net1001 sky130_fd_sc_hd__dlygate4sd3_1
Xhold224 array\[5\]\[10\] VGND VGND VPWR VPWR net990 sky130_fd_sc_hd__dlygate4sd3_1
Xhold213 array\[10\]\[15\] VGND VGND VPWR VPWR net979 sky130_fd_sc_hd__dlygate4sd3_1
Xhold268 array\[14\]\[13\] VGND VGND VPWR VPWR net1034 sky130_fd_sc_hd__dlygate4sd3_1
X_4455_ clknet_leaf_17_clk _0566_ VGND VGND VPWR VPWR array\[4\]\[12\] sky130_fd_sc_hd__dfxtp_1
Xhold246 array\[9\]\[0\] VGND VGND VPWR VPWR net1012 sky130_fd_sc_hd__dlygate4sd3_1
Xhold257 array\[11\]\[6\] VGND VGND VPWR VPWR net1023 sky130_fd_sc_hd__dlygate4sd3_1
Xfanout715 net30 VGND VGND VPWR VPWR net715 sky130_fd_sc_hd__buf_2
X_3406_ net907 net261 _1453_ _1454_ VGND VGND VPWR VPWR _0235_ sky130_fd_sc_hd__o22a_1
Xfanout704 net36 VGND VGND VPWR VPWR net704 sky130_fd_sc_hd__dlymetal6s2s_1
X_4386_ clknet_leaf_57_clk _0497_ VGND VGND VPWR VPWR array\[2\]\[7\] sky130_fd_sc_hd__dfxtp_1
Xhold279 array\[9\]\[3\] VGND VGND VPWR VPWR net1045 sky130_fd_sc_hd__dlygate4sd3_1
Xfanout726 net25 VGND VGND VPWR VPWR net726 sky130_fd_sc_hd__dlymetal6s2s_1
Xfanout748 net14 VGND VGND VPWR VPWR net748 sky130_fd_sc_hd__dlymetal6s2s_1
X_3337_ net746 net174 VGND VGND VPWR VPWR _1406_ sky130_fd_sc_hd__and2_1
Xfanout737 net19 VGND VGND VPWR VPWR net737 sky130_fd_sc_hd__buf_2
XFILLER_85_212 VGND VGND VPWR VPWR sky130_fd_sc_hd__decap_6
Xfanout759 net102 VGND VGND VPWR VPWR net759 sky130_fd_sc_hd__clkbuf_2
XFILLER_58_437 VGND VGND VPWR VPWR sky130_fd_sc_hd__fill_1
X_3268_ net657 net372 VGND VGND VPWR VPWR _1358_ sky130_fd_sc_hd__and2_1
X_3199_ net638 net373 VGND VGND VPWR VPWR _1312_ sky130_fd_sc_hd__and2_1
X_2219_ net652 net766 full net2 VGND VGND VPWR VPWR _0626_ sky130_fd_sc_hd__or4b_2
XFILLER_26_301 VGND VGND VPWR VPWR sky130_fd_sc_hd__fill_1
XANTENNA_119 net483 VGND VGND VPWR VPWR sky130_fd_sc_hd__diode_2
XTAP_TAPCELL_ROW_49_690 VGND VPWR sky130_fd_sc_hd__tapvpwrvgnd_1
XANTENNA_108 net414 VGND VGND VPWR VPWR sky130_fd_sc_hd__diode_2
XFILLER_81_39 VPWR VGND VPWR VGND sky130_ef_sc_hd__decap_12
XFILLER_64_418 VGND VGND VPWR VPWR sky130_fd_sc_hd__fill_2
XTAP_TAPCELL_ROW_75_958 VGND VPWR sky130_fd_sc_hd__tapvpwrvgnd_1
XFILLER_17_345 VGND VGND VPWR VPWR sky130_fd_sc_hd__decap_4
XFILLER_44_131 VGND VGND VPWR VPWR sky130_fd_sc_hd__decap_3
XFILLER_17_389 VGND VGND VPWR VPWR sky130_fd_sc_hd__decap_3
XFILLER_44_197 VGND VGND VPWR VPWR sky130_fd_sc_hd__decap_4
XTAP_TAPCELL_ROW_30_505 VGND VPWR sky130_fd_sc_hd__tapvpwrvgnd_1
XFILLER_72_7 VPWR VGND VPWR VGND sky130_ef_sc_hd__decap_12
X_2570_ net1214 net298 _0875_ _0876_ VGND VGND VPWR VPWR _0557_ sky130_fd_sc_hd__o22a_1
X_4240_ net714 net235 VGND VGND VPWR VPWR _2109_ sky130_fd_sc_hd__and2_1
X_4171_ net704 net233 net229 _2063_ VGND VGND VPWR VPWR _2064_ sky130_fd_sc_hd__a211o_1
XFILLER_67_223 VGND VGND VPWR VPWR sky130_fd_sc_hd__fill_1
X_3122_ net751 net185 _1257_ net189 VGND VGND VPWR VPWR _1258_ sky130_fd_sc_hd__a211o_1
X_3053_ net660 net584 net496 VGND VGND VPWR VPWR _1208_ sky130_fd_sc_hd__mux2_1
XFILLER_82_215 VGND VGND VPWR VPWR sky130_fd_sc_hd__decap_8
XFILLER_67_289 VGND VGND VPWR VPWR sky130_fd_sc_hd__fill_2
XFILLER_67_278 VGND VGND VPWR VPWR sky130_fd_sc_hd__fill_2
XFILLER_55_418 VGND VGND VPWR VPWR sky130_fd_sc_hd__decap_3
XTAP_TAPCELL_ROW_85_1054 VGND VPWR sky130_fd_sc_hd__tapvpwrvgnd_1
XTAP_TAPCELL_ROW_46_660 VGND VPWR sky130_fd_sc_hd__tapvpwrvgnd_1
XTAP_TAPCELL_ROW_18_384 VGND VPWR sky130_fd_sc_hd__tapvpwrvgnd_1
XFILLER_23_337 VGND VGND VPWR VPWR sky130_fd_sc_hd__fill_1
XFILLER_63_484 VGND VGND VPWR VPWR sky130_fd_sc_hd__fill_1
X_3955_ net418 _1871_ _1875_ net354 VGND VGND VPWR VPWR _1878_ sky130_fd_sc_hd__a22o_1
X_2906_ net1189 net200 _1104_ VGND VGND VPWR VPWR _0085_ sky130_fd_sc_hd__o21a_1
X_3886_ array\[2\]\[10\] net467 net450 array\[0\]\[10\] VGND VGND VPWR VPWR _1815_
+ sky130_fd_sc_hd__a22o_1
X_2837_ net587 net504 net276 net661 VGND VGND VPWR VPWR _1057_ sky130_fd_sc_hd__a22o_1
X_2768_ net739 net279 VGND VGND VPWR VPWR _1013_ sky130_fd_sc_hd__and2_1
X_2699_ net754 net290 _0963_ net388 VGND VGND VPWR VPWR _0964_ sky130_fd_sc_hd__a22o_1
X_4507_ clknet_leaf_58_clk _0038_ VGND VGND VPWR VPWR array\[8\]\[0\] sky130_fd_sc_hd__dfxtp_1
X_4438_ clknet_leaf_26_clk _0549_ VGND VGND VPWR VPWR array\[3\]\[27\] sky130_fd_sc_hd__dfxtp_1
Xfanout512 _0858_ VGND VGND VPWR VPWR net512 sky130_fd_sc_hd__clkbuf_2
Xfanout523 _0631_ VGND VGND VPWR VPWR net523 sky130_fd_sc_hd__buf_4
Xfanout501 _1002_ VGND VGND VPWR VPWR net501 sky130_fd_sc_hd__buf_2
Xfanout545 _0606_ VGND VGND VPWR VPWR net545 sky130_fd_sc_hd__clkbuf_4
X_4369_ clknet_leaf_57_clk _0480_ VGND VGND VPWR VPWR array\[1\]\[22\] sky130_fd_sc_hd__dfxtp_1
Xfanout556 net558 VGND VGND VPWR VPWR net556 sky130_fd_sc_hd__clkbuf_4
Xfanout534 net542 VGND VGND VPWR VPWR net534 sky130_fd_sc_hd__clkbuf_4
Xfanout567 net98 VGND VGND VPWR VPWR net567 sky130_fd_sc_hd__buf_2
Xfanout589 net88 VGND VGND VPWR VPWR net589 sky130_fd_sc_hd__clkbuf_2
Xfanout578 net93 VGND VGND VPWR VPWR net578 sky130_fd_sc_hd__clkbuf_2
XFILLER_73_215 VGND VGND VPWR VPWR sky130_fd_sc_hd__decap_8
XFILLER_92_27 VGND VGND VPWR VPWR sky130_fd_sc_hd__fill_1
XTAP_TAPCELL_ROW_72_928 VGND VPWR sky130_fd_sc_hd__tapvpwrvgnd_1
XFILLER_81_281 VGND VGND VPWR VPWR sky130_fd_sc_hd__decap_4
XFILLER_26_197 VGND VGND VPWR VPWR sky130_fd_sc_hd__decap_4
XFILLER_6_525 VGND VGND VPWR VPWR sky130_fd_sc_hd__decap_6
XFILLER_49_223 VGND VGND VPWR VPWR sky130_fd_sc_hd__fill_1
XFILLER_77_554 VGND VGND VPWR VPWR sky130_fd_sc_hd__decap_6
XFILLER_92_513 VPWR VGND VPWR VGND sky130_ef_sc_hd__decap_12
XFILLER_49_278 VGND VGND VPWR VPWR sky130_fd_sc_hd__fill_2
XFILLER_92_557 VGND VGND VPWR VPWR sky130_fd_sc_hd__decap_4
XFILLER_64_237 VGND VGND VPWR VPWR sky130_fd_sc_hd__fill_2
XFILLER_72_270 VGND VGND VPWR VPWR sky130_fd_sc_hd__decap_6
XFILLER_32_123 VGND VGND VPWR VPWR sky130_fd_sc_hd__fill_1
XTAP_TAPCELL_ROW_43_630 VGND VPWR sky130_fd_sc_hd__tapvpwrvgnd_1
XFILLER_60_454 VGND VGND VPWR VPWR sky130_fd_sc_hd__fill_2
XTAP_TAPCELL_ROW_15_354 VGND VPWR sky130_fd_sc_hd__tapvpwrvgnd_1
XANTENNA_19 _1152_ VGND VGND VPWR VPWR sky130_fd_sc_hd__diode_2
X_3740_ net1197 net239 _1686_ _1687_ VGND VGND VPWR VPWR _0336_ sky130_fd_sc_hd__o22a_1
XFILLER_60_498 VGND VGND VPWR VPWR sky130_fd_sc_hd__fill_2
XFILLER_9_363 VGND VGND VPWR VPWR sky130_fd_sc_hd__fill_1
X_3671_ net630 net348 net419 VGND VGND VPWR VPWR _1642_ sky130_fd_sc_hd__and3_1
X_2622_ net597 net509 net395 net671 net300 VGND VGND VPWR VPWR _0911_ sky130_fd_sc_hd__a221o_1
XFILLER_63_3 VGND VGND VPWR VPWR sky130_fd_sc_hd__fill_1
Xoutput115 net115 VGND VGND VPWR VPWR data_location[0] sky130_fd_sc_hd__buf_2
X_2553_ net103 net104 VGND VGND VPWR VPWR _0863_ sky130_fd_sc_hd__nor2_1
Xoutput137 net137 VGND VGND VPWR VPWR out[25] sky130_fd_sc_hd__buf_2
Xoutput148 net148 VGND VGND VPWR VPWR out[6] sky130_fd_sc_hd__buf_2
Xoutput126 net126 VGND VGND VPWR VPWR out[15] sky130_fd_sc_hd__buf_2
X_2484_ net692 net620 net515 VGND VGND VPWR VPWR _0814_ sky130_fd_sc_hd__mux2_1
XPHY_EDGE_ROW_34_Left_129 VGND VGND VPWR VPWR sky130_fd_sc_hd__decap_3
X_4223_ net728 net235 net231 _2097_ VGND VGND VPWR VPWR _2098_ sky130_fd_sc_hd__a211o_1
X_4154_ net1033 net225 _2052_ VGND VGND VPWR VPWR _0389_ sky130_fd_sc_hd__o21a_1
X_3105_ net965 net163 _1245_ _1246_ VGND VGND VPWR VPWR _0142_ sky130_fd_sc_hd__o22a_1
XFILLER_28_429 VGND VGND VPWR VPWR sky130_fd_sc_hd__fill_2
X_4085_ array\[2\]\[28\] net464 net447 array\[0\]\[28\] VGND VGND VPWR VPWR _1996_
+ sky130_fd_sc_hd__a22o_1
X_3036_ net735 net193 _1196_ net379 VGND VGND VPWR VPWR _1197_ sky130_fd_sc_hd__a22o_1
XFILLER_36_440 VGND VGND VPWR VPWR sky130_fd_sc_hd__decap_4
XPHY_EDGE_ROW_43_Left_138 VGND VGND VPWR VPWR sky130_fd_sc_hd__decap_3
XFILLER_63_270 VGND VGND VPWR VPWR sky130_fd_sc_hd__decap_3
XFILLER_63_281 VPWR VGND VPWR VGND sky130_ef_sc_hd__decap_12
X_3938_ array\[13\]\[15\] net556 net539 array\[15\]\[15\] _1861_ VGND VGND VPWR VPWR
+ _1862_ sky130_fd_sc_hd__a221o_1
X_3869_ array\[1\]\[9\] net551 net529 array\[3\]\[9\] _1798_ VGND VGND VPWR VPWR _1799_
+ sky130_fd_sc_hd__a221o_1
XFILLER_3_517 VPWR VGND VPWR VGND sky130_ef_sc_hd__decap_12
XPHY_EDGE_ROW_52_Left_147 VGND VGND VPWR VPWR sky130_fd_sc_hd__decap_3
XFILLER_87_27 VPWR VGND VPWR VGND sky130_ef_sc_hd__decap_12
XFILLER_78_307 VGND VGND VPWR VPWR sky130_fd_sc_hd__fill_1
Xfanout320 net322 VGND VGND VPWR VPWR net320 sky130_fd_sc_hd__clkbuf_4
Xfanout331 _2114_ VGND VGND VPWR VPWR net331 sky130_fd_sc_hd__clkbuf_4
Xfanout364 _1442_ VGND VGND VPWR VPWR net364 sky130_fd_sc_hd__clkbuf_2
Xfanout342 _2049_ VGND VGND VPWR VPWR net342 sky130_fd_sc_hd__clkbuf_4
Xfanout375 net378 VGND VGND VPWR VPWR net375 sky130_fd_sc_hd__buf_4
Xfanout353 _1616_ VGND VGND VPWR VPWR net353 sky130_fd_sc_hd__buf_4
XFILLER_19_429 VGND VGND VPWR VPWR sky130_fd_sc_hd__fill_2
Xfanout386 _1067_ VGND VGND VPWR VPWR net386 sky130_fd_sc_hd__buf_4
Xfanout397 _0869_ VGND VGND VPWR VPWR net397 sky130_fd_sc_hd__clkbuf_4
XFILLER_46_237 VPWR VGND VPWR VGND sky130_ef_sc_hd__decap_12
XTAP_TAPCELL_ROW_57_777 VGND VPWR sky130_fd_sc_hd__tapvpwrvgnd_1
XPHY_EDGE_ROW_61_Left_156 VGND VGND VPWR VPWR sky130_fd_sc_hd__decap_3
XTAP_TAPCELL_ROW_40_600 VGND VPWR sky130_fd_sc_hd__tapvpwrvgnd_1
XTAP_TAPCELL_ROW_12_324 VGND VPWR sky130_fd_sc_hd__tapvpwrvgnd_1
XFILLER_10_340 VGND VGND VPWR VPWR sky130_fd_sc_hd__fill_1
Xinput17 value0[19] VGND VGND VPWR VPWR net17 sky130_fd_sc_hd__buf_1
Xinput28 value0[29] VGND VGND VPWR VPWR net28 sky130_fd_sc_hd__buf_1
XFILLER_6_333 VGND VGND VPWR VPWR sky130_fd_sc_hd__decap_6
Xinput39 value1[0] VGND VGND VPWR VPWR net39 sky130_fd_sc_hd__buf_1
XPHY_EDGE_ROW_70_Left_165 VGND VGND VPWR VPWR sky130_fd_sc_hd__decap_3
XFILLER_2_561 VGND VGND VPWR VPWR sky130_fd_sc_hd__fill_1
XFILLER_92_365 VGND VGND VPWR VPWR sky130_fd_sc_hd__fill_2
XFILLER_80_505 VGND VGND VPWR VPWR sky130_fd_sc_hd__decap_6
XFILLER_18_462 VGND VGND VPWR VPWR sky130_fd_sc_hd__decap_3
XFILLER_93_81 VPWR VGND VPWR VGND sky130_ef_sc_hd__decap_12
XFILLER_18_473 VGND VGND VPWR VPWR sky130_fd_sc_hd__decap_3
XFILLER_18_495 VGND VGND VPWR VPWR sky130_fd_sc_hd__fill_1
X_4910_ clknet_leaf_1_clk _0441_ VGND VGND VPWR VPWR array\[6\]\[21\] sky130_fd_sc_hd__dfxtp_1
X_4841_ clknet_leaf_29_clk _0372_ VGND VGND VPWR VPWR net139 sky130_fd_sc_hd__dfxtp_1
XTAP_TAPCELL_ROW_82_1024 VGND VPWR sky130_fd_sc_hd__tapvpwrvgnd_1
X_4772_ clknet_leaf_64_clk _0303_ VGND VGND VPWR VPWR ready_check\[0\] sky130_fd_sc_hd__dfxtp_1
X_3723_ net743 net350 net420 VGND VGND VPWR VPWR _1676_ sky130_fd_sc_hd__and3_1
X_3654_ net563 ready_check\[3\] _1628_ VGND VGND VPWR VPWR _1629_ sky130_fd_sc_hd__and3_1
X_2605_ net1118 net299 _0898_ _0899_ VGND VGND VPWR VPWR _0569_ sky130_fd_sc_hd__o22a_1
XTAP_TAPCELL_ROW_93_1131 VGND VPWR sky130_fd_sc_hd__tapvpwrvgnd_1
X_3585_ net573 net476 net359 net643 VGND VGND VPWR VPWR _1576_ sky130_fd_sc_hd__a22o_1
X_2536_ net720 net304 _0848_ net402 net308 VGND VGND VPWR VPWR _0849_ sky130_fd_sc_hd__a221o_1
X_2467_ net705 net305 _0802_ net403 net309 VGND VGND VPWR VPWR _0803_ sky130_fd_sc_hd__a221o_1
X_4206_ net1167 net225 _2085_ _2086_ VGND VGND VPWR VPWR _0407_ sky130_fd_sc_hd__o22a_1
X_2398_ net1175 net210 _0753_ VGND VGND VPWR VPWR _0508_ sky130_fd_sc_hd__o21a_1
XFILLER_68_351 VGND VGND VPWR VPWR sky130_fd_sc_hd__fill_1
X_4137_ net2 _2036_ _2039_ VGND VGND VPWR VPWR _2040_ sky130_fd_sc_hd__and3_1
X_4068_ net416 _1975_ _1979_ net356 net214 VGND VGND VPWR VPWR _1981_ sky130_fd_sc_hd__a221o_1
XFILLER_83_354 VGND VGND VPWR VPWR sky130_fd_sc_hd__decap_3
XFILLER_71_505 VPWR VGND VPWR VGND sky130_ef_sc_hd__decap_12
XFILLER_24_421 VGND VGND VPWR VPWR sky130_fd_sc_hd__fill_1
X_3019_ net982 _1185_ net168 VGND VGND VPWR VPWR _0117_ sky130_fd_sc_hd__mux2_1
XTAP_TAPCELL_ROW_54_747 VGND VPWR sky130_fd_sc_hd__tapvpwrvgnd_1
XFILLER_51_262 VGND VGND VPWR VPWR sky130_fd_sc_hd__fill_2
XFILLER_22_66 VGND VGND VPWR VPWR sky130_fd_sc_hd__fill_2
Xfanout172 _0604_ VGND VGND VPWR VPWR net172 sky130_fd_sc_hd__clkbuf_4
Xfanout161 net164 VGND VGND VPWR VPWR net161 sky130_fd_sc_hd__buf_4
Xfanout183 _1300_ VGND VGND VPWR VPWR net183 sky130_fd_sc_hd__buf_4
Xfanout194 _1153_ VGND VGND VPWR VPWR net194 sky130_fd_sc_hd__buf_2
XFILLER_47_535 VGND VGND VPWR VPWR sky130_fd_sc_hd__fill_1
XFILLER_15_487 VGND VGND VPWR VPWR sky130_fd_sc_hd__fill_1
XFILLER_63_73 VGND VGND VPWR VPWR sky130_fd_sc_hd__decap_3
XFILLER_6_141 VGND VGND VPWR VPWR sky130_fd_sc_hd__decap_4
XFILLER_6_130 VGND VGND VPWR VPWR sky130_fd_sc_hd__fill_1
Xmax_cap339 _2113_ VGND VGND VPWR VPWR net339 sky130_fd_sc_hd__clkbuf_2
X_3370_ net581 net483 net368 net657 net178 VGND VGND VPWR VPWR _1428_ sky130_fd_sc_hd__a221o_1
X_2321_ net657 net581 net521 VGND VGND VPWR VPWR _0699_ sky130_fd_sc_hd__mux2_1
X_2252_ net637 net567 net524 VGND VGND VPWR VPWR _0653_ sky130_fd_sc_hd__mux2_1
X_2183_ ready_check\[12\] ready_check\[13\] ready_check\[14\] ready_check\[15\] _0000_
+ _0001_ VGND VGND VPWR VPWR _0594_ sky130_fd_sc_hd__mux4_1
XFILLER_53_505 VGND VGND VPWR VPWR sky130_fd_sc_hd__decap_3
XFILLER_65_387 VGND VGND VPWR VPWR sky130_fd_sc_hd__decap_4
XTAP_TAPCELL_ROW_51_717 VGND VPWR sky130_fd_sc_hd__tapvpwrvgnd_1
XFILLER_21_435 VGND VGND VPWR VPWR sky130_fd_sc_hd__decap_8
X_4824_ clknet_leaf_47_clk _0355_ VGND VGND VPWR VPWR net121 sky130_fd_sc_hd__dfxtp_1
X_4755_ clknet_leaf_36_clk _0286_ VGND VGND VPWR VPWR array\[10\]\[24\] sky130_fd_sc_hd__dfxtp_1
X_3706_ net621 net424 net344 net693 net241 VGND VGND VPWR VPWR _1666_ sky130_fd_sc_hd__a221o_1
X_4686_ clknet_leaf_58_clk _0217_ VGND VGND VPWR VPWR array\[12\]\[19\] sky130_fd_sc_hd__dfxtp_1
X_3637_ head\[3\] _0585_ VGND VGND VPWR VPWR _1616_ sky130_fd_sc_hd__nor2_4
X_3568_ net589 net473 net359 net663 net254 VGND VGND VPWR VPWR _1565_ sky130_fd_sc_hd__a221o_1
XFILLER_68_29 VPWR VGND VPWR VGND sky130_ef_sc_hd__decap_12
XFILLER_0_328 VGND VGND VPWR VPWR sky130_fd_sc_hd__decap_8
X_2519_ net1260 net204 _0837_ VGND VGND VPWR VPWR _0545_ sky130_fd_sc_hd__o21a_1
X_3499_ net717 net247 VGND VGND VPWR VPWR _1519_ sky130_fd_sc_hd__and2_1
XFILLER_29_557 VGND VGND VPWR VPWR sky130_fd_sc_hd__decap_3
XFILLER_56_365 VPWR VGND VPWR VGND sky130_ef_sc_hd__decap_12
XTAP_TAPCELL_ROW_67_872 VGND VPWR sky130_fd_sc_hd__tapvpwrvgnd_1
XFILLER_83_195 VGND VGND VPWR VPWR sky130_fd_sc_hd__fill_1
XTAP_TAPCELL_ROW_39_596 VGND VPWR sky130_fd_sc_hd__tapvpwrvgnd_1
XFILLER_71_368 VGND VGND VPWR VPWR sky130_fd_sc_hd__decap_3
XFILLER_24_240 VGND VGND VPWR VPWR sky130_fd_sc_hd__decap_3
XFILLER_12_413 VGND VGND VPWR VPWR sky130_fd_sc_hd__decap_6
XFILLER_12_457 VPWR VGND VPWR VGND sky130_ef_sc_hd__decap_12
XFILLER_3_166 VGND VGND VPWR VPWR sky130_fd_sc_hd__fill_2
XFILLER_58_73 VGND VGND VPWR VPWR sky130_fd_sc_hd__fill_1
XFILLER_94_449 VGND VGND VPWR VPWR sky130_fd_sc_hd__fill_2
XFILLER_87_490 VPWR VGND VPWR VGND sky130_ef_sc_hd__decap_12
Xhold6 net119 VGND VGND VPWR VPWR net772 sky130_fd_sc_hd__dlygate4sd3_1
XFILLER_74_184 VGND VGND VPWR VPWR sky130_fd_sc_hd__fill_1
XFILLER_62_357 VGND VGND VPWR VPWR sky130_fd_sc_hd__decap_6
XFILLER_15_262 VGND VGND VPWR VPWR sky130_fd_sc_hd__fill_1
X_2870_ net1235 net199 _1080_ VGND VGND VPWR VPWR _0073_ sky130_fd_sc_hd__o21a_1
XFILLER_15_295 VGND VGND VPWR VPWR sky130_fd_sc_hd__fill_1
Xclkbuf_leaf_10_clk clknet_3_5__leaf_clk VGND VGND VPWR VPWR clknet_leaf_10_clk sky130_fd_sc_hd__clkbuf_8
X_4540_ clknet_leaf_3_clk _0071_ VGND VGND VPWR VPWR array\[0\]\[1\] sky130_fd_sc_hd__dfxtp_1
Xhold417 array\[15\]\[3\] VGND VGND VPWR VPWR net1183 sky130_fd_sc_hd__dlygate4sd3_1
Xhold406 array\[8\]\[0\] VGND VGND VPWR VPWR net1172 sky130_fd_sc_hd__dlygate4sd3_1
XFILLER_7_461 VPWR VGND VPWR VGND sky130_ef_sc_hd__decap_12
X_4471_ clknet_leaf_54_clk _0582_ VGND VGND VPWR VPWR array\[4\]\[28\] sky130_fd_sc_hd__dfxtp_1
X_3422_ net621 net478 net364 net693 VGND VGND VPWR VPWR _1465_ sky130_fd_sc_hd__a22o_1
Xhold428 array\[0\]\[7\] VGND VGND VPWR VPWR net1194 sky130_fd_sc_hd__dlygate4sd3_1
Xhold439 array\[4\]\[0\] VGND VGND VPWR VPWR net1205 sky130_fd_sc_hd__dlygate4sd3_1
XTAP_TAPCELL_ROW_90_1101 VGND VPWR sky130_fd_sc_hd__tapvpwrvgnd_1
X_3353_ net1207 net153 _1415_ _1416_ VGND VGND VPWR VPWR _0220_ sky130_fd_sc_hd__o22a_1
X_3284_ _0625_ _1145_ _1366_ _1369_ net563 VGND VGND VPWR VPWR _1370_ sky130_fd_sc_hd__o311a_1
X_2304_ net733 net320 _0687_ net411 net328 VGND VGND VPWR VPWR _0688_ sky130_fd_sc_hd__a221o_1
X_2235_ net654 net411 _0639_ VGND VGND VPWR VPWR _0641_ sky130_fd_sc_hd__or3b_1
XFILLER_93_482 VPWR VGND VPWR VGND sky130_ef_sc_hd__decap_12
XFILLER_65_162 VGND VGND VPWR VPWR sky130_fd_sc_hd__fill_1
XTAP_TAPCELL_ROW_88_1085 VGND VPWR sky130_fd_sc_hd__tapvpwrvgnd_1
XTAP_TAPCELL_ROW_64_842 VGND VPWR sky130_fd_sc_hd__tapvpwrvgnd_1
XFILLER_53_335 VGND VGND VPWR VPWR sky130_fd_sc_hd__fill_1
XTAP_TAPCELL_ROW_36_566 VGND VPWR sky130_fd_sc_hd__tapvpwrvgnd_1
XPHY_EDGE_ROW_3_Right_3 VGND VGND VPWR VPWR sky130_fd_sc_hd__decap_3
X_4807_ clknet_leaf_41_clk _0338_ VGND VGND VPWR VPWR array\[9\]\[25\] sky130_fd_sc_hd__dfxtp_1
X_2999_ net627 net758 net493 VGND VGND VPWR VPWR _1172_ sky130_fd_sc_hd__mux2_1
X_4738_ clknet_leaf_60_clk _0269_ VGND VGND VPWR VPWR array\[10\]\[7\] sky130_fd_sc_hd__dfxtp_1
X_4669_ clknet_leaf_34_clk _0200_ VGND VGND VPWR VPWR array\[12\]\[2\] sky130_fd_sc_hd__dfxtp_1
XFILLER_0_169 VGND VGND VPWR VPWR sky130_fd_sc_hd__decap_8
XFILLER_91_408 VPWR VGND VPWR VGND sky130_ef_sc_hd__decap_12
XFILLER_56_195 VGND VGND VPWR VPWR sky130_fd_sc_hd__fill_1
XFILLER_71_165 VGND VGND VPWR VPWR sky130_fd_sc_hd__decap_3
XFILLER_12_210 VGND VGND VPWR VPWR sky130_fd_sc_hd__decap_4
XFILLER_60_41 VPWR VGND VPWR VGND sky130_ef_sc_hd__decap_12
XFILLER_60_85 VGND VGND VPWR VPWR sky130_fd_sc_hd__fill_1
XFILLER_4_475 VGND VGND VPWR VPWR sky130_fd_sc_hd__fill_1
XFILLER_69_94 VGND VGND VPWR VPWR sky130_fd_sc_hd__fill_1
XFILLER_79_287 VGND VGND VPWR VPWR sky130_fd_sc_hd__decap_8
XTAP_TAPCELL_ROW_78_989 VGND VPWR sky130_fd_sc_hd__tapvpwrvgnd_1
Xclkbuf_leaf_59_clk clknet_3_0__leaf_clk VGND VGND VPWR VPWR clknet_leaf_59_clk sky130_fd_sc_hd__clkbuf_8
XFILLER_94_279 VGND VGND VPWR VPWR sky130_fd_sc_hd__fill_1
XFILLER_85_93 VPWR VGND VPWR VGND sky130_ef_sc_hd__decap_12
XFILLER_35_324 VGND VGND VPWR VPWR sky130_fd_sc_hd__fill_2
X_3971_ array\[6\]\[18\] net460 net443 array\[4\]\[18\] VGND VGND VPWR VPWR _1892_
+ sky130_fd_sc_hd__a22o_1
XTAP_TAPCELL_ROW_61_812 VGND VPWR sky130_fd_sc_hd__tapvpwrvgnd_1
XTAP_TAPCELL_ROW_33_536 VGND VPWR sky130_fd_sc_hd__tapvpwrvgnd_1
X_2922_ net597 net671 net497 VGND VGND VPWR VPWR _1115_ sky130_fd_sc_hd__mux2_1
XFILLER_93_3 VPWR VGND VPWR VGND sky130_ef_sc_hd__decap_12
X_2853_ net756 _0709_ net497 VGND VGND VPWR VPWR _1067_ sky130_fd_sc_hd__o21ai_4
X_2784_ net1187 net283 _1022_ _1023_ VGND VGND VPWR VPWR _0044_ sky130_fd_sc_hd__o22a_1
X_4523_ clknet_leaf_21_clk _0054_ VGND VGND VPWR VPWR array\[8\]\[16\] sky130_fd_sc_hd__dfxtp_1
Xhold225 array\[9\]\[11\] VGND VGND VPWR VPWR net991 sky130_fd_sc_hd__dlygate4sd3_1
Xhold203 array\[8\]\[29\] VGND VGND VPWR VPWR net969 sky130_fd_sc_hd__dlygate4sd3_1
Xhold214 array\[8\]\[14\] VGND VGND VPWR VPWR net980 sky130_fd_sc_hd__dlygate4sd3_1
Xhold236 array\[1\]\[13\] VGND VGND VPWR VPWR net1002 sky130_fd_sc_hd__dlygate4sd3_1
X_4454_ clknet_leaf_17_clk _0565_ VGND VGND VPWR VPWR array\[4\]\[11\] sky130_fd_sc_hd__dfxtp_1
Xhold258 array\[15\]\[8\] VGND VGND VPWR VPWR net1024 sky130_fd_sc_hd__dlygate4sd3_1
Xhold247 array\[11\]\[25\] VGND VGND VPWR VPWR net1013 sky130_fd_sc_hd__dlygate4sd3_1
Xhold269 array\[2\]\[2\] VGND VGND VPWR VPWR net1035 sky130_fd_sc_hd__dlygate4sd3_1
X_3405_ net567 net479 net365 net637 net265 VGND VGND VPWR VPWR _1454_ sky130_fd_sc_hd__a221o_1
Xfanout705 net35 VGND VGND VPWR VPWR net705 sky130_fd_sc_hd__buf_2
X_4385_ clknet_leaf_7_clk _0496_ VGND VGND VPWR VPWR array\[2\]\[6\] sky130_fd_sc_hd__dfxtp_1
Xfanout716 net30 VGND VGND VPWR VPWR net716 sky130_fd_sc_hd__clkbuf_2
X_3336_ net805 net154 _1404_ _1405_ VGND VGND VPWR VPWR _0214_ sky130_fd_sc_hd__o22a_1
Xfanout727 net24 VGND VGND VPWR VPWR net727 sky130_fd_sc_hd__clkbuf_2
Xfanout749 net13 VGND VGND VPWR VPWR net749 sky130_fd_sc_hd__buf_2
XFILLER_58_405 VGND VGND VPWR VPWR sky130_fd_sc_hd__fill_2
Xfanout738 net19 VGND VGND VPWR VPWR net738 sky130_fd_sc_hd__dlymetal6s2s_1
X_3267_ net820 _1357_ net160 VGND VGND VPWR VPWR _0193_ sky130_fd_sc_hd__mux2_1
XFILLER_65_19 VGND VGND VPWR VPWR sky130_fd_sc_hd__decap_8
X_2218_ net651 _0624_ VGND VGND VPWR VPWR _0625_ sky130_fd_sc_hd__nor2_1
X_3198_ net963 _1311_ net157 VGND VGND VPWR VPWR _0170_ sky130_fd_sc_hd__mux2_1
XTAP_TAPCELL_ROW_49_691 VGND VPWR sky130_fd_sc_hd__tapvpwrvgnd_1
XANTENNA_109 net414 VGND VGND VPWR VPWR sky130_fd_sc_hd__diode_2
XFILLER_41_327 VGND VGND VPWR VPWR sky130_fd_sc_hd__fill_1
XFILLER_89_541 VPWR VGND VPWR VGND sky130_ef_sc_hd__decap_12
XFILLER_49_449 VGND VGND VPWR VPWR sky130_fd_sc_hd__decap_3
XFILLER_57_471 VGND VGND VPWR VPWR sky130_fd_sc_hd__decap_3
XTAP_TAPCELL_ROW_75_959 VGND VPWR sky130_fd_sc_hd__tapvpwrvgnd_1
XFILLER_55_30 VGND VGND VPWR VPWR sky130_fd_sc_hd__decap_8
XFILLER_13_541 VPWR VGND VPWR VGND sky130_ef_sc_hd__decap_12
XFILLER_25_390 VGND VGND VPWR VPWR sky130_fd_sc_hd__fill_2
XFILLER_71_51 VGND VGND VPWR VPWR sky130_fd_sc_hd__decap_4
XTAP_TAPCELL_ROW_30_506 VGND VPWR sky130_fd_sc_hd__tapvpwrvgnd_1
XFILLER_65_7 VPWR VGND VPWR VGND sky130_ef_sc_hd__decap_12
X_4170_ net763 net431 net340 net634 VGND VGND VPWR VPWR _2063_ sky130_fd_sc_hd__a22o_1
X_3121_ net615 net489 net375 net687 VGND VGND VPWR VPWR _1257_ sky130_fd_sc_hd__a22o_1
X_3052_ net830 _1207_ net167 VGND VGND VPWR VPWR _0128_ sky130_fd_sc_hd__mux2_1
XFILLER_82_249 VGND VGND VPWR VPWR sky130_fd_sc_hd__decap_3
XFILLER_35_110 VGND VGND VPWR VPWR sky130_fd_sc_hd__fill_2
XTAP_TAPCELL_ROW_85_1055 VGND VPWR sky130_fd_sc_hd__tapvpwrvgnd_1
XTAP_TAPCELL_ROW_46_661 VGND VPWR sky130_fd_sc_hd__tapvpwrvgnd_1
XFILLER_90_293 VGND VGND VPWR VPWR sky130_fd_sc_hd__fill_1
XTAP_TAPCELL_ROW_18_385 VGND VPWR sky130_fd_sc_hd__tapvpwrvgnd_1
X_3954_ array\[9\]\[16\] net554 net538 array\[11\]\[16\] _1876_ VGND VGND VPWR VPWR
+ _1877_ sky130_fd_sc_hd__a221o_1
XFILLER_16_390 VGND VGND VPWR VPWR sky130_fd_sc_hd__decap_3
XFILLER_50_135 VGND VGND VPWR VPWR sky130_fd_sc_hd__decap_4
X_3885_ array\[13\]\[10\] net552 net530 array\[15\]\[10\] _1813_ VGND VGND VPWR VPWR
+ _1814_ sky130_fd_sc_hd__a221o_1
X_2905_ net749 net272 _1103_ net385 net269 VGND VGND VPWR VPWR _1104_ sky130_fd_sc_hd__a221o_1
X_2836_ net1031 net284 _1055_ _1056_ VGND VGND VPWR VPWR _0063_ sky130_fd_sc_hd__o22a_1
X_2767_ net1172 net284 _1011_ _1012_ VGND VGND VPWR VPWR _0038_ sky130_fd_sc_hd__o22a_1
X_2698_ net689 net617 net392 VGND VGND VPWR VPWR _0963_ sky130_fd_sc_hd__mux2_1
X_4506_ clknet_leaf_44_clk _0037_ VGND VGND VPWR VPWR array\[5\]\[31\] sky130_fd_sc_hd__dfxtp_1
X_4437_ clknet_leaf_24_clk _0548_ VGND VGND VPWR VPWR array\[3\]\[26\] sky130_fd_sc_hd__dfxtp_1
Xfanout513 net514 VGND VGND VPWR VPWR net513 sky130_fd_sc_hd__buf_4
Xfanout502 net505 VGND VGND VPWR VPWR net502 sky130_fd_sc_hd__clkbuf_4
Xfanout524 _0631_ VGND VGND VPWR VPWR net524 sky130_fd_sc_hd__buf_2
XFILLER_86_533 VPWR VGND VPWR VGND sky130_ef_sc_hd__decap_12
Xfanout557 net558 VGND VGND VPWR VPWR net557 sky130_fd_sc_hd__buf_2
XFILLER_76_29 VGND VGND VPWR VPWR sky130_fd_sc_hd__decap_8
X_4368_ clknet_leaf_0_clk _0479_ VGND VGND VPWR VPWR array\[1\]\[21\] sky130_fd_sc_hd__dfxtp_1
Xfanout546 net549 VGND VGND VPWR VPWR net546 sky130_fd_sc_hd__clkbuf_4
Xfanout535 net542 VGND VGND VPWR VPWR net535 sky130_fd_sc_hd__buf_2
XFILLER_58_213 VGND VGND VPWR VPWR sky130_fd_sc_hd__fill_1
Xfanout568 net98 VGND VGND VPWR VPWR net568 sky130_fd_sc_hd__clkbuf_2
Xfanout579 net92 VGND VGND VPWR VPWR net579 sky130_fd_sc_hd__buf_2
X_3319_ net964 net154 _1393_ _1394_ VGND VGND VPWR VPWR _0208_ sky130_fd_sc_hd__o22a_1
X_4299_ net742 net335 VGND VGND VPWR VPWR _2148_ sky130_fd_sc_hd__and2_1
XFILLER_58_279 VGND VGND VPWR VPWR sky130_fd_sc_hd__decap_4
XTAP_TAPCELL_ROW_72_929 VGND VPWR sky130_fd_sc_hd__tapvpwrvgnd_1
XFILLER_81_293 VGND VGND VPWR VPWR sky130_fd_sc_hd__decap_6
XFILLER_10_533 VPWR VGND VPWR VGND sky130_ef_sc_hd__decap_12
XFILLER_1_253 VGND VGND VPWR VPWR sky130_fd_sc_hd__fill_1
XFILLER_2_15 VPWR VGND VPWR VGND sky130_ef_sc_hd__decap_12
XFILLER_89_393 VPWR VGND VPWR VGND sky130_ef_sc_hd__decap_12
XFILLER_1_297 VGND VGND VPWR VPWR sky130_fd_sc_hd__fill_1
XFILLER_49_257 VGND VGND VPWR VPWR sky130_fd_sc_hd__decap_8
XFILLER_92_525 VGND VGND VPWR VPWR sky130_fd_sc_hd__decap_6
XFILLER_82_83 VGND VGND VPWR VPWR sky130_fd_sc_hd__fill_1
XTAP_TAPCELL_ROW_43_631 VGND VPWR sky130_fd_sc_hd__tapvpwrvgnd_1
XTAP_TAPCELL_ROW_15_355 VGND VPWR sky130_fd_sc_hd__tapvpwrvgnd_1
XFILLER_60_477 VGND VGND VPWR VPWR sky130_fd_sc_hd__fill_1
XFILLER_13_393 VGND VGND VPWR VPWR sky130_fd_sc_hd__decap_3
X_3670_ net348 net420 VGND VGND VPWR VPWR _1641_ sky130_fd_sc_hd__and2_2
XFILLER_9_397 VGND VGND VPWR VPWR sky130_fd_sc_hd__fill_1
X_2621_ net735 net399 net506 VGND VGND VPWR VPWR _0910_ sky130_fd_sc_hd__and3_1
Xoutput116 net116 VGND VGND VPWR VPWR data_location[1] sky130_fd_sc_hd__buf_2
X_2552_ _0860_ _0861_ net509 VGND VGND VPWR VPWR _0862_ sky130_fd_sc_hd__a21oi_2
XFILLER_56_3 VPWR VGND VPWR VGND sky130_ef_sc_hd__decap_12
Xoutput127 net127 VGND VGND VPWR VPWR out[16] sky130_fd_sc_hd__buf_2
Xoutput138 net138 VGND VGND VPWR VPWR out[26] sky130_fd_sc_hd__buf_2
Xoutput149 net149 VGND VGND VPWR VPWR out[7] sky130_fd_sc_hd__buf_2
X_2483_ net914 net205 _0813_ VGND VGND VPWR VPWR _0533_ sky130_fd_sc_hd__o21a_1
X_4222_ net590 net433 net342 net664 VGND VGND VPWR VPWR _2097_ sky130_fd_sc_hd__a22o_1
X_4153_ net740 net233 net229 _2051_ VGND VGND VPWR VPWR _2052_ sky130_fd_sc_hd__a211o_1
XFILLER_83_514 VPWR VGND VPWR VGND sky130_ef_sc_hd__decap_12
X_3104_ net761 net492 net377 net632 net191 VGND VGND VPWR VPWR _1246_ sky130_fd_sc_hd__a221o_1
X_4084_ array\[13\]\[28\] net550 net529 array\[15\]\[28\] _1994_ VGND VGND VPWR VPWR
+ _1995_ sky130_fd_sc_hd__a221o_1
XFILLER_83_558 VGND VGND VPWR VPWR sky130_fd_sc_hd__fill_2
X_3035_ net671 net597 net493 VGND VGND VPWR VPWR _1196_ sky130_fd_sc_hd__mux2_1
XFILLER_36_463 VGND VGND VPWR VPWR sky130_fd_sc_hd__decap_4
XFILLER_23_102 VGND VGND VPWR VPWR sky130_fd_sc_hd__fill_1
XFILLER_23_135 VGND VGND VPWR VPWR sky130_fd_sc_hd__fill_2
XFILLER_63_293 VGND VGND VPWR VPWR sky130_fd_sc_hd__fill_2
X_3937_ array\[14\]\[15\] net470 net453 array\[12\]\[15\] VGND VGND VPWR VPWR _1861_
+ sky130_fd_sc_hd__a22o_1
X_3868_ array\[2\]\[9\] net464 net447 array\[0\]\[9\] VGND VGND VPWR VPWR _1798_ sky130_fd_sc_hd__a22o_1
X_2819_ net603 net502 net275 net677 net285 VGND VGND VPWR VPWR _1046_ sky130_fd_sc_hd__a221o_1
X_3799_ net802 net171 _1735_ VGND VGND VPWR VPWR _0347_ sky130_fd_sc_hd__o21a_1
XFILLER_3_529 VPWR VGND VPWR VGND sky130_ef_sc_hd__decap_12
XFILLER_87_39 VPWR VGND VPWR VGND sky130_ef_sc_hd__decap_12
Xfanout310 _0787_ VGND VGND VPWR VPWR net310 sky130_fd_sc_hd__buf_4
Xfanout321 net322 VGND VGND VPWR VPWR net321 sky130_fd_sc_hd__clkbuf_4
Xfanout332 _2114_ VGND VGND VPWR VPWR net332 sky130_fd_sc_hd__clkbuf_2
Xfanout343 _2049_ VGND VGND VPWR VPWR net343 sky130_fd_sc_hd__clkbuf_2
Xfanout365 _1442_ VGND VGND VPWR VPWR net365 sky130_fd_sc_hd__buf_4
Xfanout354 _1616_ VGND VGND VPWR VPWR net354 sky130_fd_sc_hd__buf_2
XFILLER_86_363 VGND VGND VPWR VPWR sky130_fd_sc_hd__fill_1
Xfanout398 _0869_ VGND VGND VPWR VPWR net398 sky130_fd_sc_hd__clkbuf_2
Xfanout376 net378 VGND VGND VPWR VPWR net376 sky130_fd_sc_hd__buf_4
Xfanout387 net388 VGND VGND VPWR VPWR net387 sky130_fd_sc_hd__clkbuf_4
XFILLER_46_249 VGND VGND VPWR VPWR sky130_fd_sc_hd__decap_3
XTAP_TAPCELL_ROW_57_778 VGND VPWR sky130_fd_sc_hd__tapvpwrvgnd_1
XTAP_TAPCELL_ROW_40_601 VGND VPWR sky130_fd_sc_hd__tapvpwrvgnd_1
XTAP_TAPCELL_ROW_12_325 VGND VPWR sky130_fd_sc_hd__tapvpwrvgnd_1
Xinput18 value0[1] VGND VGND VPWR VPWR net18 sky130_fd_sc_hd__clkbuf_1
XFILLER_10_363 VGND VGND VPWR VPWR sky130_fd_sc_hd__fill_1
Xinput29 value0[2] VGND VGND VPWR VPWR net29 sky130_fd_sc_hd__clkbuf_1
XFILLER_28_7 VGND VGND VPWR VPWR sky130_fd_sc_hd__fill_1
XFILLER_18_452 VGND VGND VPWR VPWR sky130_fd_sc_hd__decap_3
XFILLER_93_93 VPWR VGND VPWR VGND sky130_ef_sc_hd__decap_12
X_4840_ clknet_leaf_25_clk _0371_ VGND VGND VPWR VPWR net138 sky130_fd_sc_hd__dfxtp_1
XTAP_TAPCELL_ROW_82_1025 VGND VPWR sky130_fd_sc_hd__tapvpwrvgnd_1
XTAP_TAPCELL_ROW_28_480 VGND VPWR sky130_fd_sc_hd__tapvpwrvgnd_1
XFILLER_33_488 VGND VGND VPWR VPWR sky130_fd_sc_hd__decap_3
X_4771_ clknet_leaf_61_clk _0302_ VGND VGND VPWR VPWR ready_check\[10\] sky130_fd_sc_hd__dfxtp_1
X_3722_ net1253 net243 _1641_ net745 _1675_ VGND VGND VPWR VPWR _0330_ sky130_fd_sc_hd__a221o_1
XFILLER_9_183 VGND VGND VPWR VPWR sky130_fd_sc_hd__fill_1
X_3653_ _1140_ _1604_ VGND VGND VPWR VPWR _1628_ sky130_fd_sc_hd__nand2_1
X_2604_ net613 net512 net398 net685 net303 VGND VGND VPWR VPWR _0899_ sky130_fd_sc_hd__a221o_1
XTAP_TAPCELL_ROW_93_1132 VGND VPWR sky130_fd_sc_hd__tapvpwrvgnd_1
X_3584_ net874 net250 _1574_ _1575_ VGND VGND VPWR VPWR _0292_ sky130_fd_sc_hd__o22a_1
X_2535_ net650 net580 net513 VGND VGND VPWR VPWR _0848_ sky130_fd_sc_hd__mux2_1
XFILLER_87_105 VGND VGND VPWR VPWR sky130_fd_sc_hd__decap_6
X_2466_ net635 net565 net514 VGND VGND VPWR VPWR _0802_ sky130_fd_sc_hd__mux2_1
X_4205_ net604 net431 net340 net678 net229 VGND VGND VPWR VPWR _2086_ sky130_fd_sc_hd__a221o_1
X_2397_ net743 net318 _0752_ net407 _0715_ VGND VGND VPWR VPWR _0753_ sky130_fd_sc_hd__a221o_1
XFILLER_68_341 VGND VGND VPWR VPWR sky130_fd_sc_hd__decap_3
X_4136_ _0618_ _0620_ _2037_ _2038_ VGND VGND VPWR VPWR _2039_ sky130_fd_sc_hd__and4_1
X_4067_ net437 _1973_ _1977_ net353 VGND VGND VPWR VPWR _1980_ sky130_fd_sc_hd__a22o_1
XFILLER_71_517 VPWR VGND VPWR VGND sky130_ef_sc_hd__decap_12
X_3018_ net750 net196 _1184_ net382 VGND VGND VPWR VPWR _1185_ sky130_fd_sc_hd__a22o_1
XTAP_TAPCELL_ROW_54_748 VGND VPWR sky130_fd_sc_hd__tapvpwrvgnd_1
XFILLER_24_477 VPWR VGND VPWR VGND sky130_ef_sc_hd__decap_12
XFILLER_7_109 VGND VGND VPWR VPWR sky130_fd_sc_hd__decap_3
XFILLER_3_337 VPWR VGND VPWR VGND sky130_ef_sc_hd__decap_12
Xfanout162 net164 VGND VGND VPWR VPWR net162 sky130_fd_sc_hd__buf_4
Xfanout173 net176 VGND VGND VPWR VPWR net173 sky130_fd_sc_hd__buf_4
XFILLER_59_363 VGND VGND VPWR VPWR sky130_fd_sc_hd__fill_1
Xfanout184 _1300_ VGND VGND VPWR VPWR net184 sky130_fd_sc_hd__buf_2
Xfanout195 net198 VGND VGND VPWR VPWR net195 sky130_fd_sc_hd__buf_4
XFILLER_74_377 VGND VGND VPWR VPWR sky130_fd_sc_hd__decap_8
XTAP_TAPCELL_ROW_25_450 VGND VPWR sky130_fd_sc_hd__tapvpwrvgnd_1
XFILLER_63_63 VGND VGND VPWR VPWR sky130_fd_sc_hd__fill_1
XFILLER_8_47 VGND VGND VPWR VPWR sky130_fd_sc_hd__fill_1
X_2320_ net912 net326 _0698_ VGND VGND VPWR VPWR _0485_ sky130_fd_sc_hd__o21a_1
X_2251_ net1267 net323 _0652_ VGND VGND VPWR VPWR _0462_ sky130_fd_sc_hd__o21a_1
X_2182_ ready_check\[8\] ready_check\[9\] ready_check\[10\] ready_check\[11\] _0000_
+ _0001_ VGND VGND VPWR VPWR _0593_ sky130_fd_sc_hd__mux4_1
XFILLER_92_141 VGND VGND VPWR VPWR sky130_fd_sc_hd__fill_2
XFILLER_80_336 VGND VGND VPWR VPWR sky130_fd_sc_hd__fill_1
XFILLER_18_293 VGND VGND VPWR VPWR sky130_fd_sc_hd__decap_3
XTAP_TAPCELL_ROW_51_718 VGND VPWR sky130_fd_sc_hd__tapvpwrvgnd_1
XFILLER_61_561 VGND VGND VPWR VPWR sky130_fd_sc_hd__fill_1
X_4823_ clknet_3_2__leaf_clk _0354_ VGND VGND VPWR VPWR net151 sky130_fd_sc_hd__dfxtp_1
X_4754_ clknet_leaf_37_clk _0285_ VGND VGND VPWR VPWR array\[10\]\[23\] sky130_fd_sc_hd__dfxtp_1
X_3705_ net585 net348 net419 VGND VGND VPWR VPWR _1665_ sky130_fd_sc_hd__and3_1
X_4685_ clknet_leaf_12_clk _0216_ VGND VGND VPWR VPWR array\[12\]\[18\] sky130_fd_sc_hd__dfxtp_1
X_3636_ net564 net1320 _1614_ _1612_ VGND VGND VPWR VPWR _1615_ sky130_fd_sc_hd__a31o_1
X_3567_ net727 net245 VGND VGND VPWR VPWR _1564_ sky130_fd_sc_hd__and2_1
XFILLER_0_307 VGND VGND VPWR VPWR sky130_fd_sc_hd__fill_1
X_2518_ net731 net304 _0836_ _0783_ net308 VGND VGND VPWR VPWR _0837_ sky130_fd_sc_hd__a221o_1
XFILLER_88_458 VPWR VGND VPWR VGND sky130_ef_sc_hd__decap_12
X_3498_ net1164 net249 _1517_ _1518_ VGND VGND VPWR VPWR _0263_ sky130_fd_sc_hd__o22a_1
X_2449_ net629 net305 _0790_ net403 VGND VGND VPWR VPWR _0791_ sky130_fd_sc_hd__a22o_1
XFILLER_84_29 VPWR VGND VPWR VGND sky130_ef_sc_hd__decap_12
XFILLER_68_182 VGND VGND VPWR VPWR sky130_fd_sc_hd__decap_3
XFILLER_29_525 VPWR VGND VPWR VGND sky130_ef_sc_hd__decap_12
X_4119_ array\[9\]\[31\] net552 net530 array\[11\]\[31\] _2026_ VGND VGND VPWR VPWR
+ _2027_ sky130_fd_sc_hd__a221o_1
XTAP_TAPCELL_ROW_67_873 VGND VPWR sky130_fd_sc_hd__tapvpwrvgnd_1
XFILLER_56_377 VGND VGND VPWR VPWR sky130_fd_sc_hd__fill_2
XTAP_TAPCELL_ROW_39_597 VGND VPWR sky130_fd_sc_hd__tapvpwrvgnd_1
XFILLER_12_469 VGND VGND VPWR VPWR sky130_fd_sc_hd__decap_6
XTAP_TAPCELL_ROW_22_420 VGND VPWR sky130_fd_sc_hd__tapvpwrvgnd_1
XFILLER_79_458 VGND VGND VPWR VPWR sky130_fd_sc_hd__decap_8
Xhold7 net130 VGND VGND VPWR VPWR net773 sky130_fd_sc_hd__dlygate4sd3_1
XFILLER_74_141 VGND VGND VPWR VPWR sky130_fd_sc_hd__decap_6
XFILLER_47_344 VGND VGND VPWR VPWR sky130_fd_sc_hd__decap_4
XFILLER_74_163 VGND VGND VPWR VPWR sky130_fd_sc_hd__decap_6
XFILLER_43_561 VGND VGND VPWR VPWR sky130_fd_sc_hd__fill_1
XFILLER_90_83 VGND VGND VPWR VPWR sky130_fd_sc_hd__fill_1
X_4470_ clknet_leaf_22_clk _0581_ VGND VGND VPWR VPWR array\[4\]\[27\] sky130_fd_sc_hd__dfxtp_1
Xhold407 array\[10\]\[22\] VGND VGND VPWR VPWR net1173 sky130_fd_sc_hd__dlygate4sd3_1
XFILLER_7_473 VPWR VGND VPWR VGND sky130_ef_sc_hd__decap_12
Xhold418 array\[11\]\[8\] VGND VGND VPWR VPWR net1184 sky130_fd_sc_hd__dlygate4sd3_1
X_3421_ net828 net261 _1464_ VGND VGND VPWR VPWR _0240_ sky130_fd_sc_hd__o21a_1
Xhold429 array\[11\]\[28\] VGND VGND VPWR VPWR net1195 sky130_fd_sc_hd__dlygate4sd3_1
XTAP_TAPCELL_ROW_90_1102 VGND VPWR sky130_fd_sc_hd__tapvpwrvgnd_1
X_3352_ net595 net481 net367 net669 net177 VGND VGND VPWR VPWR _1416_ sky130_fd_sc_hd__a221o_1
X_2303_ net669 net595 net522 VGND VGND VPWR VPWR _0687_ sky130_fd_sc_hd__mux2_1
X_3283_ _0861_ _1150_ net481 VGND VGND VPWR VPWR _1369_ sky130_fd_sc_hd__a21oi_1
X_2234_ net411 _0639_ net564 VGND VGND VPWR VPWR _0640_ sky130_fd_sc_hd__and3b_1
XFILLER_93_494 VGND VGND VPWR VPWR sky130_fd_sc_hd__decap_8
XTAP_TAPCELL_ROW_88_1086 VGND VPWR sky130_fd_sc_hd__tapvpwrvgnd_1
XFILLER_80_111 VGND VGND VPWR VPWR sky130_fd_sc_hd__decap_8
XTAP_TAPCELL_ROW_64_843 VGND VPWR sky130_fd_sc_hd__tapvpwrvgnd_1
XFILLER_34_561 VGND VGND VPWR VPWR sky130_fd_sc_hd__fill_1
XTAP_TAPCELL_ROW_36_567 VGND VPWR sky130_fd_sc_hd__tapvpwrvgnd_1
XFILLER_21_255 VGND VGND VPWR VPWR sky130_fd_sc_hd__fill_1
X_4806_ clknet_leaf_36_clk _0337_ VGND VGND VPWR VPWR array\[9\]\[24\] sky130_fd_sc_hd__dfxtp_1
X_2998_ net1024 _1171_ net168 VGND VGND VPWR VPWR _0110_ sky130_fd_sc_hd__mux2_1
X_4737_ clknet_leaf_4_clk _0268_ VGND VGND VPWR VPWR array\[10\]\[6\] sky130_fd_sc_hd__dfxtp_1
XFILLER_79_18 VPWR VGND VPWR VGND sky130_ef_sc_hd__decap_12
X_4668_ clknet_leaf_58_clk _0199_ VGND VGND VPWR VPWR array\[12\]\[1\] sky130_fd_sc_hd__dfxtp_1
X_3619_ net211 _0609_ _1601_ _1599_ VGND VGND VPWR VPWR _0301_ sky130_fd_sc_hd__o31a_1
X_4599_ clknet_leaf_50_clk _0130_ VGND VGND VPWR VPWR array\[15\]\[28\] sky130_fd_sc_hd__dfxtp_1
XFILLER_0_126 VGND VGND VPWR VPWR sky130_fd_sc_hd__decap_8
XFILLER_0_104 VGND VGND VPWR VPWR sky130_fd_sc_hd__decap_4
XFILLER_88_277 VGND VGND VPWR VPWR sky130_fd_sc_hd__fill_2
XFILLER_84_461 VPWR VGND VPWR VGND sky130_ef_sc_hd__decap_12
XFILLER_29_366 VGND VGND VPWR VPWR sky130_fd_sc_hd__decap_3
XFILLER_25_561 VGND VGND VPWR VPWR sky130_fd_sc_hd__fill_1
XFILLER_44_369 VGND VGND VPWR VPWR sky130_fd_sc_hd__fill_1
XFILLER_60_53 VGND VGND VPWR VPWR sky130_fd_sc_hd__fill_2
XFILLER_5_15 VPWR VGND VPWR VGND sky130_ef_sc_hd__decap_12
XFILLER_4_421 VPWR VGND VPWR VGND sky130_ef_sc_hd__decap_12
XFILLER_67_417 VGND VGND VPWR VPWR sky130_fd_sc_hd__decap_3
XTAP_TAPCELL_ROW_7_270 VGND VPWR sky130_fd_sc_hd__tapvpwrvgnd_1
XPHY_EDGE_ROW_13_Right_13 VGND VGND VPWR VPWR sky130_fd_sc_hd__decap_3
XFILLER_47_196 VGND VGND VPWR VPWR sky130_fd_sc_hd__fill_2
XFILLER_90_475 VGND VGND VPWR VPWR sky130_fd_sc_hd__fill_1
X_3970_ array\[13\]\[18\] net547 net536 array\[15\]\[18\] _1890_ VGND VGND VPWR VPWR
+ _1891_ sky130_fd_sc_hd__a221o_1
XFILLER_43_380 VPWR VGND VPWR VGND sky130_ef_sc_hd__decap_12
XFILLER_50_339 VGND VGND VPWR VPWR sky130_fd_sc_hd__fill_1
X_2921_ net1264 net202 _1114_ VGND VGND VPWR VPWR _0090_ sky130_fd_sc_hd__o21a_1
XTAP_TAPCELL_ROW_61_813 VGND VPWR sky130_fd_sc_hd__tapvpwrvgnd_1
XFILLER_62_188 VGND VGND VPWR VPWR sky130_fd_sc_hd__decap_3
XFILLER_31_531 VGND VGND VPWR VPWR sky130_fd_sc_hd__fill_1
XTAP_TAPCELL_ROW_33_537 VGND VPWR sky130_fd_sc_hd__tapvpwrvgnd_1
XFILLER_86_3 VPWR VGND VPWR VGND sky130_ef_sc_hd__decap_12
X_2852_ net753 _0628_ _0857_ VGND VGND VPWR VPWR _1066_ sky130_fd_sc_hd__or3b_1
XPHY_EDGE_ROW_22_Right_22 VGND VGND VPWR VPWR sky130_fd_sc_hd__decap_3
X_2783_ net566 net504 net276 net636 net286 VGND VGND VPWR VPWR _1023_ sky130_fd_sc_hd__a221o_1
X_4522_ clknet_leaf_20_clk _0053_ VGND VGND VPWR VPWR array\[8\]\[15\] sky130_fd_sc_hd__dfxtp_1
Xhold215 array\[2\]\[12\] VGND VGND VPWR VPWR net981 sky130_fd_sc_hd__dlygate4sd3_1
Xhold226 array\[15\]\[10\] VGND VGND VPWR VPWR net992 sky130_fd_sc_hd__dlygate4sd3_1
X_4453_ clknet_leaf_45_clk _0564_ VGND VGND VPWR VPWR array\[4\]\[10\] sky130_fd_sc_hd__dfxtp_1
Xhold204 array\[15\]\[2\] VGND VGND VPWR VPWR net970 sky130_fd_sc_hd__dlygate4sd3_1
X_3404_ net707 net257 VGND VGND VPWR VPWR _1453_ sky130_fd_sc_hd__and2_1
Xhold237 array\[12\]\[19\] VGND VGND VPWR VPWR net1003 sky130_fd_sc_hd__dlygate4sd3_1
Xhold259 array\[4\]\[6\] VGND VGND VPWR VPWR net1025 sky130_fd_sc_hd__dlygate4sd3_1
Xhold248 array\[2\]\[24\] VGND VGND VPWR VPWR net1014 sky130_fd_sc_hd__dlygate4sd3_1
X_4384_ clknet_leaf_27_clk _0495_ VGND VGND VPWR VPWR array\[2\]\[5\] sky130_fd_sc_hd__dfxtp_1
Xfanout706 net35 VGND VGND VPWR VPWR net706 sky130_fd_sc_hd__buf_1
X_3335_ net612 net484 net369 net684 net179 VGND VGND VPWR VPWR _1405_ sky130_fd_sc_hd__a221o_1
Xfanout728 net24 VGND VGND VPWR VPWR net728 sky130_fd_sc_hd__dlymetal6s2s_1
Xfanout739 net740 VGND VGND VPWR VPWR net739 sky130_fd_sc_hd__buf_2
Xfanout717 net718 VGND VGND VPWR VPWR net717 sky130_fd_sc_hd__buf_2
X_3266_ net584 net488 net184 net724 _1356_ VGND VGND VPWR VPWR _1357_ sky130_fd_sc_hd__a221o_1
XPHY_EDGE_ROW_31_Right_31 VGND VGND VPWR VPWR sky130_fd_sc_hd__decap_3
X_2217_ net766 full net2 VGND VGND VPWR VPWR _0624_ sky130_fd_sc_hd__or3b_2
XFILLER_73_409 VGND VGND VPWR VPWR sky130_fd_sc_hd__decap_4
XFILLER_38_141 VGND VGND VPWR VPWR sky130_fd_sc_hd__decap_3
X_3197_ net570 net486 net181 net710 _1310_ VGND VGND VPWR VPWR _1311_ sky130_fd_sc_hd__a221o_1
XTAP_TAPCELL_ROW_49_692 VGND VPWR sky130_fd_sc_hd__tapvpwrvgnd_1
XPHY_EDGE_ROW_40_Right_40 VGND VGND VPWR VPWR sky130_fd_sc_hd__decap_3
XFILLER_30_45 VGND VGND VPWR VPWR sky130_fd_sc_hd__fill_1
XFILLER_89_553 VGND VGND VPWR VPWR sky130_fd_sc_hd__decap_6
XFILLER_39_54 VGND VGND VPWR VPWR sky130_fd_sc_hd__fill_2
XTAP_TAPCELL_ROW_4_240 VGND VPWR sky130_fd_sc_hd__tapvpwrvgnd_1
XFILLER_55_86 VGND VGND VPWR VPWR sky130_fd_sc_hd__fill_2
XFILLER_13_553 VGND VGND VPWR VPWR sky130_fd_sc_hd__decap_6
XTAP_TAPCELL_ROW_30_507 VGND VPWR sky130_fd_sc_hd__tapvpwrvgnd_1
XFILLER_4_251 VGND VGND VPWR VPWR sky130_fd_sc_hd__fill_1
XFILLER_4_295 VPWR VGND VPWR VGND sky130_ef_sc_hd__decap_12
X_3120_ net1034 net164 _1256_ VGND VGND VPWR VPWR _0147_ sky130_fd_sc_hd__o21a_1
XFILLER_67_225 VPWR VGND VPWR VGND sky130_ef_sc_hd__decap_12
XFILLER_67_214 VGND VGND VPWR VPWR sky130_fd_sc_hd__fill_1
X_3051_ net726 net195 _1206_ net381 VGND VGND VPWR VPWR _1207_ sky130_fd_sc_hd__a22o_1
XFILLER_82_206 VGND VGND VPWR VPWR sky130_fd_sc_hd__fill_2
XFILLER_75_291 VGND VGND VPWR VPWR sky130_fd_sc_hd__decap_4
XFILLER_90_250 VGND VGND VPWR VPWR sky130_fd_sc_hd__fill_2
XTAP_TAPCELL_ROW_85_1056 VGND VPWR sky130_fd_sc_hd__tapvpwrvgnd_1
XFILLER_90_261 VGND VGND VPWR VPWR sky130_fd_sc_hd__decap_3
XTAP_TAPCELL_ROW_46_662 VGND VPWR sky130_fd_sc_hd__tapvpwrvgnd_1
XTAP_TAPCELL_ROW_18_386 VGND VPWR sky130_fd_sc_hd__tapvpwrvgnd_1
X_3953_ array\[10\]\[16\] net468 net451 array\[8\]\[16\] VGND VGND VPWR VPWR _1876_
+ sky130_fd_sc_hd__a22o_1
X_3884_ array\[14\]\[10\] net467 net450 array\[12\]\[10\] VGND VGND VPWR VPWR _1813_
+ sky130_fd_sc_hd__a22o_1
X_2904_ net613 net685 net498 VGND VGND VPWR VPWR _1103_ sky130_fd_sc_hd__mux2_1
X_2835_ net589 net502 net275 net663 net285 VGND VGND VPWR VPWR _1056_ sky130_fd_sc_hd__a221o_1
X_2766_ net625 net502 net279 net629 net285 VGND VGND VPWR VPWR _1012_ sky130_fd_sc_hd__a221o_1
X_2697_ net810 _0962_ net294 VGND VGND VPWR VPWR _0018_ sky130_fd_sc_hd__mux2_1
X_4505_ clknet_leaf_20_clk _0036_ VGND VGND VPWR VPWR array\[5\]\[30\] sky130_fd_sc_hd__dfxtp_1
X_4436_ clknet_leaf_41_clk _0547_ VGND VGND VPWR VPWR array\[3\]\[25\] sky130_fd_sc_hd__dfxtp_1
Xfanout514 _0782_ VGND VGND VPWR VPWR net514 sky130_fd_sc_hd__buf_4
Xfanout503 net505 VGND VGND VPWR VPWR net503 sky130_fd_sc_hd__clkbuf_4
X_4367_ clknet_leaf_9_clk _0478_ VGND VGND VPWR VPWR array\[1\]\[20\] sky130_fd_sc_hd__dfxtp_1
Xfanout547 net548 VGND VGND VPWR VPWR net547 sky130_fd_sc_hd__clkbuf_4
Xfanout536 net542 VGND VGND VPWR VPWR net536 sky130_fd_sc_hd__clkbuf_4
Xfanout525 _0626_ VGND VGND VPWR VPWR net525 sky130_fd_sc_hd__buf_2
X_3318_ net624 net483 net368 net696 net178 VGND VGND VPWR VPWR _1394_ sky130_fd_sc_hd__a221o_1
XFILLER_86_545 VPWR VGND VPWR VGND sky130_ef_sc_hd__decap_12
X_4298_ net1179 net219 _2146_ _2147_ VGND VGND VPWR VPWR _0438_ sky130_fd_sc_hd__o22a_1
Xfanout558 _0606_ VGND VGND VPWR VPWR net558 sky130_fd_sc_hd__clkbuf_4
Xfanout569 net97 VGND VGND VPWR VPWR net569 sky130_fd_sc_hd__buf_2
X_3249_ net1113 _1345_ net157 VGND VGND VPWR VPWR _0187_ sky130_fd_sc_hd__mux2_1
XTAP_TAPCELL_ROW_1_210 VGND VPWR sky130_fd_sc_hd__tapvpwrvgnd_1
XFILLER_92_29 VPWR VGND VPWR VGND sky130_ef_sc_hd__decap_12
XFILLER_81_261 VGND VGND VPWR VPWR sky130_fd_sc_hd__fill_2
XFILLER_14_328 VGND VGND VPWR VPWR sky130_fd_sc_hd__fill_1
XFILLER_54_475 VGND VGND VPWR VPWR sky130_fd_sc_hd__fill_1
XFILLER_54_497 VGND VGND VPWR VPWR sky130_fd_sc_hd__fill_1
XFILLER_10_501 VPWR VGND VPWR VGND sky130_ef_sc_hd__decap_12
XFILLER_22_350 VGND VGND VPWR VPWR sky130_fd_sc_hd__decap_4
XFILLER_41_169 VGND VGND VPWR VPWR sky130_fd_sc_hd__fill_2
XFILLER_10_545 VPWR VGND VPWR VGND sky130_ef_sc_hd__decap_12
XFILLER_2_27 VGND VGND VPWR VPWR sky130_fd_sc_hd__fill_1
XFILLER_49_225 VGND VGND VPWR VPWR sky130_fd_sc_hd__fill_1
XFILLER_66_41 VGND VGND VPWR VPWR sky130_fd_sc_hd__decap_6
XTAP_TAPCELL_ROW_43_632 VGND VPWR sky130_fd_sc_hd__tapvpwrvgnd_1
XTAP_TAPCELL_ROW_15_356 VGND VPWR sky130_fd_sc_hd__tapvpwrvgnd_1
XFILLER_13_361 VGND VGND VPWR VPWR sky130_fd_sc_hd__fill_2
XFILLER_20_309 VGND VGND VPWR VPWR sky130_fd_sc_hd__decap_3
X_2620_ net1248 net298 _0908_ _0909_ VGND VGND VPWR VPWR _0574_ sky130_fd_sc_hd__o22a_1
X_2551_ net756 net757 VGND VGND VPWR VPWR _0861_ sky130_fd_sc_hd__nor2_2
Xoutput139 net139 VGND VGND VPWR VPWR out[27] sky130_fd_sc_hd__buf_2
Xoutput128 net128 VGND VGND VPWR VPWR out[17] sky130_fd_sc_hd__buf_2
X_2482_ net586 net306 _0812_ net404 net310 VGND VGND VPWR VPWR _0813_ sky130_fd_sc_hd__a221o_1
Xoutput117 net117 VGND VGND VPWR VPWR data_location[2] sky130_fd_sc_hd__buf_2
X_4221_ net1142 net227 _2096_ VGND VGND VPWR VPWR _0412_ sky130_fd_sc_hd__o21a_1
X_4152_ net602 net431 net340 net676 VGND VGND VPWR VPWR _2051_ sky130_fd_sc_hd__a22o_1
X_3103_ net702 net187 VGND VGND VPWR VPWR _1245_ sky130_fd_sc_hd__and2_1
X_4083_ array\[14\]\[28\] net464 net447 array\[12\]\[28\] VGND VGND VPWR VPWR _1994_
+ sky130_fd_sc_hd__a22o_1
XFILLER_83_526 VPWR VGND VPWR VGND sky130_ef_sc_hd__decap_12
X_3034_ net800 _1195_ net167 VGND VGND VPWR VPWR _0122_ sky130_fd_sc_hd__mux2_1
XFILLER_63_261 VGND VGND VPWR VPWR sky130_fd_sc_hd__fill_1
XFILLER_51_445 VGND VGND VPWR VPWR sky130_fd_sc_hd__decap_3
XFILLER_51_489 VGND VGND VPWR VPWR sky130_fd_sc_hd__fill_2
X_3936_ array\[5\]\[15\] net556 net539 array\[7\]\[15\] _1859_ VGND VGND VPWR VPWR
+ _1860_ sky130_fd_sc_hd__a221o_1
X_3867_ net767 net172 _1797_ VGND VGND VPWR VPWR _0353_ sky130_fd_sc_hd__o21a_1
X_2818_ net741 net279 VGND VGND VPWR VPWR _1045_ sky130_fd_sc_hd__and2_1
X_3798_ net215 _1733_ _1734_ VGND VGND VPWR VPWR _1735_ sky130_fd_sc_hd__or3_1
X_2749_ net645 net575 net391 VGND VGND VPWR VPWR _0997_ sky130_fd_sc_hd__mux2_1
X_4419_ clknet_leaf_27_clk _0530_ VGND VGND VPWR VPWR array\[3\]\[8\] sky130_fd_sc_hd__dfxtp_1
Xfanout322 _0642_ VGND VGND VPWR VPWR net322 sky130_fd_sc_hd__clkbuf_4
Xfanout300 _0866_ VGND VGND VPWR VPWR net300 sky130_fd_sc_hd__clkbuf_4
Xfanout311 _0787_ VGND VGND VPWR VPWR net311 sky130_fd_sc_hd__clkbuf_2
Xfanout355 _1600_ VGND VGND VPWR VPWR net355 sky130_fd_sc_hd__buf_4
Xfanout344 _1643_ VGND VGND VPWR VPWR net344 sky130_fd_sc_hd__buf_4
Xfanout333 _2114_ VGND VGND VPWR VPWR net333 sky130_fd_sc_hd__clkbuf_4
Xfanout366 _1442_ VGND VGND VPWR VPWR net366 sky130_fd_sc_hd__buf_2
Xfanout399 net401 VGND VGND VPWR VPWR net399 sky130_fd_sc_hd__clkbuf_4
Xfanout388 net390 VGND VGND VPWR VPWR net388 sky130_fd_sc_hd__buf_4
Xfanout377 net378 VGND VGND VPWR VPWR net377 sky130_fd_sc_hd__buf_2
XTAP_TAPCELL_ROW_57_779 VGND VPWR sky130_fd_sc_hd__tapvpwrvgnd_1
XFILLER_61_209 VGND VGND VPWR VPWR sky130_fd_sc_hd__decap_3
XTAP_TAPCELL_ROW_40_602 VGND VPWR sky130_fd_sc_hd__tapvpwrvgnd_1
XTAP_TAPCELL_ROW_12_326 VGND VPWR sky130_fd_sc_hd__tapvpwrvgnd_1
Xinput19 value0[20] VGND VGND VPWR VPWR net19 sky130_fd_sc_hd__buf_1
XFILLER_77_73 VGND VGND VPWR VPWR sky130_fd_sc_hd__fill_1
XFILLER_33_401 VGND VGND VPWR VPWR sky130_fd_sc_hd__decap_4
XFILLER_52_209 VGND VGND VPWR VPWR sky130_fd_sc_hd__decap_8
XTAP_TAPCELL_ROW_82_1026 VGND VPWR sky130_fd_sc_hd__tapvpwrvgnd_1
XTAP_TAPCELL_ROW_28_481 VGND VPWR sky130_fd_sc_hd__tapvpwrvgnd_1
XFILLER_60_231 VPWR VGND VPWR VGND sky130_ef_sc_hd__decap_12
XFILLER_60_253 VPWR VGND VPWR VGND sky130_ef_sc_hd__decap_12
X_4770_ clknet_leaf_61_clk _0301_ VGND VGND VPWR VPWR ready_check\[11\] sky130_fd_sc_hd__dfxtp_1
X_3721_ net609 net425 net347 net681 VGND VGND VPWR VPWR _1675_ sky130_fd_sc_hd__a22o_1
X_3652_ net212 _1595_ _1617_ _1627_ VGND VGND VPWR VPWR _0308_ sky130_fd_sc_hd__o31a_1
X_2603_ net749 net401 net508 VGND VGND VPWR VPWR _0898_ sky130_fd_sc_hd__and3_1
X_3583_ net575 net476 net361 net645 net253 VGND VGND VPWR VPWR _1575_ sky130_fd_sc_hd__a221o_1
XTAP_TAPCELL_ROW_93_1133 VGND VPWR sky130_fd_sc_hd__tapvpwrvgnd_1
X_2534_ net1295 net203 _0847_ VGND VGND VPWR VPWR _0550_ sky130_fd_sc_hd__o21a_1
X_2465_ net870 net205 _0801_ VGND VGND VPWR VPWR _0527_ sky130_fd_sc_hd__o21a_1
X_2396_ net605 net679 net520 VGND VGND VPWR VPWR _0752_ sky130_fd_sc_hd__mux2_1
X_4204_ net742 net233 VGND VGND VPWR VPWR _2085_ sky130_fd_sc_hd__and2_1
X_4135_ _1581_ _1582_ net559 VGND VGND VPWR VPWR _2038_ sky130_fd_sc_hd__o21ai_1
X_4066_ array\[9\]\[26\] net548 net535 array\[11\]\[26\] _1978_ VGND VGND VPWR VPWR
+ _1979_ sky130_fd_sc_hd__a221o_1
XFILLER_83_389 VGND VGND VPWR VPWR sky130_fd_sc_hd__decap_3
XFILLER_71_529 VGND VGND VPWR VPWR sky130_fd_sc_hd__decap_4
X_3017_ net686 net614 net496 VGND VGND VPWR VPWR _1184_ sky130_fd_sc_hd__mux2_1
XFILLER_51_220 VGND VGND VPWR VPWR sky130_fd_sc_hd__decap_4
XTAP_TAPCELL_ROW_54_749 VGND VPWR sky130_fd_sc_hd__tapvpwrvgnd_1
XFILLER_24_489 VGND VGND VPWR VPWR sky130_fd_sc_hd__fill_2
X_3919_ array\[10\]\[13\] net459 net442 array\[8\]\[13\] VGND VGND VPWR VPWR _1845_
+ sky130_fd_sc_hd__a22o_1
X_4899_ clknet_leaf_45_clk _0430_ VGND VGND VPWR VPWR array\[6\]\[10\] sky130_fd_sc_hd__dfxtp_1
XFILLER_22_46 VPWR VGND VPWR VGND sky130_ef_sc_hd__decap_12
XFILLER_3_305 VPWR VGND VPWR VGND sky130_ef_sc_hd__decap_12
XFILLER_3_349 VPWR VGND VPWR VGND sky130_ef_sc_hd__decap_12
Xfanout174 net176 VGND VGND VPWR VPWR net174 sky130_fd_sc_hd__buf_4
Xfanout163 net164 VGND VGND VPWR VPWR net163 sky130_fd_sc_hd__clkbuf_4
Xfanout196 net197 VGND VGND VPWR VPWR net196 sky130_fd_sc_hd__clkbuf_4
Xfanout185 net188 VGND VGND VPWR VPWR net185 sky130_fd_sc_hd__buf_4
XFILLER_86_194 VGND VGND VPWR VPWR sky130_fd_sc_hd__fill_2
XFILLER_15_445 VGND VGND VPWR VPWR sky130_fd_sc_hd__decap_3
XFILLER_15_434 VGND VGND VPWR VPWR sky130_fd_sc_hd__decap_3
XPHY_EDGE_ROW_69_Right_69 VGND VGND VPWR VPWR sky130_fd_sc_hd__decap_3
XFILLER_15_456 VGND VGND VPWR VPWR sky130_fd_sc_hd__decap_4
XTAP_TAPCELL_ROW_25_451 VGND VPWR sky130_fd_sc_hd__tapvpwrvgnd_1
XFILLER_42_231 VGND VGND VPWR VPWR sky130_fd_sc_hd__decap_8
XFILLER_42_253 VGND VGND VPWR VPWR sky130_fd_sc_hd__decap_4
XFILLER_8_15 VGND VGND VPWR VPWR sky130_fd_sc_hd__decap_6
XFILLER_6_176 VGND VGND VPWR VPWR sky130_fd_sc_hd__decap_3
XPHY_EDGE_ROW_78_Right_78 VGND VGND VPWR VPWR sky130_fd_sc_hd__decap_3
XFILLER_40_7 VGND VGND VPWR VPWR sky130_fd_sc_hd__fill_1
XFILLER_88_83 VGND VGND VPWR VPWR sky130_fd_sc_hd__fill_1
XFILLER_2_360 VGND VGND VPWR VPWR sky130_fd_sc_hd__decap_4
XFILLER_2_371 VGND VGND VPWR VPWR sky130_fd_sc_hd__fill_1
X_2250_ net709 net319 _0651_ net410 net327 VGND VGND VPWR VPWR _0652_ sky130_fd_sc_hd__a221o_1
XFILLER_84_109 VPWR VGND VPWR VGND sky130_ef_sc_hd__decap_12
XFILLER_77_150 VGND VGND VPWR VPWR sky130_fd_sc_hd__fill_2
X_2181_ _0002_ VGND VGND VPWR VPWR _0592_ sky130_fd_sc_hd__inv_2
XFILLER_80_315 VGND VGND VPWR VPWR sky130_fd_sc_hd__decap_6
XFILLER_18_261 VGND VGND VPWR VPWR sky130_fd_sc_hd__decap_8
XPHY_EDGE_ROW_87_Right_87 VGND VGND VPWR VPWR sky130_fd_sc_hd__decap_3
XTAP_TAPCELL_ROW_51_719 VGND VPWR sky130_fd_sc_hd__tapvpwrvgnd_1
X_4822_ clknet_leaf_33_clk _0353_ VGND VGND VPWR VPWR net150 sky130_fd_sc_hd__dfxtp_1
X_4753_ clknet_leaf_57_clk _0284_ VGND VGND VPWR VPWR array\[10\]\[22\] sky130_fd_sc_hd__dfxtp_1
X_3704_ net1261 net238 _1663_ _1664_ VGND VGND VPWR VPWR _0323_ sky130_fd_sc_hd__o22a_1
X_4684_ clknet_leaf_15_clk _0215_ VGND VGND VPWR VPWR array\[12\]\[17\] sky130_fd_sc_hd__dfxtp_1
X_3635_ _1140_ _1613_ VGND VGND VPWR VPWR _1614_ sky130_fd_sc_hd__nand2_1
X_3566_ net872 net251 _1562_ _1563_ VGND VGND VPWR VPWR _0286_ sky130_fd_sc_hd__o22a_1
XFILLER_88_404 VPWR VGND VPWR VGND sky130_ef_sc_hd__decap_12
X_3497_ net601 net473 net359 net675 net254 VGND VGND VPWR VPWR _1518_ sky130_fd_sc_hd__a221o_1
X_2517_ net667 net593 net513 VGND VGND VPWR VPWR _0836_ sky130_fd_sc_hd__mux2_1
X_2448_ net697 net625 net514 VGND VGND VPWR VPWR _0790_ sky130_fd_sc_hd__mux2_1
XFILLER_75_109 VGND VGND VPWR VPWR sky130_fd_sc_hd__decap_3
X_2379_ net764 net318 _0740_ net407 net312 VGND VGND VPWR VPWR _0741_ sky130_fd_sc_hd__a221o_1
XFILLER_29_537 VPWR VGND VPWR VGND sky130_ef_sc_hd__decap_12
X_4118_ array\[10\]\[31\] net467 net450 array\[8\]\[31\] VGND VGND VPWR VPWR _2026_
+ sky130_fd_sc_hd__a22o_1
XFILLER_83_164 VGND VGND VPWR VPWR sky130_fd_sc_hd__decap_4
XFILLER_71_315 VGND VGND VPWR VPWR sky130_fd_sc_hd__decap_6
XTAP_TAPCELL_ROW_67_874 VGND VPWR sky130_fd_sc_hd__tapvpwrvgnd_1
X_4049_ array\[13\]\[25\] net553 net531 array\[15\]\[25\] _1962_ VGND VGND VPWR VPWR
+ _1963_ sky130_fd_sc_hd__a221o_1
XTAP_TAPCELL_ROW_39_598 VGND VPWR sky130_fd_sc_hd__tapvpwrvgnd_1
XTAP_TAPCELL_ROW_22_421 VGND VPWR sky130_fd_sc_hd__tapvpwrvgnd_1
XPHY_EDGE_ROW_49_Left_144 VGND VGND VPWR VPWR sky130_fd_sc_hd__decap_3
XPHY_EDGE_ROW_58_Left_153 VGND VGND VPWR VPWR sky130_fd_sc_hd__decap_3
Xhold8 array\[13\]\[19\] VGND VGND VPWR VPWR net774 sky130_fd_sc_hd__dlygate4sd3_1
XFILLER_47_334 VGND VGND VPWR VPWR sky130_fd_sc_hd__fill_2
XFILLER_47_356 VGND VGND VPWR VPWR sky130_fd_sc_hd__decap_4
XFILLER_15_253 VGND VGND VPWR VPWR sky130_fd_sc_hd__decap_3
XFILLER_15_286 VGND VGND VPWR VPWR sky130_fd_sc_hd__fill_1
XPHY_EDGE_ROW_67_Left_162 VGND VGND VPWR VPWR sky130_fd_sc_hd__decap_3
XFILLER_30_278 VGND VGND VPWR VPWR sky130_fd_sc_hd__decap_3
Xhold408 array\[12\]\[28\] VGND VGND VPWR VPWR net1174 sky130_fd_sc_hd__dlygate4sd3_1
XFILLER_7_485 VPWR VGND VPWR VGND sky130_ef_sc_hd__decap_12
X_3420_ net607 net257 _1463_ net265 VGND VGND VPWR VPWR _1464_ sky130_fd_sc_hd__a211o_1
Xhold419 array\[1\]\[6\] VGND VGND VPWR VPWR net1185 sky130_fd_sc_hd__dlygate4sd3_1
XTAP_TAPCELL_ROW_90_1103 VGND VPWR sky130_fd_sc_hd__tapvpwrvgnd_1
X_3351_ net733 net173 VGND VGND VPWR VPWR _1415_ sky130_fd_sc_hd__and2_1
XPHY_EDGE_ROW_76_Left_171 VGND VGND VPWR VPWR sky130_fd_sc_hd__decap_3
X_2302_ net1225 net324 _0686_ VGND VGND VPWR VPWR _0479_ sky130_fd_sc_hd__o21a_1
X_3282_ net753 _0854_ _0857_ VGND VGND VPWR VPWR _1368_ sky130_fd_sc_hd__and3_4
XFILLER_85_429 VGND VGND VPWR VPWR sky130_fd_sc_hd__decap_8
X_2233_ _0637_ _0638_ VGND VGND VPWR VPWR _0639_ sky130_fd_sc_hd__nand2_1
XFILLER_57_109 VGND VGND VPWR VPWR sky130_fd_sc_hd__decap_3
XTAP_TAPCELL_ROW_88_1087 VGND VPWR sky130_fd_sc_hd__tapvpwrvgnd_1
XTAP_TAPCELL_ROW_64_844 VGND VPWR sky130_fd_sc_hd__tapvpwrvgnd_1
XFILLER_0_71 VGND VGND VPWR VPWR sky130_fd_sc_hd__fill_2
XFILLER_53_337 VGND VGND VPWR VPWR sky130_fd_sc_hd__decap_4
XTAP_TAPCELL_ROW_36_568 VGND VPWR sky130_fd_sc_hd__tapvpwrvgnd_1
XPHY_EDGE_ROW_85_Left_180 VGND VGND VPWR VPWR sky130_fd_sc_hd__decap_3
XFILLER_21_223 VGND VGND VPWR VPWR sky130_fd_sc_hd__fill_1
X_4805_ clknet_leaf_35_clk _0336_ VGND VGND VPWR VPWR array\[9\]\[23\] sky130_fd_sc_hd__dfxtp_1
X_2997_ net702 net195 _1170_ net382 VGND VGND VPWR VPWR _1171_ sky130_fd_sc_hd__a22o_1
X_4736_ clknet_leaf_22_clk _0267_ VGND VGND VPWR VPWR array\[10\]\[5\] sky130_fd_sc_hd__dfxtp_1
X_4667_ clknet_leaf_59_clk _0198_ VGND VGND VPWR VPWR array\[12\]\[0\] sky130_fd_sc_hd__dfxtp_1
X_3618_ head\[3\] _0585_ VGND VGND VPWR VPWR _1601_ sky130_fd_sc_hd__nand2_1
X_4598_ clknet_leaf_29_clk _0129_ VGND VGND VPWR VPWR array\[15\]\[27\] sky130_fd_sc_hd__dfxtp_1
X_3549_ net741 net245 VGND VGND VPWR VPWR _1552_ sky130_fd_sc_hd__and2_1
XFILLER_76_429 VGND VGND VPWR VPWR sky130_fd_sc_hd__fill_1
XFILLER_48_109 VGND VGND VPWR VPWR sky130_fd_sc_hd__decap_4
XFILLER_29_345 VGND VGND VPWR VPWR sky130_fd_sc_hd__decap_6
XFILLER_56_131 VGND VGND VPWR VPWR sky130_fd_sc_hd__fill_1
XFILLER_84_473 VGND VGND VPWR VPWR sky130_fd_sc_hd__decap_3
XFILLER_56_197 VPWR VGND VPWR VGND sky130_ef_sc_hd__decap_12
XFILLER_5_27 VGND VGND VPWR VPWR sky130_fd_sc_hd__decap_4
XFILLER_4_433 VPWR VGND VPWR VGND sky130_ef_sc_hd__decap_12
XFILLER_4_477 VPWR VGND VPWR VGND sky130_ef_sc_hd__decap_12
XTAP_TAPCELL_ROW_7_271 VGND VPWR sky130_fd_sc_hd__tapvpwrvgnd_1
XFILLER_85_51 VGND VGND VPWR VPWR sky130_fd_sc_hd__decap_4
XFILLER_90_421 VPWR VGND VPWR VGND sky130_ef_sc_hd__decap_12
XFILLER_35_337 VGND VGND VPWR VPWR sky130_fd_sc_hd__decap_3
X_2920_ net737 net271 _1113_ net384 _1072_ VGND VGND VPWR VPWR _1114_ sky130_fd_sc_hd__a221o_1
XTAP_TAPCELL_ROW_61_814 VGND VPWR sky130_fd_sc_hd__tapvpwrvgnd_1
XTAP_TAPCELL_ROW_33_538 VGND VPWR sky130_fd_sc_hd__tapvpwrvgnd_1
X_2851_ net1273 net288 net279 net713 _1065_ VGND VGND VPWR VPWR _0069_ sky130_fd_sc_hd__a221o_1
X_2782_ net706 net280 VGND VGND VPWR VPWR _1022_ sky130_fd_sc_hd__and2_1
X_4521_ clknet_leaf_4_clk _0052_ VGND VGND VPWR VPWR array\[8\]\[14\] sky130_fd_sc_hd__dfxtp_1
Xhold205 array\[11\]\[22\] VGND VGND VPWR VPWR net971 sky130_fd_sc_hd__dlygate4sd3_1
X_4452_ clknet_leaf_53_clk _0563_ VGND VGND VPWR VPWR array\[4\]\[9\] sky130_fd_sc_hd__dfxtp_1
Xhold216 array\[15\]\[15\] VGND VGND VPWR VPWR net982 sky130_fd_sc_hd__dlygate4sd3_1
Xhold238 array\[9\]\[5\] VGND VGND VPWR VPWR net1004 sky130_fd_sc_hd__dlygate4sd3_1
Xhold227 array\[12\]\[25\] VGND VGND VPWR VPWR net993 sky130_fd_sc_hd__dlygate4sd3_1
X_3403_ net1279 net261 _1452_ VGND VGND VPWR VPWR _0234_ sky130_fd_sc_hd__o21a_1
Xhold249 net125 VGND VGND VPWR VPWR net1015 sky130_fd_sc_hd__dlygate4sd3_1
X_4383_ clknet_leaf_40_clk _0494_ VGND VGND VPWR VPWR array\[2\]\[4\] sky130_fd_sc_hd__dfxtp_1
X_3334_ net748 net175 VGND VGND VPWR VPWR _1404_ sky130_fd_sc_hd__and2_1
Xfanout707 net34 VGND VGND VPWR VPWR net707 sky130_fd_sc_hd__buf_2
Xfanout729 net23 VGND VGND VPWR VPWR net729 sky130_fd_sc_hd__buf_2
Xfanout718 net29 VGND VGND VPWR VPWR net718 sky130_fd_sc_hd__clkbuf_2
X_3265_ net660 net374 VGND VGND VPWR VPWR _1356_ sky130_fd_sc_hd__and2_1
XFILLER_85_248 VGND VGND VPWR VPWR sky130_fd_sc_hd__decap_3
X_2216_ tail\[3\] _0615_ _0622_ VGND VGND VPWR VPWR _0623_ sky130_fd_sc_hd__a21oi_1
X_3196_ net640 net371 VGND VGND VPWR VPWR _1310_ sky130_fd_sc_hd__and2_1
XFILLER_38_197 VGND VGND VPWR VPWR sky130_fd_sc_hd__decap_4
XTAP_TAPCELL_ROW_49_693 VGND VPWR sky130_fd_sc_hd__tapvpwrvgnd_1
XFILLER_81_465 VGND VGND VPWR VPWR sky130_fd_sc_hd__decap_4
XFILLER_14_47 VGND VGND VPWR VPWR sky130_fd_sc_hd__fill_2
X_4719_ clknet_leaf_5_clk _0250_ VGND VGND VPWR VPWR array\[11\]\[20\] sky130_fd_sc_hd__dfxtp_1
XFILLER_1_447 VGND VGND VPWR VPWR sky130_fd_sc_hd__fill_1
XTAP_TAPCELL_ROW_4_241 VGND VPWR sky130_fd_sc_hd__tapvpwrvgnd_1
XFILLER_91_218 VGND VGND VPWR VPWR sky130_fd_sc_hd__decap_3
XFILLER_17_304 VGND VGND VPWR VPWR sky130_fd_sc_hd__fill_1
XFILLER_57_440 VGND VGND VPWR VPWR sky130_fd_sc_hd__decap_8
XFILLER_44_101 VGND VGND VPWR VPWR sky130_fd_sc_hd__decap_3
XFILLER_55_54 VGND VGND VPWR VPWR sky130_fd_sc_hd__fill_2
XFILLER_72_498 VGND VGND VPWR VPWR sky130_fd_sc_hd__decap_8
XFILLER_9_503 VGND VGND VPWR VPWR sky130_fd_sc_hd__fill_1
XTAP_TAPCELL_ROW_30_508 VGND VPWR sky130_fd_sc_hd__tapvpwrvgnd_1
XFILLER_71_97 VGND VGND VPWR VPWR sky130_fd_sc_hd__fill_1
X_3050_ net662 net588 net495 VGND VGND VPWR VPWR _1206_ sky130_fd_sc_hd__mux2_1
XFILLER_67_237 VGND VGND VPWR VPWR sky130_fd_sc_hd__decap_4
XTAP_TAPCELL_ROW_85_1057 VGND VPWR sky130_fd_sc_hd__tapvpwrvgnd_1
XTAP_TAPCELL_ROW_46_663 VGND VPWR sky130_fd_sc_hd__tapvpwrvgnd_1
X_3952_ array\[5\]\[16\] net555 net540 array\[7\]\[16\] _1874_ VGND VGND VPWR VPWR
+ _1875_ sky130_fd_sc_hd__a221o_1
XTAP_TAPCELL_ROW_18_387 VGND VPWR sky130_fd_sc_hd__tapvpwrvgnd_1
X_3883_ array\[5\]\[10\] net552 net530 array\[7\]\[10\] _1811_ VGND VGND VPWR VPWR
+ _1812_ sky130_fd_sc_hd__a221o_1
X_2903_ net1131 net199 _1102_ VGND VGND VPWR VPWR _0084_ sky130_fd_sc_hd__o21a_1
X_2834_ net727 net279 VGND VGND VPWR VPWR _1055_ sky130_fd_sc_hd__and2_1
X_2765_ net697 net275 VGND VGND VPWR VPWR _1011_ sky130_fd_sc_hd__and2_1
X_4504_ clknet_leaf_54_clk _0035_ VGND VGND VPWR VPWR array\[5\]\[29\] sky130_fd_sc_hd__dfxtp_1
X_2696_ net764 net290 _0961_ net390 VGND VGND VPWR VPWR _0962_ sky130_fd_sc_hd__a22o_1
XFILLER_6_70 VPWR VGND VPWR VGND sky130_ef_sc_hd__decap_12
XFILLER_6_92 VGND VGND VPWR VPWR sky130_fd_sc_hd__decap_3
X_4435_ clknet_leaf_37_clk _0546_ VGND VGND VPWR VPWR array\[3\]\[24\] sky130_fd_sc_hd__dfxtp_1
X_4366_ clknet_leaf_56_clk _0477_ VGND VGND VPWR VPWR array\[1\]\[19\] sky130_fd_sc_hd__dfxtp_1
Xfanout504 net505 VGND VGND VPWR VPWR net504 sky130_fd_sc_hd__clkbuf_4
Xfanout515 _0782_ VGND VGND VPWR VPWR net515 sky130_fd_sc_hd__buf_4
XFILLER_86_502 VPWR VGND VPWR VGND sky130_ef_sc_hd__decap_12
Xfanout537 net542 VGND VGND VPWR VPWR net537 sky130_fd_sc_hd__clkbuf_2
Xfanout526 net528 VGND VGND VPWR VPWR net526 sky130_fd_sc_hd__clkbuf_4
X_3317_ net608 net174 VGND VGND VPWR VPWR _1393_ sky130_fd_sc_hd__and2_1
Xfanout548 net549 VGND VGND VPWR VPWR net548 sky130_fd_sc_hd__clkbuf_4
XFILLER_86_557 VGND VGND VPWR VPWR sky130_fd_sc_hd__decap_4
X_4297_ net605 net428 net332 net679 net222 VGND VGND VPWR VPWR _2147_ sky130_fd_sc_hd__a221o_1
Xfanout559 head\[2\] VGND VGND VPWR VPWR net559 sky130_fd_sc_hd__clkbuf_4
X_3248_ net597 net485 net181 net735 _1344_ VGND VGND VPWR VPWR _1345_ sky130_fd_sc_hd__a221o_1
XTAP_TAPCELL_ROW_1_211 VGND VPWR sky130_fd_sc_hd__tapvpwrvgnd_1
X_3179_ _0931_ _1150_ net485 VGND VGND VPWR VPWR _1297_ sky130_fd_sc_hd__a21oi_1
XFILLER_39_484 VPWR VGND VPWR VGND sky130_ef_sc_hd__decap_12
XFILLER_25_13 VPWR VGND VPWR VGND sky130_ef_sc_hd__decap_12
XFILLER_26_156 VGND VGND VPWR VPWR sky130_fd_sc_hd__decap_3
XFILLER_22_362 VGND VGND VPWR VPWR sky130_fd_sc_hd__fill_2
XFILLER_10_513 VPWR VGND VPWR VGND sky130_ef_sc_hd__decap_12
XFILLER_10_557 VGND VGND VPWR VPWR sky130_fd_sc_hd__decap_4
XFILLER_9_3 VGND VGND VPWR VPWR sky130_fd_sc_hd__decap_4
XFILLER_89_373 VGND VGND VPWR VPWR sky130_fd_sc_hd__fill_2
XFILLER_49_215 VGND VGND VPWR VPWR sky130_fd_sc_hd__fill_1
XFILLER_64_229 VGND VGND VPWR VPWR sky130_fd_sc_hd__decap_8
XFILLER_82_41 VPWR VGND VPWR VGND sky130_ef_sc_hd__decap_12
XFILLER_45_476 VPWR VGND VPWR VGND sky130_ef_sc_hd__decap_12
XFILLER_72_284 VGND VGND VPWR VPWR sky130_fd_sc_hd__fill_1
XTAP_TAPCELL_ROW_43_633 VGND VPWR sky130_fd_sc_hd__tapvpwrvgnd_1
XFILLER_82_85 VPWR VGND VPWR VGND sky130_ef_sc_hd__decap_12
XTAP_TAPCELL_ROW_15_357 VGND VPWR sky130_fd_sc_hd__tapvpwrvgnd_1
X_2550_ _0590_ _0859_ VGND VGND VPWR VPWR _0860_ sky130_fd_sc_hd__and2_2
Xoutput129 net129 VGND VGND VPWR VPWR out[18] sky130_fd_sc_hd__buf_2
X_2481_ net694 net622 net515 VGND VGND VPWR VPWR _0812_ sky130_fd_sc_hd__mux2_1
XFILLER_5_561 VGND VGND VPWR VPWR sky130_fd_sc_hd__fill_1
Xoutput118 net118 VGND VGND VPWR VPWR data_location[3] sky130_fd_sc_hd__buf_2
X_4220_ net730 net236 net232 _2095_ VGND VGND VPWR VPWR _2096_ sky130_fd_sc_hd__a211o_1
X_4151_ net1190 net225 _2050_ _2046_ VGND VGND VPWR VPWR _0388_ sky130_fd_sc_hd__o22a_1
X_3102_ net1067 net161 _1244_ VGND VGND VPWR VPWR _0141_ sky130_fd_sc_hd__o21a_1
X_4082_ array\[5\]\[28\] net551 net531 array\[7\]\[28\] _1992_ VGND VGND VPWR VPWR
+ _1993_ sky130_fd_sc_hd__a221o_1
XFILLER_83_538 VPWR VGND VPWR VGND sky130_ef_sc_hd__decap_12
X_3033_ net737 net195 _1194_ net381 VGND VGND VPWR VPWR _1195_ sky130_fd_sc_hd__a22o_1
XFILLER_23_159 VGND VGND VPWR VPWR sky130_fd_sc_hd__fill_1
X_3935_ array\[6\]\[15\] net470 net453 array\[4\]\[15\] VGND VGND VPWR VPWR _1859_
+ sky130_fd_sc_hd__a22o_1
X_3866_ net216 _1795_ _1796_ VGND VGND VPWR VPWR _1797_ sky130_fd_sc_hd__or3_1
XPHY_EDGE_ROW_12_Left_107 VGND VGND VPWR VPWR sky130_fd_sc_hd__decap_3
XFILLER_31_181 VGND VGND VPWR VPWR sky130_fd_sc_hd__decap_3
X_2817_ net1116 net283 _1043_ _1044_ VGND VGND VPWR VPWR _0056_ sky130_fd_sc_hd__o22a_1
X_3797_ net357 _1728_ _1732_ net417 VGND VGND VPWR VPWR _1734_ sky130_fd_sc_hd__a22o_1
XFILLER_11_48 VGND VGND VPWR VPWR sky130_fd_sc_hd__decap_8
X_2748_ net846 _0996_ net295 VGND VGND VPWR VPWR _0035_ sky130_fd_sc_hd__mux2_1
X_4418_ clknet_leaf_57_clk _0529_ VGND VGND VPWR VPWR array\[3\]\[7\] sky130_fd_sc_hd__dfxtp_1
X_2679_ net782 _0950_ net293 VGND VGND VPWR VPWR _0012_ sky130_fd_sc_hd__mux2_1
Xfanout323 net324 VGND VGND VPWR VPWR net323 sky130_fd_sc_hd__clkbuf_4
Xfanout312 _0715_ VGND VGND VPWR VPWR net312 sky130_fd_sc_hd__buf_4
Xfanout301 _0866_ VGND VGND VPWR VPWR net301 sky130_fd_sc_hd__buf_2
Xfanout334 _2114_ VGND VGND VPWR VPWR net334 sky130_fd_sc_hd__clkbuf_2
Xfanout356 _1600_ VGND VGND VPWR VPWR net356 sky130_fd_sc_hd__clkbuf_2
XPHY_EDGE_ROW_21_Left_116 VGND VGND VPWR VPWR sky130_fd_sc_hd__decap_3
X_4349_ clknet_leaf_38_clk _0460_ VGND VGND VPWR VPWR array\[1\]\[2\] sky130_fd_sc_hd__dfxtp_1
Xfanout345 _1643_ VGND VGND VPWR VPWR net345 sky130_fd_sc_hd__clkbuf_2
XFILLER_86_365 VGND VGND VPWR VPWR sky130_fd_sc_hd__fill_1
Xfanout389 net390 VGND VGND VPWR VPWR net389 sky130_fd_sc_hd__buf_4
Xfanout367 net370 VGND VGND VPWR VPWR net367 sky130_fd_sc_hd__buf_4
Xfanout378 _1228_ VGND VGND VPWR VPWR net378 sky130_fd_sc_hd__clkbuf_8
XFILLER_54_273 VGND VGND VPWR VPWR sky130_fd_sc_hd__fill_2
XFILLER_42_457 VGND VGND VPWR VPWR sky130_fd_sc_hd__decap_3
XFILLER_52_22 VGND VGND VPWR VPWR sky130_fd_sc_hd__fill_1
XTAP_TAPCELL_ROW_12_327 VGND VPWR sky130_fd_sc_hd__tapvpwrvgnd_1
XPHY_EDGE_ROW_30_Left_125 VGND VGND VPWR VPWR sky130_fd_sc_hd__decap_3
XTAP_TAPCELL_ROW_40_603 VGND VPWR sky130_fd_sc_hd__tapvpwrvgnd_1
XFILLER_52_66 VGND VGND VPWR VPWR sky130_fd_sc_hd__fill_2
XFILLER_6_347 VGND VGND VPWR VPWR sky130_fd_sc_hd__fill_1
XFILLER_2_531 VGND VGND VPWR VPWR sky130_fd_sc_hd__fill_1
XFILLER_77_30 VGND VGND VPWR VPWR sky130_fd_sc_hd__decap_8
XFILLER_77_96 VGND VGND VPWR VPWR sky130_fd_sc_hd__fill_1
XFILLER_65_505 VGND VGND VPWR VPWR sky130_fd_sc_hd__decap_3
XFILLER_93_51 VGND VGND VPWR VPWR sky130_fd_sc_hd__decap_4
XFILLER_80_519 VPWR VGND VPWR VGND sky130_ef_sc_hd__decap_12
XTAP_TAPCELL_ROW_82_1027 VGND VPWR sky130_fd_sc_hd__tapvpwrvgnd_1
XTAP_TAPCELL_ROW_28_482 VGND VPWR sky130_fd_sc_hd__tapvpwrvgnd_1
XFILLER_33_446 VGND VGND VPWR VPWR sky130_fd_sc_hd__fill_2
XFILLER_60_221 VGND VGND VPWR VPWR sky130_fd_sc_hd__fill_2
XFILLER_60_243 VGND VGND VPWR VPWR sky130_fd_sc_hd__fill_1
XFILLER_60_265 VGND VGND VPWR VPWR sky130_fd_sc_hd__decap_6
XFILLER_20_118 VGND VGND VPWR VPWR sky130_fd_sc_hd__decap_3
X_3720_ net1287 net244 _1641_ net747 _1674_ VGND VGND VPWR VPWR _0329_ sky130_fd_sc_hd__a221o_1
Xclkbuf_leaf_40_clk clknet_3_3__leaf_clk VGND VGND VPWR VPWR clknet_leaf_40_clk sky130_fd_sc_hd__clkbuf_8
X_3651_ net564 ready_check\[4\] _1626_ _0865_ VGND VGND VPWR VPWR _1627_ sky130_fd_sc_hd__a31o_1
X_2602_ net1256 net297 _0896_ _0897_ VGND VGND VPWR VPWR _0568_ sky130_fd_sc_hd__o22a_1
X_3582_ net715 net247 VGND VGND VPWR VPWR _1574_ sky130_fd_sc_hd__and2_1
X_2533_ net722 net304 _0846_ net402 net308 VGND VGND VPWR VPWR _0847_ sky130_fd_sc_hd__a221o_1
XTAP_TAPCELL_ROW_93_1134 VGND VPWR sky130_fd_sc_hd__tapvpwrvgnd_1
X_2464_ net708 net306 _0800_ net405 net310 VGND VGND VPWR VPWR _0801_ sky130_fd_sc_hd__a221o_1
X_4203_ net1199 net228 _2084_ VGND VGND VPWR VPWR _0406_ sky130_fd_sc_hd__o21a_1
X_2395_ net947 net209 _0751_ VGND VGND VPWR VPWR _0507_ sky130_fd_sc_hd__o21a_1
XFILLER_68_321 VPWR VGND VPWR VGND sky130_ef_sc_hd__decap_12
X_4134_ net559 _1581_ _1582_ VGND VGND VPWR VPWR _2037_ sky130_fd_sc_hd__or3_1
XFILLER_3_71 VGND VGND VPWR VPWR sky130_fd_sc_hd__decap_4
XFILLER_68_376 VGND VGND VPWR VPWR sky130_fd_sc_hd__fill_1
X_4065_ array\[10\]\[26\] net461 net444 array\[8\]\[26\] VGND VGND VPWR VPWR _1978_
+ sky130_fd_sc_hd__a22o_1
XFILLER_36_251 VGND VGND VPWR VPWR sky130_fd_sc_hd__fill_1
X_3016_ net1093 _1183_ net165 VGND VGND VPWR VPWR _0116_ sky130_fd_sc_hd__mux2_1
Xclkbuf_leaf_31_clk clknet_3_7__leaf_clk VGND VGND VPWR VPWR clknet_leaf_31_clk sky130_fd_sc_hd__clkbuf_8
X_3918_ array\[13\]\[13\] net549 net536 array\[15\]\[13\] _1843_ VGND VGND VPWR VPWR
+ _1844_ sky130_fd_sc_hd__a221o_1
XFILLER_22_25 VGND VGND VPWR VPWR sky130_fd_sc_hd__decap_3
X_4898_ clknet_leaf_40_clk _0429_ VGND VGND VPWR VPWR array\[6\]\[9\] sky130_fd_sc_hd__dfxtp_1
XFILLER_22_58 VGND VGND VPWR VPWR sky130_fd_sc_hd__decap_8
X_3849_ array\[1\]\[7\] net543 net528 array\[3\]\[7\] _1780_ VGND VGND VPWR VPWR _1781_
+ sky130_fd_sc_hd__a221o_1
XFILLER_3_317 VGND VGND VPWR VPWR sky130_fd_sc_hd__decap_4
Xfanout153 net156 VGND VGND VPWR VPWR net153 sky130_fd_sc_hd__buf_4
Xfanout164 _1226_ VGND VGND VPWR VPWR net164 sky130_fd_sc_hd__clkbuf_8
XFILLER_59_354 VGND VGND VPWR VPWR sky130_fd_sc_hd__fill_1
Xfanout186 net188 VGND VGND VPWR VPWR net186 sky130_fd_sc_hd__buf_4
XFILLER_19_218 VGND VGND VPWR VPWR sky130_fd_sc_hd__decap_6
Xfanout175 net176 VGND VGND VPWR VPWR net175 sky130_fd_sc_hd__buf_2
XFILLER_47_77 VGND VGND VPWR VPWR sky130_fd_sc_hd__fill_1
XTAP_TAPCELL_ROW_25_452 VGND VPWR sky130_fd_sc_hd__tapvpwrvgnd_1
XFILLER_30_438 VGND VGND VPWR VPWR sky130_fd_sc_hd__decap_3
Xclkbuf_leaf_22_clk clknet_3_7__leaf_clk VGND VGND VPWR VPWR clknet_leaf_22_clk sky130_fd_sc_hd__clkbuf_8
XFILLER_23_490 VGND VGND VPWR VPWR sky130_fd_sc_hd__fill_1
XFILLER_30_449 VPWR VGND VPWR VGND sky130_ef_sc_hd__decap_12
X_2180_ net105 VGND VGND VPWR VPWR _0591_ sky130_fd_sc_hd__inv_2
XFILLER_26_6 VPWR VGND VPWR VGND sky130_ef_sc_hd__decap_12
XFILLER_92_121 VGND VGND VPWR VPWR sky130_fd_sc_hd__decap_8
XFILLER_92_176 VGND VGND VPWR VPWR sky130_fd_sc_hd__fill_2
X_4821_ clknet_leaf_59_clk _0352_ VGND VGND VPWR VPWR net149 sky130_fd_sc_hd__dfxtp_1
Xclkbuf_leaf_13_clk clknet_3_5__leaf_clk VGND VGND VPWR VPWR clknet_leaf_13_clk sky130_fd_sc_hd__clkbuf_8
XFILLER_21_449 VGND VGND VPWR VPWR sky130_fd_sc_hd__decap_3
X_4752_ clknet_leaf_2_clk _0283_ VGND VGND VPWR VPWR array\[10\]\[21\] sky130_fd_sc_hd__dfxtp_1
X_4683_ clknet_leaf_26_clk _0214_ VGND VGND VPWR VPWR array\[12\]\[16\] sky130_fd_sc_hd__dfxtp_1
X_3703_ net623 net425 net346 net695 net243 VGND VGND VPWR VPWR _1664_ sky130_fd_sc_hd__a221o_1
X_3634_ _1143_ _1142_ VGND VGND VPWR VPWR _1613_ sky130_fd_sc_hd__and2b_1
X_3565_ net591 net474 net361 net665 _1511_ VGND VGND VPWR VPWR _1563_ sky130_fd_sc_hd__a221o_1
XFILLER_88_416 VGND VGND VPWR VPWR sky130_fd_sc_hd__decap_4
XFILLER_0_309 VGND VGND VPWR VPWR sky130_fd_sc_hd__fill_2
X_2516_ net1301 net204 _0835_ VGND VGND VPWR VPWR _0544_ sky130_fd_sc_hd__o21a_1
X_3496_ net739 net245 VGND VGND VPWR VPWR _1517_ sky130_fd_sc_hd__and2_1
X_2447_ net403 _0785_ VGND VGND VPWR VPWR _0789_ sky130_fd_sc_hd__nor2_2
X_2378_ net619 net691 net520 VGND VGND VPWR VPWR _0740_ sky130_fd_sc_hd__mux2_1
XFILLER_29_505 VGND VGND VPWR VPWR sky130_fd_sc_hd__decap_4
X_4117_ array\[1\]\[31\] net552 net530 array\[3\]\[31\] _2024_ VGND VGND VPWR VPWR
+ _2025_ sky130_fd_sc_hd__a221o_1
XFILLER_29_549 VGND VGND VPWR VPWR sky130_fd_sc_hd__decap_8
XTAP_TAPCELL_ROW_67_875 VGND VPWR sky130_fd_sc_hd__tapvpwrvgnd_1
X_4048_ array\[14\]\[25\] net466 net449 array\[12\]\[25\] VGND VGND VPWR VPWR _1962_
+ sky130_fd_sc_hd__a22o_1
XTAP_TAPCELL_ROW_39_599 VGND VPWR sky130_fd_sc_hd__tapvpwrvgnd_1
XTAP_TAPCELL_ROW_22_422 VGND VPWR sky130_fd_sc_hd__tapvpwrvgnd_1
XFILLER_33_57 VGND VGND VPWR VPWR sky130_fd_sc_hd__decap_6
XFILLER_3_169 VPWR VGND VPWR VGND sky130_ef_sc_hd__decap_12
XFILLER_94_408 VGND VGND VPWR VPWR sky130_fd_sc_hd__fill_1
XFILLER_58_65 VGND VGND VPWR VPWR sky130_fd_sc_hd__decap_8
XFILLER_94_419 VGND VGND VPWR VPWR sky130_fd_sc_hd__fill_1
Xhold9 net145 VGND VGND VPWR VPWR net775 sky130_fd_sc_hd__dlygate4sd3_1
XFILLER_62_338 VGND VGND VPWR VPWR sky130_fd_sc_hd__decap_4
XFILLER_15_221 VGND VGND VPWR VPWR sky130_fd_sc_hd__decap_3
XFILLER_90_41 VPWR VGND VPWR VGND sky130_ef_sc_hd__decap_12
XFILLER_90_85 VPWR VGND VPWR VGND sky130_ef_sc_hd__decap_12
Xhold409 array\[2\]\[18\] VGND VGND VPWR VPWR net1175 sky130_fd_sc_hd__dlygate4sd3_1
XFILLER_7_497 VGND VGND VPWR VPWR sky130_fd_sc_hd__decap_6
XTAP_TAPCELL_ROW_90_1104 VGND VPWR sky130_fd_sc_hd__tapvpwrvgnd_1
X_3350_ net1289 net153 _1413_ _1414_ VGND VGND VPWR VPWR _0219_ sky130_fd_sc_hd__o22a_1
X_2301_ net735 net320 _0685_ net411 net328 VGND VGND VPWR VPWR _0686_ sky130_fd_sc_hd__a221o_1
X_3281_ _1366_ net525 net267 VGND VGND VPWR VPWR _1367_ sky130_fd_sc_hd__and3b_1
X_2232_ net104 net103 VGND VGND VPWR VPWR _0638_ sky130_fd_sc_hd__and2b_1
Xclkbuf_leaf_2_clk clknet_3_1__leaf_clk VGND VGND VPWR VPWR clknet_leaf_2_clk sky130_fd_sc_hd__clkbuf_8
XFILLER_38_335 VGND VGND VPWR VPWR sky130_fd_sc_hd__fill_1
XTAP_TAPCELL_ROW_88_1088 VGND VPWR sky130_fd_sc_hd__tapvpwrvgnd_1
XFILLER_65_176 VGND VGND VPWR VPWR sky130_fd_sc_hd__decap_4
XTAP_TAPCELL_ROW_64_845 VGND VPWR sky130_fd_sc_hd__tapvpwrvgnd_1
XFILLER_0_83 VGND VGND VPWR VPWR sky130_fd_sc_hd__fill_1
XTAP_TAPCELL_ROW_36_569 VGND VPWR sky130_fd_sc_hd__tapvpwrvgnd_1
X_4804_ clknet_leaf_57_clk _0335_ VGND VGND VPWR VPWR array\[9\]\[22\] sky130_fd_sc_hd__dfxtp_1
X_2996_ net632 net761 net496 VGND VGND VPWR VPWR _1170_ sky130_fd_sc_hd__mux2_1
X_4735_ clknet_leaf_40_clk _0266_ VGND VGND VPWR VPWR array\[10\]\[4\] sky130_fd_sc_hd__dfxtp_1
X_4666_ clknet_leaf_47_clk _0197_ VGND VGND VPWR VPWR array\[13\]\[31\] sky130_fd_sc_hd__dfxtp_1
X_4597_ clknet_leaf_15_clk _0128_ VGND VGND VPWR VPWR array\[15\]\[26\] sky130_fd_sc_hd__dfxtp_1
X_3617_ _0584_ net559 VGND VGND VPWR VPWR _1600_ sky130_fd_sc_hd__nor2_4
X_3548_ net1196 net250 _1551_ VGND VGND VPWR VPWR _0280_ sky130_fd_sc_hd__o21a_1
XFILLER_0_139 VGND VGND VPWR VPWR sky130_fd_sc_hd__fill_1
X_3479_ net715 net258 VGND VGND VPWR VPWR _1503_ sky130_fd_sc_hd__and2_1
XFILLER_29_335 VGND VGND VPWR VPWR sky130_fd_sc_hd__fill_1
XFILLER_71_157 VGND VGND VPWR VPWR sky130_fd_sc_hd__decap_8
XFILLER_52_360 VGND VGND VPWR VPWR sky130_fd_sc_hd__decap_4
XFILLER_52_371 VGND VGND VPWR VPWR sky130_fd_sc_hd__fill_1
XFILLER_60_77 VGND VGND VPWR VPWR sky130_fd_sc_hd__decap_6
XFILLER_4_445 VPWR VGND VPWR VGND sky130_ef_sc_hd__decap_12
XFILLER_4_489 VPWR VGND VPWR VGND sky130_ef_sc_hd__decap_12
XFILLER_79_279 VGND VGND VPWR VPWR sky130_fd_sc_hd__fill_1
XTAP_TAPCELL_ROW_7_272 VGND VPWR sky130_fd_sc_hd__tapvpwrvgnd_1
XFILLER_90_433 VGND VGND VPWR VPWR sky130_fd_sc_hd__fill_1
XFILLER_90_477 VPWR VGND VPWR VGND sky130_ef_sc_hd__decap_12
XFILLER_43_371 VGND VGND VPWR VPWR sky130_fd_sc_hd__decap_3
XTAP_TAPCELL_ROW_61_815 VGND VPWR sky130_fd_sc_hd__tapvpwrvgnd_1
X_2850_ net573 net502 net275 net643 VGND VGND VPWR VPWR _1065_ sky130_fd_sc_hd__a22o_1
XTAP_TAPCELL_ROW_33_539 VGND VPWR sky130_fd_sc_hd__tapvpwrvgnd_1
X_2781_ net1288 net287 net281 net707 _1021_ VGND VGND VPWR VPWR _0043_ sky130_fd_sc_hd__a221o_1
X_4520_ clknet_leaf_5_clk _0051_ VGND VGND VPWR VPWR array\[8\]\[13\] sky130_fd_sc_hd__dfxtp_1
X_4451_ clknet_leaf_31_clk _0562_ VGND VGND VPWR VPWR array\[4\]\[8\] sky130_fd_sc_hd__dfxtp_1
Xhold206 array\[8\]\[11\] VGND VGND VPWR VPWR net972 sky130_fd_sc_hd__dlygate4sd3_1
Xhold217 array\[10\]\[6\] VGND VGND VPWR VPWR net983 sky130_fd_sc_hd__dlygate4sd3_1
Xhold228 array\[0\]\[27\] VGND VGND VPWR VPWR net994 sky130_fd_sc_hd__dlygate4sd3_1
Xhold239 array\[1\]\[20\] VGND VGND VPWR VPWR net1005 sky130_fd_sc_hd__dlygate4sd3_1
X_3402_ net709 net257 _1451_ net265 VGND VGND VPWR VPWR _1452_ sky130_fd_sc_hd__a211o_1
X_4382_ clknet_leaf_9_clk _0493_ VGND VGND VPWR VPWR array\[2\]\[3\] sky130_fd_sc_hd__dfxtp_1
Xfanout708 net34 VGND VGND VPWR VPWR net708 sky130_fd_sc_hd__clkbuf_2
Xfanout719 net28 VGND VGND VPWR VPWR net719 sky130_fd_sc_hd__buf_2
X_3333_ net1186 net179 net175 net750 _1403_ VGND VGND VPWR VPWR _0213_ sky130_fd_sc_hd__a221o_1
X_3264_ net795 _1355_ net159 VGND VGND VPWR VPWR _0192_ sky130_fd_sc_hd__mux2_1
XPHY_EDGE_ROW_7_Right_7 VGND VGND VPWR VPWR sky130_fd_sc_hd__decap_3
X_2215_ _0617_ _0620_ _0621_ _0618_ VGND VGND VPWR VPWR _0622_ sky130_fd_sc_hd__or4b_1
X_3195_ net786 _1309_ net159 VGND VGND VPWR VPWR _0169_ sky130_fd_sc_hd__mux2_1
XTAP_TAPCELL_ROW_77_970 VGND VPWR sky130_fd_sc_hd__tapvpwrvgnd_1
XFILLER_38_176 VGND VGND VPWR VPWR sky130_fd_sc_hd__decap_4
XTAP_TAPCELL_ROW_49_694 VGND VPWR sky130_fd_sc_hd__tapvpwrvgnd_1
XFILLER_53_113 VGND VGND VPWR VPWR sky130_fd_sc_hd__fill_2
XFILLER_41_308 VGND VGND VPWR VPWR sky130_fd_sc_hd__decap_6
XFILLER_14_15 VGND VGND VPWR VPWR sky130_fd_sc_hd__decap_6
XFILLER_22_533 VGND VGND VPWR VPWR sky130_fd_sc_hd__fill_1
X_2979_ net718 net193 _1158_ net380 VGND VGND VPWR VPWR _1159_ sky130_fd_sc_hd__a22o_1
X_4718_ clknet_leaf_58_clk _0249_ VGND VGND VPWR VPWR array\[11\]\[19\] sky130_fd_sc_hd__dfxtp_1
X_4649_ clknet_leaf_0_clk _0180_ VGND VGND VPWR VPWR array\[13\]\[14\] sky130_fd_sc_hd__dfxtp_1
XFILLER_30_69 VGND VGND VPWR VPWR sky130_fd_sc_hd__fill_2
XFILLER_76_249 VGND VGND VPWR VPWR sky130_fd_sc_hd__decap_3
XTAP_TAPCELL_ROW_4_242 VGND VPWR sky130_fd_sc_hd__tapvpwrvgnd_1
XFILLER_17_316 VGND VGND VPWR VPWR sky130_fd_sc_hd__fill_1
XFILLER_29_187 VGND VGND VPWR VPWR sky130_fd_sc_hd__fill_1
XFILLER_72_477 VGND VGND VPWR VPWR sky130_fd_sc_hd__fill_1
XFILLER_71_65 VPWR VGND VPWR VGND sky130_ef_sc_hd__decap_12
XTAP_TAPCELL_ROW_30_509 VGND VPWR sky130_fd_sc_hd__tapvpwrvgnd_1
XFILLER_40_341 VGND VGND VPWR VPWR sky130_fd_sc_hd__decap_4
XFILLER_40_352 VPWR VGND VPWR VGND sky130_ef_sc_hd__decap_12
XFILLER_9_559 VGND VGND VPWR VPWR sky130_fd_sc_hd__fill_1
XFILLER_4_275 VPWR VGND VPWR VGND sky130_ef_sc_hd__decap_12
XFILLER_4_253 VGND VGND VPWR VPWR sky130_fd_sc_hd__decap_8
XFILLER_35_113 VGND VGND VPWR VPWR sky130_fd_sc_hd__decap_3
XFILLER_48_474 VGND VGND VPWR VPWR sky130_fd_sc_hd__fill_2
XTAP_TAPCELL_ROW_74_940 VGND VPWR sky130_fd_sc_hd__tapvpwrvgnd_1
XTAP_TAPCELL_ROW_85_1058 VGND VPWR sky130_fd_sc_hd__tapvpwrvgnd_1
X_3951_ array\[6\]\[16\] net469 net452 array\[4\]\[16\] VGND VGND VPWR VPWR _1874_
+ sky130_fd_sc_hd__a22o_1
XTAP_TAPCELL_ROW_46_664 VGND VPWR sky130_fd_sc_hd__tapvpwrvgnd_1
XTAP_TAPCELL_ROW_18_388 VGND VPWR sky130_fd_sc_hd__tapvpwrvgnd_1
X_2902_ net751 net271 _1101_ net383 net268 VGND VGND VPWR VPWR _1102_ sky130_fd_sc_hd__a221o_1
XFILLER_91_3 VPWR VGND VPWR VGND sky130_ef_sc_hd__decap_12
X_3882_ array\[6\]\[10\] net467 net450 array\[4\]\[10\] VGND VGND VPWR VPWR _1811_
+ sky130_fd_sc_hd__a22o_1
X_2833_ net978 net283 _1053_ _1054_ VGND VGND VPWR VPWR _0062_ sky130_fd_sc_hd__o22a_1
X_2764_ net502 _1003_ VGND VGND VPWR VPWR _1010_ sky130_fd_sc_hd__nor2_1
X_4503_ clknet_leaf_40_clk _0034_ VGND VGND VPWR VPWR array\[5\]\[28\] sky130_fd_sc_hd__dfxtp_1
X_2695_ net691 net619 net392 VGND VGND VPWR VPWR _0961_ sky130_fd_sc_hd__mux2_1
XFILLER_6_82 VGND VGND VPWR VPWR sky130_fd_sc_hd__fill_2
X_4434_ clknet_leaf_42_clk _0545_ VGND VGND VPWR VPWR array\[3\]\[23\] sky130_fd_sc_hd__dfxtp_1
X_4365_ clknet_leaf_14_clk _0476_ VGND VGND VPWR VPWR array\[1\]\[18\] sky130_fd_sc_hd__dfxtp_1
Xfanout505 _1001_ VGND VGND VPWR VPWR net505 sky130_fd_sc_hd__buf_4
XFILLER_86_514 VPWR VGND VPWR VGND sky130_ef_sc_hd__decap_12
X_3316_ net1039 net154 _1391_ _1392_ VGND VGND VPWR VPWR _0207_ sky130_fd_sc_hd__o22a_1
Xfanout527 net528 VGND VGND VPWR VPWR net527 sky130_fd_sc_hd__clkbuf_4
Xfanout538 net542 VGND VGND VPWR VPWR net538 sky130_fd_sc_hd__clkbuf_4
Xfanout516 _0782_ VGND VGND VPWR VPWR net516 sky130_fd_sc_hd__clkbuf_2
XFILLER_58_205 VGND VGND VPWR VPWR sky130_fd_sc_hd__fill_2
X_4296_ net743 net336 VGND VGND VPWR VPWR _2146_ sky130_fd_sc_hd__and2_1
Xfanout549 _0606_ VGND VGND VPWR VPWR net549 sky130_fd_sc_hd__buf_2
XFILLER_58_238 VGND VGND VPWR VPWR sky130_fd_sc_hd__fill_2
X_3247_ net671 net371 VGND VGND VPWR VPWR _1344_ sky130_fd_sc_hd__and2_1
XTAP_TAPCELL_ROW_1_212 VGND VPWR sky130_fd_sc_hd__tapvpwrvgnd_1
X_3178_ net753 _0629_ _0854_ VGND VGND VPWR VPWR _1296_ sky130_fd_sc_hd__and3_4
XFILLER_39_474 VGND VGND VPWR VPWR sky130_fd_sc_hd__decap_3
XFILLER_39_496 VGND VGND VPWR VPWR sky130_fd_sc_hd__decap_3
XFILLER_81_252 VGND VGND VPWR VPWR sky130_fd_sc_hd__decap_3
XFILLER_25_25 VPWR VGND VPWR VGND sky130_ef_sc_hd__decap_12
XFILLER_10_525 VGND VGND VPWR VPWR sky130_fd_sc_hd__decap_6
XFILLER_41_68 VGND VGND VPWR VPWR sky130_fd_sc_hd__fill_1
XFILLER_2_29 VGND VGND VPWR VPWR sky130_fd_sc_hd__decap_8
XTAP_TAPCELL_ROW_71_910 VGND VPWR sky130_fd_sc_hd__tapvpwrvgnd_1
XFILLER_45_488 VPWR VGND VPWR VGND sky130_ef_sc_hd__decap_12
XFILLER_82_53 VPWR VGND VPWR VGND sky130_ef_sc_hd__decap_12
XTAP_TAPCELL_ROW_43_634 VGND VPWR sky130_fd_sc_hd__tapvpwrvgnd_1
XFILLER_82_97 VPWR VGND VPWR VGND sky130_ef_sc_hd__decap_12
XTAP_TAPCELL_ROW_15_358 VGND VPWR sky130_fd_sc_hd__tapvpwrvgnd_1
X_2480_ net948 net203 _0811_ VGND VGND VPWR VPWR _0532_ sky130_fd_sc_hd__o21a_1
Xoutput119 net119 VGND VGND VPWR VPWR done sky130_fd_sc_hd__buf_2
X_4150_ net626 net431 net340 net698 net229 VGND VGND VPWR VPWR _2050_ sky130_fd_sc_hd__a221o_1
X_3101_ net703 net185 _1243_ net189 VGND VGND VPWR VPWR _1244_ sky130_fd_sc_hd__a211o_1
X_4081_ array\[6\]\[28\] net465 net448 array\[4\]\[28\] VGND VGND VPWR VPWR _1992_
+ sky130_fd_sc_hd__a22o_1
XFILLER_36_400 VGND VGND VPWR VPWR sky130_fd_sc_hd__decap_3
X_3032_ net673 net599 net495 VGND VGND VPWR VPWR _1194_ sky130_fd_sc_hd__mux2_1
XFILLER_91_561 VGND VGND VPWR VPWR sky130_fd_sc_hd__fill_1
XFILLER_23_127 VGND VGND VPWR VPWR sky130_fd_sc_hd__decap_8
XFILLER_51_436 VGND VGND VPWR VPWR sky130_fd_sc_hd__fill_1
X_3934_ net1015 net169 _1857_ _1858_ VGND VGND VPWR VPWR _0359_ sky130_fd_sc_hd__o22a_1
XFILLER_51_469 VPWR VGND VPWR VGND sky130_ef_sc_hd__decap_12
X_3865_ net357 _1790_ _1794_ net417 VGND VGND VPWR VPWR _1796_ sky130_fd_sc_hd__a22o_1
X_2816_ net605 net504 net276 net679 net286 VGND VGND VPWR VPWR _1044_ sky130_fd_sc_hd__a221o_1
X_3796_ net435 _1726_ _1730_ net351 VGND VGND VPWR VPWR _1733_ sky130_fd_sc_hd__a22o_1
X_2747_ net720 net289 _0995_ net388 VGND VGND VPWR VPWR _0996_ sky130_fd_sc_hd__a22o_1
X_2678_ net705 net289 _0949_ net388 VGND VGND VPWR VPWR _0950_ sky130_fd_sc_hd__a22o_1
X_4417_ clknet_leaf_7_clk _0528_ VGND VGND VPWR VPWR array\[3\]\[6\] sky130_fd_sc_hd__dfxtp_1
Xfanout313 net314 VGND VGND VPWR VPWR net313 sky130_fd_sc_hd__clkbuf_4
Xfanout302 _0866_ VGND VGND VPWR VPWR net302 sky130_fd_sc_hd__clkbuf_4
Xfanout357 _1600_ VGND VGND VPWR VPWR net357 sky130_fd_sc_hd__buf_4
Xfanout346 _1643_ VGND VGND VPWR VPWR net346 sky130_fd_sc_hd__clkbuf_4
Xfanout324 net326 VGND VGND VPWR VPWR net324 sky130_fd_sc_hd__buf_4
Xfanout335 net339 VGND VGND VPWR VPWR net335 sky130_fd_sc_hd__clkbuf_4
X_4348_ clknet_leaf_19_clk _0459_ VGND VGND VPWR VPWR array\[1\]\[1\] sky130_fd_sc_hd__dfxtp_1
XFILLER_59_514 VGND VGND VPWR VPWR sky130_fd_sc_hd__fill_2
X_4279_ net999 net219 _2135_ VGND VGND VPWR VPWR _0431_ sky130_fd_sc_hd__o21a_1
Xfanout368 net370 VGND VGND VPWR VPWR net368 sky130_fd_sc_hd__buf_4
Xfanout379 _1151_ VGND VGND VPWR VPWR net379 sky130_fd_sc_hd__clkbuf_4
XFILLER_46_208 VGND VGND VPWR VPWR sky130_fd_sc_hd__decap_6
XFILLER_36_35 VGND VGND VPWR VPWR sky130_fd_sc_hd__fill_1
XFILLER_27_455 VGND VGND VPWR VPWR sky130_fd_sc_hd__decap_3
XFILLER_14_138 VGND VGND VPWR VPWR sky130_fd_sc_hd__fill_2
XTAP_TAPCELL_ROW_40_604 VGND VPWR sky130_fd_sc_hd__tapvpwrvgnd_1
XFILLER_52_45 VGND VGND VPWR VPWR sky130_fd_sc_hd__fill_1
XTAP_TAPCELL_ROW_12_328 VGND VPWR sky130_fd_sc_hd__tapvpwrvgnd_1
XFILLER_22_193 VGND VGND VPWR VPWR sky130_fd_sc_hd__decap_3
XFILLER_73_561 VGND VGND VPWR VPWR sky130_fd_sc_hd__fill_1
XTAP_TAPCELL_ROW_82_1028 VGND VPWR sky130_fd_sc_hd__tapvpwrvgnd_1
XTAP_TAPCELL_ROW_28_483 VGND VPWR sky130_fd_sc_hd__tapvpwrvgnd_1
X_3650_ _1366_ _1613_ VGND VGND VPWR VPWR _1626_ sky130_fd_sc_hd__nand2b_1
X_3581_ net941 net249 _1572_ _1573_ VGND VGND VPWR VPWR _0291_ sky130_fd_sc_hd__o22a_1
X_2601_ net615 net509 net395 net687 net300 VGND VGND VPWR VPWR _0897_ sky130_fd_sc_hd__a221o_1
X_2532_ net658 net582 net513 VGND VGND VPWR VPWR _0846_ sky130_fd_sc_hd__mux2_1
XTAP_TAPCELL_ROW_93_1135 VGND VPWR sky130_fd_sc_hd__tapvpwrvgnd_1
XFILLER_5_370 VGND VGND VPWR VPWR sky130_fd_sc_hd__decap_6
X_2463_ net638 net568 net516 VGND VGND VPWR VPWR _0800_ sky130_fd_sc_hd__mux2_1
X_4202_ net743 net234 net230 _2083_ VGND VGND VPWR VPWR _2084_ sky130_fd_sc_hd__a211o_1
X_2394_ net745 net317 _0750_ net409 net314 VGND VGND VPWR VPWR _0751_ sky130_fd_sc_hd__a221o_1
XFILLER_68_333 VGND VGND VPWR VPWR sky130_fd_sc_hd__decap_8
X_4133_ _0584_ _1586_ VGND VGND VPWR VPWR _2036_ sky130_fd_sc_hd__xnor2_1
XFILLER_3_50 VGND VGND VPWR VPWR sky130_fd_sc_hd__decap_6
X_4064_ array\[5\]\[26\] net549 net537 array\[7\]\[26\] _1976_ VGND VGND VPWR VPWR
+ _1977_ sky130_fd_sc_hd__a221o_1
X_3015_ net751 net193 _1182_ net379 VGND VGND VPWR VPWR _1183_ sky130_fd_sc_hd__a22o_1
XFILLER_24_469 VGND VGND VPWR VPWR sky130_fd_sc_hd__decap_6
XFILLER_51_233 VGND VGND VPWR VPWR sky130_fd_sc_hd__decap_4
X_3917_ array\[14\]\[13\] net460 net443 array\[12\]\[13\] VGND VGND VPWR VPWR _1843_
+ sky130_fd_sc_hd__a22o_1
X_4897_ clknet_leaf_32_clk _0428_ VGND VGND VPWR VPWR array\[6\]\[8\] sky130_fd_sc_hd__dfxtp_1
X_3848_ array\[2\]\[7\] net456 net439 array\[0\]\[7\] VGND VGND VPWR VPWR _1780_ sky130_fd_sc_hd__a22o_1
X_3779_ array\[13\]\[1\] net543 net528 array\[15\]\[1\] _1716_ VGND VGND VPWR VPWR
+ _1717_ sky130_fd_sc_hd__a221o_1
Xfanout154 net156 VGND VGND VPWR VPWR net154 sky130_fd_sc_hd__buf_4
Xfanout165 _1152_ VGND VGND VPWR VPWR net165 sky130_fd_sc_hd__clkbuf_8
XFILLER_19_208 VGND VGND VPWR VPWR sky130_fd_sc_hd__fill_2
Xfanout176 _1372_ VGND VGND VPWR VPWR net176 sky130_fd_sc_hd__clkbuf_8
Xfanout187 net188 VGND VGND VPWR VPWR net187 sky130_fd_sc_hd__buf_2
XFILLER_27_252 VGND VGND VPWR VPWR sky130_fd_sc_hd__fill_1
XFILLER_55_561 VGND VGND VPWR VPWR sky130_fd_sc_hd__fill_1
XFILLER_82_391 VGND VGND VPWR VPWR sky130_fd_sc_hd__decap_8
XFILLER_15_469 VPWR VGND VPWR VGND sky130_ef_sc_hd__decap_12
XTAP_TAPCELL_ROW_25_453 VGND VPWR sky130_fd_sc_hd__tapvpwrvgnd_1
XFILLER_6_134 VGND VGND VPWR VPWR sky130_fd_sc_hd__decap_6
XFILLER_88_41 VPWR VGND VPWR VGND sky130_ef_sc_hd__decap_12
XFILLER_88_85 VPWR VGND VPWR VGND sky130_ef_sc_hd__decap_12
XFILLER_19_6 VPWR VGND VPWR VGND sky130_ef_sc_hd__decap_12
XFILLER_65_369 VGND VGND VPWR VPWR sky130_fd_sc_hd__fill_2
XFILLER_80_328 VGND VGND VPWR VPWR sky130_fd_sc_hd__decap_8
XFILLER_18_274 VGND VGND VPWR VPWR sky130_fd_sc_hd__decap_4
X_4820_ clknet_leaf_8_clk _0351_ VGND VGND VPWR VPWR net148 sky130_fd_sc_hd__dfxtp_1
X_4751_ clknet_leaf_4_clk _0282_ VGND VGND VPWR VPWR array\[10\]\[20\] sky130_fd_sc_hd__dfxtp_1
X_3702_ net607 net349 net421 VGND VGND VPWR VPWR _1663_ sky130_fd_sc_hd__and3_1
X_4682_ clknet_leaf_33_clk _0213_ VGND VGND VPWR VPWR array\[12\]\[15\] sky130_fd_sc_hd__dfxtp_1
X_3633_ net756 net107 _0860_ _1610_ net431 VGND VGND VPWR VPWR _1612_ sky130_fd_sc_hd__a311o_1
X_3564_ net729 net248 VGND VGND VPWR VPWR _1562_ sky130_fd_sc_hd__and2_1
X_3495_ net817 _1516_ net249 VGND VGND VPWR VPWR _0262_ sky130_fd_sc_hd__mux2_1
X_2515_ net734 net305 _0834_ net403 net309 VGND VGND VPWR VPWR _0835_ sky130_fd_sc_hd__a221o_1
X_2446_ net654 _0786_ VGND VGND VPWR VPWR _0788_ sky130_fd_sc_hd__or2_1
X_2377_ net841 net207 _0739_ VGND VGND VPWR VPWR _0501_ sky130_fd_sc_hd__o21a_1
X_4116_ array\[2\]\[31\] net467 net450 array\[0\]\[31\] VGND VGND VPWR VPWR _2024_
+ sky130_fd_sc_hd__a22o_1
XFILLER_83_111 VGND VGND VPWR VPWR sky130_fd_sc_hd__fill_1
XTAP_TAPCELL_ROW_67_876 VGND VPWR sky130_fd_sc_hd__tapvpwrvgnd_1
XFILLER_17_15 VGND VGND VPWR VPWR sky130_fd_sc_hd__decap_8
XFILLER_37_561 VGND VGND VPWR VPWR sky130_fd_sc_hd__fill_1
X_4047_ net794 net172 _1960_ _1961_ VGND VGND VPWR VPWR _0369_ sky130_fd_sc_hd__o22a_1
XFILLER_83_177 VGND VGND VPWR VPWR sky130_fd_sc_hd__fill_2
XFILLER_52_531 VGND VGND VPWR VPWR sky130_fd_sc_hd__fill_1
XTAP_TAPCELL_ROW_22_423 VGND VPWR sky130_fd_sc_hd__tapvpwrvgnd_1
XFILLER_74_21 VGND VGND VPWR VPWR sky130_fd_sc_hd__decap_3
XFILLER_62_306 VGND VGND VPWR VPWR sky130_fd_sc_hd__fill_2
XFILLER_43_520 VGND VGND VPWR VPWR sky130_fd_sc_hd__fill_1
XFILLER_70_372 VGND VGND VPWR VPWR sky130_fd_sc_hd__fill_1
XFILLER_70_361 VGND VGND VPWR VPWR sky130_fd_sc_hd__decap_3
XFILLER_90_53 VPWR VGND VPWR VGND sky130_ef_sc_hd__decap_12
XFILLER_90_97 VPWR VGND VPWR VGND sky130_ef_sc_hd__decap_12
XFILLER_11_461 VPWR VGND VPWR VGND sky130_ef_sc_hd__decap_12
XFILLER_7_421 VPWR VGND VPWR VGND sky130_ef_sc_hd__decap_12
XTAP_TAPCELL_ROW_90_1105 VGND VPWR sky130_fd_sc_hd__tapvpwrvgnd_1
X_3280_ _1137_ _1138_ _1139_ VGND VGND VPWR VPWR _1366_ sky130_fd_sc_hd__or3b_2
X_2300_ net671 net597 net522 VGND VGND VPWR VPWR _0685_ sky130_fd_sc_hd__mux2_1
X_2231_ _0591_ _0636_ VGND VGND VPWR VPWR _0637_ sky130_fd_sc_hd__and2_1
XFILLER_78_450 VPWR VGND VPWR VGND sky130_ef_sc_hd__decap_12
XFILLER_65_111 VGND VGND VPWR VPWR sky130_fd_sc_hd__fill_1
XFILLER_17_3 VPWR VGND VPWR VGND sky130_ef_sc_hd__decap_12
XTAP_TAPCELL_ROW_88_1089 VGND VPWR sky130_fd_sc_hd__tapvpwrvgnd_1
XFILLER_65_188 VGND VGND VPWR VPWR sky130_fd_sc_hd__decap_3
XFILLER_19_561 VGND VGND VPWR VPWR sky130_fd_sc_hd__fill_1
XFILLER_53_317 VPWR VGND VPWR VGND sky130_ef_sc_hd__decap_12
XTAP_TAPCELL_ROW_64_846 VGND VPWR sky130_fd_sc_hd__tapvpwrvgnd_1
XFILLER_21_225 VGND VGND VPWR VPWR sky130_fd_sc_hd__decap_3
XFILLER_21_236 VGND VGND VPWR VPWR sky130_fd_sc_hd__decap_4
X_4803_ clknet_leaf_2_clk _0334_ VGND VGND VPWR VPWR array\[9\]\[21\] sky130_fd_sc_hd__dfxtp_1
X_2995_ net922 _1169_ net165 VGND VGND VPWR VPWR _0109_ sky130_fd_sc_hd__mux2_1
X_4734_ clknet_leaf_3_clk _0265_ VGND VGND VPWR VPWR array\[10\]\[3\] sky130_fd_sc_hd__dfxtp_1
X_4665_ clknet_leaf_25_clk _0196_ VGND VGND VPWR VPWR array\[13\]\[30\] sky130_fd_sc_hd__dfxtp_1
X_3616_ net562 ready_check\[11\] _1598_ _1438_ VGND VGND VPWR VPWR _1599_ sky130_fd_sc_hd__a31o_1
X_4596_ clknet_leaf_44_clk _0127_ VGND VGND VPWR VPWR array\[15\]\[25\] sky130_fd_sc_hd__dfxtp_1
X_3547_ net743 net246 _1550_ net252 VGND VGND VPWR VPWR _1551_ sky130_fd_sc_hd__a211o_1
X_3478_ net1044 net261 _1502_ VGND VGND VPWR VPWR _0259_ sky130_fd_sc_hd__o21a_1
X_2429_ net579 net649 net518 VGND VGND VPWR VPWR _0774_ sky130_fd_sc_hd__mux2_1
XFILLER_28_25 VGND VGND VPWR VPWR sky130_fd_sc_hd__decap_3
XFILLER_29_358 VGND VGND VPWR VPWR sky130_fd_sc_hd__decap_8
XFILLER_37_391 VGND VGND VPWR VPWR sky130_fd_sc_hd__fill_1
XFILLER_71_169 VPWR VGND VPWR VGND sky130_ef_sc_hd__decap_12
XFILLER_12_203 VGND VGND VPWR VPWR sky130_fd_sc_hd__fill_1
XFILLER_40_501 VGND VGND VPWR VPWR sky130_fd_sc_hd__decap_3
XFILLER_12_214 VGND VGND VPWR VPWR sky130_fd_sc_hd__fill_1
XFILLER_8_229 VGND VGND VPWR VPWR sky130_fd_sc_hd__fill_1
XFILLER_4_457 VPWR VGND VPWR VGND sky130_ef_sc_hd__decap_12
XFILLER_79_247 VGND VGND VPWR VPWR sky130_fd_sc_hd__fill_1
XTAP_TAPCELL_ROW_7_273 VGND VPWR sky130_fd_sc_hd__tapvpwrvgnd_1
XFILLER_47_166 VGND VGND VPWR VPWR sky130_fd_sc_hd__fill_2
XFILLER_16_542 VPWR VGND VPWR VGND sky130_ef_sc_hd__decap_12
XFILLER_90_489 VPWR VGND VPWR VGND sky130_ef_sc_hd__decap_12
XTAP_TAPCELL_ROW_61_816 VGND VPWR sky130_fd_sc_hd__tapvpwrvgnd_1
X_2780_ net567 net503 net277 net637 VGND VGND VPWR VPWR _1021_ sky130_fd_sc_hd__a22o_1
Xhold207 net149 VGND VGND VPWR VPWR net973 sky130_fd_sc_hd__dlygate4sd3_1
X_4450_ clknet_leaf_2_clk _0561_ VGND VGND VPWR VPWR array\[4\]\[7\] sky130_fd_sc_hd__dfxtp_1
Xhold229 array\[6\]\[29\] VGND VGND VPWR VPWR net995 sky130_fd_sc_hd__dlygate4sd3_1
X_3401_ net569 net479 net365 net639 VGND VGND VPWR VPWR _1451_ sky130_fd_sc_hd__a22o_1
X_4381_ clknet_leaf_20_clk _0492_ VGND VGND VPWR VPWR array\[2\]\[2\] sky130_fd_sc_hd__dfxtp_1
Xhold218 array\[2\]\[20\] VGND VGND VPWR VPWR net984 sky130_fd_sc_hd__dlygate4sd3_1
X_3332_ net614 net484 net369 net686 VGND VGND VPWR VPWR _1403_ sky130_fd_sc_hd__a22o_1
Xfanout709 net33 VGND VGND VPWR VPWR net709 sky130_fd_sc_hd__buf_2
X_3263_ net588 net487 net183 net726 _1354_ VGND VGND VPWR VPWR _1355_ sky130_fd_sc_hd__a221o_1
X_3194_ net571 net487 net183 net711 _1308_ VGND VGND VPWR VPWR _1309_ sky130_fd_sc_hd__a221o_1
X_2214_ tail\[3\] _0615_ VGND VGND VPWR VPWR _0621_ sky130_fd_sc_hd__nor2_1
XFILLER_66_464 VPWR VGND VPWR VGND sky130_ef_sc_hd__decap_12
XFILLER_66_442 VGND VGND VPWR VPWR sky130_fd_sc_hd__fill_1
XTAP_TAPCELL_ROW_77_971 VGND VPWR sky130_fd_sc_hd__tapvpwrvgnd_1
XFILLER_19_391 VGND VGND VPWR VPWR sky130_fd_sc_hd__fill_1
XTAP_TAPCELL_ROW_49_695 VGND VPWR sky130_fd_sc_hd__tapvpwrvgnd_1
Xclkbuf_3_5__f_clk clknet_0_clk VGND VGND VPWR VPWR clknet_3_5__leaf_clk sky130_fd_sc_hd__clkbuf_16
XFILLER_22_501 VGND VGND VPWR VPWR sky130_fd_sc_hd__decap_8
XFILLER_53_169 VGND VGND VPWR VPWR sky130_fd_sc_hd__fill_2
XFILLER_22_523 VGND VGND VPWR VPWR sky130_fd_sc_hd__fill_1
X_2978_ net648 net578 net494 VGND VGND VPWR VPWR _1158_ sky130_fd_sc_hd__mux2_1
X_4717_ clknet_leaf_10_clk _0248_ VGND VGND VPWR VPWR array\[11\]\[18\] sky130_fd_sc_hd__dfxtp_1
X_4648_ clknet_leaf_11_clk _0179_ VGND VGND VPWR VPWR array\[13\]\[13\] sky130_fd_sc_hd__dfxtp_1
XFILLER_30_26 VGND VGND VPWR VPWR sky130_fd_sc_hd__fill_2
X_4579_ clknet_leaf_31_clk _0110_ VGND VGND VPWR VPWR array\[15\]\[8\] sky130_fd_sc_hd__dfxtp_1
XFILLER_1_405 VPWR VGND VPWR VGND sky130_ef_sc_hd__decap_12
XFILLER_1_449 VPWR VGND VPWR VGND sky130_ef_sc_hd__decap_12
XFILLER_76_206 VGND VGND VPWR VPWR sky130_fd_sc_hd__decap_4
XFILLER_39_57 VGND VGND VPWR VPWR sky130_fd_sc_hd__fill_2
XFILLER_76_217 VGND VGND VPWR VPWR sky130_fd_sc_hd__decap_8
XTAP_TAPCELL_ROW_4_243 VGND VPWR sky130_fd_sc_hd__tapvpwrvgnd_1
XFILLER_84_261 VGND VGND VPWR VPWR sky130_fd_sc_hd__decap_8
XFILLER_72_445 VPWR VGND VPWR VGND sky130_ef_sc_hd__decap_12
XFILLER_71_55 VGND VGND VPWR VPWR sky130_fd_sc_hd__fill_1
XFILLER_9_505 VPWR VGND VPWR VGND sky130_ef_sc_hd__decap_12
XFILLER_71_77 VGND VGND VPWR VPWR sky130_fd_sc_hd__decap_8
XFILLER_4_210 VPWR VGND VPWR VGND sky130_ef_sc_hd__decap_12
XFILLER_20_70 VGND VGND VPWR VPWR sky130_fd_sc_hd__fill_2
XFILLER_4_287 VGND VGND VPWR VPWR sky130_fd_sc_hd__decap_4
Xhold90 array\[5\]\[27\] VGND VGND VPWR VPWR net856 sky130_fd_sc_hd__dlygate4sd3_1
XTAP_TAPCELL_ROW_74_941 VGND VPWR sky130_fd_sc_hd__tapvpwrvgnd_1
XFILLER_63_445 VGND VGND VPWR VPWR sky130_fd_sc_hd__decap_3
XTAP_TAPCELL_ROW_85_1059 VGND VPWR sky130_fd_sc_hd__tapvpwrvgnd_1
X_3950_ array\[1\]\[16\] net555 net540 array\[3\]\[16\] _1872_ VGND VGND VPWR VPWR
+ _1873_ sky130_fd_sc_hd__a221o_1
XFILLER_35_169 VGND VGND VPWR VPWR sky130_fd_sc_hd__decap_4
XTAP_TAPCELL_ROW_46_665 VGND VPWR sky130_fd_sc_hd__tapvpwrvgnd_1
XFILLER_16_372 VGND VGND VPWR VPWR sky130_fd_sc_hd__fill_2
XTAP_TAPCELL_ROW_18_389 VGND VPWR sky130_fd_sc_hd__tapvpwrvgnd_1
X_2901_ net615 net687 net497 VGND VGND VPWR VPWR _1101_ sky130_fd_sc_hd__mux2_1
XFILLER_50_139 VGND VGND VPWR VPWR sky130_fd_sc_hd__fill_1
X_3881_ array\[9\]\[10\] net552 net530 array\[11\]\[10\] _1809_ VGND VGND VPWR VPWR
+ _1810_ sky130_fd_sc_hd__a221o_1
XFILLER_31_331 VGND VGND VPWR VPWR sky130_fd_sc_hd__decap_4
XFILLER_84_3 VPWR VGND VPWR VGND sky130_ef_sc_hd__decap_12
X_2832_ net591 net503 net277 net665 net288 VGND VGND VPWR VPWR _1054_ sky130_fd_sc_hd__a221o_1
X_2763_ net502 _1003_ _1005_ _0863_ VGND VGND VPWR VPWR _1009_ sky130_fd_sc_hd__and4b_1
X_4502_ clknet_leaf_27_clk _0033_ VGND VGND VPWR VPWR array\[5\]\[27\] sky130_fd_sc_hd__dfxtp_1
X_2694_ net863 _0960_ net294 VGND VGND VPWR VPWR _0017_ sky130_fd_sc_hd__mux2_1
X_4433_ clknet_leaf_57_clk _0544_ VGND VGND VPWR VPWR array\[3\]\[22\] sky130_fd_sc_hd__dfxtp_1
X_4364_ clknet_leaf_24_clk _0475_ VGND VGND VPWR VPWR array\[1\]\[17\] sky130_fd_sc_hd__dfxtp_1
Xfanout506 net508 VGND VGND VPWR VPWR net506 sky130_fd_sc_hd__clkbuf_4
X_4295_ net1198 net224 net337 net745 _2145_ VGND VGND VPWR VPWR _0437_ sky130_fd_sc_hd__a221o_1
X_3315_ net758 net483 net368 net627 net178 VGND VGND VPWR VPWR _1392_ sky130_fd_sc_hd__a221o_1
Xfanout528 net533 VGND VGND VPWR VPWR net528 sky130_fd_sc_hd__buf_4
Xfanout517 net520 VGND VGND VPWR VPWR net517 sky130_fd_sc_hd__clkbuf_8
Xfanout539 net542 VGND VGND VPWR VPWR net539 sky130_fd_sc_hd__buf_2
XFILLER_86_526 VGND VGND VPWR VPWR sky130_fd_sc_hd__decap_6
XFILLER_39_420 VGND VGND VPWR VPWR sky130_fd_sc_hd__fill_1
X_3246_ net796 _1343_ net159 VGND VGND VPWR VPWR _0186_ sky130_fd_sc_hd__mux2_1
XFILLER_66_261 VGND VGND VPWR VPWR sky130_fd_sc_hd__decap_4
XTAP_TAPCELL_ROW_1_213 VGND VPWR sky130_fd_sc_hd__tapvpwrvgnd_1
X_3177_ net525 net267 _1293_ VGND VGND VPWR VPWR _1295_ sky130_fd_sc_hd__and3_1
XFILLER_81_220 VGND VGND VPWR VPWR sky130_fd_sc_hd__decap_4
XFILLER_26_114 VGND VGND VPWR VPWR sky130_fd_sc_hd__decap_3
XFILLER_54_445 VGND VGND VPWR VPWR sky130_fd_sc_hd__fill_2
XFILLER_14_309 VGND VGND VPWR VPWR sky130_fd_sc_hd__decap_3
XFILLER_41_128 VGND VGND VPWR VPWR sky130_fd_sc_hd__fill_1
XFILLER_22_386 VGND VGND VPWR VPWR sky130_fd_sc_hd__fill_2
XFILLER_1_279 VGND VGND VPWR VPWR sky130_fd_sc_hd__fill_1
XFILLER_66_99 VGND VGND VPWR VPWR sky130_fd_sc_hd__fill_2
XFILLER_45_445 VGND VGND VPWR VPWR sky130_fd_sc_hd__decap_3
XFILLER_57_294 VPWR VGND VPWR VGND sky130_ef_sc_hd__decap_12
XFILLER_72_253 VGND VGND VPWR VPWR sky130_fd_sc_hd__decap_4
XFILLER_17_147 VGND VGND VPWR VPWR sky130_fd_sc_hd__fill_1
XFILLER_17_169 VGND VGND VPWR VPWR sky130_fd_sc_hd__fill_1
XFILLER_82_65 VPWR VGND VPWR VGND sky130_ef_sc_hd__decap_12
XTAP_TAPCELL_ROW_71_911 VGND VPWR sky130_fd_sc_hd__tapvpwrvgnd_1
XTAP_TAPCELL_ROW_43_635 VGND VPWR sky130_fd_sc_hd__tapvpwrvgnd_1
XFILLER_60_437 VGND VGND VPWR VPWR sky130_fd_sc_hd__fill_2
XTAP_TAPCELL_ROW_15_359 VGND VPWR sky130_fd_sc_hd__tapvpwrvgnd_1
XFILLER_40_150 VGND VGND VPWR VPWR sky130_fd_sc_hd__fill_2
XFILLER_5_541 VPWR VGND VPWR VGND sky130_ef_sc_hd__decap_12
XFILLER_49_6 VGND VGND VPWR VPWR sky130_fd_sc_hd__fill_1
X_3100_ net762 net489 net375 net633 VGND VGND VPWR VPWR _1243_ sky130_fd_sc_hd__a22o_1
X_4080_ net768 net172 _1990_ _1991_ VGND VGND VPWR VPWR _0372_ sky130_fd_sc_hd__o22a_1
X_3031_ net1001 _1193_ net165 VGND VGND VPWR VPWR _0121_ sky130_fd_sc_hd__mux2_1
XTAP_TAPCELL_ROW_59_790 VGND VPWR sky130_fd_sc_hd__tapvpwrvgnd_1
XFILLER_23_117 VGND VGND VPWR VPWR sky130_fd_sc_hd__decap_4
X_3933_ net415 _1852_ _1856_ net351 net213 VGND VGND VPWR VPWR _1858_ sky130_fd_sc_hd__a221o_1
X_3864_ net437 _1788_ _1792_ net353 VGND VGND VPWR VPWR _1795_ sky130_fd_sc_hd__a22o_1
X_2815_ net743 net280 VGND VGND VPWR VPWR _1043_ sky130_fd_sc_hd__and2_1
X_3795_ array\[13\]\[2\] net553 net532 array\[15\]\[2\] _1731_ VGND VGND VPWR VPWR
+ _1732_ sky130_fd_sc_hd__a221o_1
XFILLER_11_39 VGND VGND VPWR VPWR sky130_fd_sc_hd__fill_2
X_2746_ net650 net580 net391 VGND VGND VPWR VPWR _0995_ sky130_fd_sc_hd__mux2_1
X_2677_ net635 net565 net392 VGND VGND VPWR VPWR _0949_ sky130_fd_sc_hd__mux2_1
X_4416_ clknet_leaf_28_clk _0527_ VGND VGND VPWR VPWR array\[3\]\[5\] sky130_fd_sc_hd__dfxtp_1
Xfanout303 _0866_ VGND VGND VPWR VPWR net303 sky130_fd_sc_hd__clkbuf_2
Xfanout314 _0715_ VGND VGND VPWR VPWR net314 sky130_fd_sc_hd__buf_4
XFILLER_86_323 VGND VGND VPWR VPWR sky130_fd_sc_hd__decap_6
Xfanout325 net326 VGND VGND VPWR VPWR net325 sky130_fd_sc_hd__buf_4
X_4347_ clknet_leaf_57_clk _0458_ VGND VGND VPWR VPWR array\[1\]\[0\] sky130_fd_sc_hd__dfxtp_1
Xfanout336 _2113_ VGND VGND VPWR VPWR net336 sky130_fd_sc_hd__clkbuf_2
Xfanout347 _1643_ VGND VGND VPWR VPWR net347 sky130_fd_sc_hd__buf_2
X_4278_ net621 net428 net222 _2134_ VGND VGND VPWR VPWR _2135_ sky130_fd_sc_hd__a211o_1
Xfanout369 net370 VGND VGND VPWR VPWR net369 sky130_fd_sc_hd__buf_2
Xfanout358 _1600_ VGND VGND VPWR VPWR net358 sky130_fd_sc_hd__clkbuf_4
X_3229_ net686 net374 VGND VGND VPWR VPWR _1332_ sky130_fd_sc_hd__and2_1
XFILLER_54_253 VPWR VGND VPWR VGND sky130_ef_sc_hd__decap_12
XTAP_TAPCELL_ROW_40_605 VGND VPWR sky130_fd_sc_hd__tapvpwrvgnd_1
XTAP_TAPCELL_ROW_12_329 VGND VPWR sky130_fd_sc_hd__tapvpwrvgnd_1
XFILLER_2_533 VPWR VGND VPWR VGND sky130_ef_sc_hd__decap_12
Xhold390 array\[1\]\[19\] VGND VGND VPWR VPWR net1156 sky130_fd_sc_hd__dlygate4sd3_1
XFILLER_89_150 VGND VGND VPWR VPWR sky130_fd_sc_hd__fill_1
XTAP_TAPCELL_ROW_82_1029 VGND VPWR sky130_fd_sc_hd__tapvpwrvgnd_1
XTAP_TAPCELL_ROW_28_484 VGND VPWR sky130_fd_sc_hd__tapvpwrvgnd_1
XTAP_TAPCELL_ROW_56_760 VGND VPWR sky130_fd_sc_hd__tapvpwrvgnd_1
XFILLER_20_109 VGND VGND VPWR VPWR sky130_fd_sc_hd__fill_2
X_3580_ net579 net476 net362 net649 net254 VGND VGND VPWR VPWR _1573_ sky130_fd_sc_hd__a221o_1
X_2600_ net751 net399 net506 VGND VGND VPWR VPWR _0896_ sky130_fd_sc_hd__and3_1
X_2531_ net1041 net206 _0845_ VGND VGND VPWR VPWR _0549_ sky130_fd_sc_hd__o21a_1
XTAP_TAPCELL_ROW_93_1136 VGND VPWR sky130_fd_sc_hd__tapvpwrvgnd_1
X_4201_ net605 net432 net341 net679 VGND VGND VPWR VPWR _2083_ sky130_fd_sc_hd__a22o_1
X_2462_ net1230 net203 _0799_ VGND VGND VPWR VPWR _0526_ sky130_fd_sc_hd__o21a_1
X_2393_ net609 net681 net519 VGND VGND VPWR VPWR _0750_ sky130_fd_sc_hd__mux2_1
X_4132_ full _0602_ net652 VGND VGND VPWR VPWR _2035_ sky130_fd_sc_hd__a21oi_1
X_4063_ array\[6\]\[26\] net461 net444 array\[4\]\[26\] VGND VGND VPWR VPWR _1976_
+ sky130_fd_sc_hd__a22o_1
X_3014_ net687 net615 net493 VGND VGND VPWR VPWR _1182_ sky130_fd_sc_hd__mux2_1
XFILLER_36_231 VGND VGND VPWR VPWR sky130_fd_sc_hd__fill_1
XFILLER_36_253 VPWR VGND VPWR VGND sky130_ef_sc_hd__decap_12
XFILLER_24_437 VGND VGND VPWR VPWR sky130_fd_sc_hd__fill_2
X_3916_ array\[1\]\[13\] net546 net536 array\[3\]\[13\] _1841_ VGND VGND VPWR VPWR
+ _1842_ sky130_fd_sc_hd__a221o_1
X_4896_ clknet_leaf_2_clk _0427_ VGND VGND VPWR VPWR array\[6\]\[7\] sky130_fd_sc_hd__dfxtp_1
X_3847_ array\[9\]\[7\] net543 net526 array\[11\]\[7\] _1778_ VGND VGND VPWR VPWR
+ _1779_ sky130_fd_sc_hd__a221o_1
X_3778_ array\[14\]\[1\] net456 net439 array\[12\]\[1\] VGND VGND VPWR VPWR _1716_
+ sky130_fd_sc_hd__a22o_1
X_2729_ net732 net291 _0983_ net389 VGND VGND VPWR VPWR _0984_ sky130_fd_sc_hd__a22o_1
Xfanout155 net156 VGND VGND VPWR VPWR net155 sky130_fd_sc_hd__clkbuf_2
XFILLER_59_334 VGND VGND VPWR VPWR sky130_fd_sc_hd__fill_2
Xfanout177 net180 VGND VGND VPWR VPWR net177 sky130_fd_sc_hd__buf_4
Xfanout166 _1152_ VGND VGND VPWR VPWR net166 sky130_fd_sc_hd__buf_2
Xfanout199 net202 VGND VGND VPWR VPWR net199 sky130_fd_sc_hd__buf_4
Xfanout188 _1227_ VGND VGND VPWR VPWR net188 sky130_fd_sc_hd__clkbuf_8
XFILLER_47_24 VGND VGND VPWR VPWR sky130_fd_sc_hd__fill_1
XPHY_EDGE_ROW_29_Right_29 VGND VGND VPWR VPWR sky130_fd_sc_hd__decap_3
XTAP_TAPCELL_ROW_53_730 VGND VPWR sky130_fd_sc_hd__tapvpwrvgnd_1
XTAP_TAPCELL_ROW_25_454 VGND VPWR sky130_fd_sc_hd__tapvpwrvgnd_1
XFILLER_8_29 VPWR VGND VPWR VGND sky130_ef_sc_hd__decap_12
XFILLER_10_120 VPWR VGND VPWR VGND sky130_ef_sc_hd__decap_12
XPHY_EDGE_ROW_38_Right_38 VGND VGND VPWR VPWR sky130_fd_sc_hd__decap_3
XFILLER_88_53 VPWR VGND VPWR VGND sky130_ef_sc_hd__decap_12
XFILLER_88_97 VPWR VGND VPWR VGND sky130_ef_sc_hd__decap_12
XPHY_EDGE_ROW_0_Left_95 VGND VGND VPWR VPWR sky130_fd_sc_hd__decap_3
XFILLER_2_396 VPWR VGND VPWR VGND sky130_ef_sc_hd__decap_12
XPHY_EDGE_ROW_47_Right_47 VGND VGND VPWR VPWR sky130_fd_sc_hd__decap_3
XFILLER_77_186 VGND VGND VPWR VPWR sky130_fd_sc_hd__decap_4
X_4750_ clknet_leaf_58_clk _0281_ VGND VGND VPWR VPWR array\[10\]\[19\] sky130_fd_sc_hd__dfxtp_1
XPHY_EDGE_ROW_56_Right_56 VGND VGND VPWR VPWR sky130_fd_sc_hd__decap_3
X_3701_ net1098 net238 _1661_ _1662_ VGND VGND VPWR VPWR _0322_ sky130_fd_sc_hd__o22a_1
X_4681_ clknet_leaf_0_clk _0212_ VGND VGND VPWR VPWR array\[12\]\[14\] sky130_fd_sc_hd__dfxtp_1
X_3632_ _0586_ _0780_ _0854_ VGND VGND VPWR VPWR _1611_ sky130_fd_sc_hd__and3_2
X_3563_ net927 net251 _1560_ _1561_ VGND VGND VPWR VPWR _0285_ sky130_fd_sc_hd__o22a_1
X_3494_ net629 net245 _1515_ VGND VGND VPWR VPWR _1516_ sky130_fd_sc_hd__a21o_1
X_2514_ net670 net596 net514 VGND VGND VPWR VPWR _0834_ sky130_fd_sc_hd__mux2_1
XPHY_EDGE_ROW_65_Right_65 VGND VGND VPWR VPWR sky130_fd_sc_hd__decap_3
X_2445_ net403 _0785_ net564 VGND VGND VPWR VPWR _0787_ sky130_fd_sc_hd__and3b_2
XFILLER_68_120 VGND VGND VPWR VPWR sky130_fd_sc_hd__decap_6
X_4115_ net778 net172 _2022_ _2023_ VGND VGND VPWR VPWR _0375_ sky130_fd_sc_hd__o22a_1
X_2376_ net585 net315 _0738_ net407 net312 VGND VGND VPWR VPWR _0739_ sky130_fd_sc_hd__a221o_1
XTAP_TAPCELL_ROW_67_877 VGND VPWR sky130_fd_sc_hd__tapvpwrvgnd_1
XFILLER_56_359 VGND VGND VPWR VPWR sky130_fd_sc_hd__decap_4
X_4046_ net438 _1955_ _1959_ net354 net216 VGND VGND VPWR VPWR _1961_ sky130_fd_sc_hd__a221o_1
XPHY_EDGE_ROW_74_Right_74 VGND VGND VPWR VPWR sky130_fd_sc_hd__decap_3
XFILLER_33_15 VPWR VGND VPWR VGND sky130_ef_sc_hd__decap_12
XTAP_TAPCELL_ROW_50_700 VGND VPWR sky130_fd_sc_hd__tapvpwrvgnd_1
XTAP_TAPCELL_ROW_22_424 VGND VPWR sky130_fd_sc_hd__tapvpwrvgnd_1
X_4879_ clknet_leaf_2_clk _0410_ VGND VGND VPWR VPWR array\[7\]\[22\] sky130_fd_sc_hd__dfxtp_1
XFILLER_20_473 VGND VGND VPWR VPWR sky130_fd_sc_hd__decap_3
XPHY_EDGE_ROW_18_Left_113 VGND VGND VPWR VPWR sky130_fd_sc_hd__decap_3
XPHY_EDGE_ROW_83_Right_83 VGND VGND VPWR VPWR sky130_fd_sc_hd__decap_3
XFILLER_79_418 VGND VGND VPWR VPWR sky130_fd_sc_hd__decap_3
XFILLER_47_326 VGND VGND VPWR VPWR sky130_fd_sc_hd__decap_8
XFILLER_74_11 VGND VGND VPWR VPWR sky130_fd_sc_hd__fill_2
XPHY_EDGE_ROW_27_Left_122 VGND VGND VPWR VPWR sky130_fd_sc_hd__decap_3
XFILLER_47_348 VGND VGND VPWR VPWR sky130_fd_sc_hd__fill_1
XPHY_EDGE_ROW_92_Right_92 VGND VGND VPWR VPWR sky130_fd_sc_hd__decap_3
XFILLER_90_65 VPWR VGND VPWR VGND sky130_ef_sc_hd__decap_12
XFILLER_30_248 VGND VGND VPWR VPWR sky130_fd_sc_hd__decap_4
XFILLER_11_473 VPWR VGND VPWR VGND sky130_ef_sc_hd__decap_12
XFILLER_7_433 VPWR VGND VPWR VGND sky130_ef_sc_hd__decap_12
XPHY_EDGE_ROW_36_Left_131 VGND VGND VPWR VPWR sky130_fd_sc_hd__decap_3
XTAP_TAPCELL_ROW_90_1106 VGND VPWR sky130_fd_sc_hd__tapvpwrvgnd_1
X_2230_ net653 net106 net3 net766 VGND VGND VPWR VPWR _0636_ sky130_fd_sc_hd__and4bb_1
XFILLER_31_6 VPWR VGND VPWR VGND sky130_ef_sc_hd__decap_12
XFILLER_78_462 VPWR VGND VPWR VGND sky130_ef_sc_hd__decap_12
XPHY_EDGE_ROW_45_Left_140 VGND VGND VPWR VPWR sky130_fd_sc_hd__decap_3
XFILLER_0_41 VPWR VGND VPWR VGND sky130_ef_sc_hd__decap_12
XFILLER_53_329 VGND VGND VPWR VPWR sky130_fd_sc_hd__decap_6
XTAP_TAPCELL_ROW_64_847 VGND VPWR sky130_fd_sc_hd__tapvpwrvgnd_1
XFILLER_0_85 VPWR VGND VPWR VGND sky130_ef_sc_hd__decap_12
XFILLER_0_63 VGND VGND VPWR VPWR sky130_fd_sc_hd__decap_8
X_2994_ net703 net193 _1168_ net379 VGND VGND VPWR VPWR _1169_ sky130_fd_sc_hd__a22o_1
X_4802_ clknet_leaf_5_clk _0333_ VGND VGND VPWR VPWR array\[9\]\[20\] sky130_fd_sc_hd__dfxtp_1
XFILLER_9_61 VGND VGND VPWR VPWR sky130_fd_sc_hd__fill_1
X_4733_ clknet_leaf_39_clk _0264_ VGND VGND VPWR VPWR array\[10\]\[2\] sky130_fd_sc_hd__dfxtp_1
X_4664_ clknet_leaf_50_clk _0195_ VGND VGND VPWR VPWR array\[13\]\[29\] sky130_fd_sc_hd__dfxtp_1
X_4595_ clknet_leaf_33_clk _0126_ VGND VGND VPWR VPWR array\[15\]\[24\] sky130_fd_sc_hd__dfxtp_1
X_3615_ _1140_ _1597_ VGND VGND VPWR VPWR _1598_ sky130_fd_sc_hd__nand2_1
X_3546_ net605 net475 net360 net679 VGND VGND VPWR VPWR _1550_ sky130_fd_sc_hd__a22o_1
XFILLER_0_119 VGND VGND VPWR VPWR sky130_fd_sc_hd__decap_3
X_3477_ net719 net257 _1501_ net265 VGND VGND VPWR VPWR _1502_ sky130_fd_sc_hd__a211o_1
XFILLER_69_462 VGND VGND VPWR VPWR sky130_fd_sc_hd__decap_8
X_2428_ net1244 net208 _0773_ VGND VGND VPWR VPWR _0518_ sky130_fd_sc_hd__o21a_1
X_2359_ net1016 net209 _0727_ VGND VGND VPWR VPWR _0495_ sky130_fd_sc_hd__o21a_1
XFILLER_29_337 VGND VGND VPWR VPWR sky130_fd_sc_hd__fill_2
XFILLER_56_123 VGND VGND VPWR VPWR sky130_fd_sc_hd__decap_8
XFILLER_44_307 VGND VGND VPWR VPWR sky130_fd_sc_hd__fill_1
X_4029_ array\[9\]\[23\] net556 net539 array\[11\]\[23\] _1944_ VGND VGND VPWR VPWR
+ _1945_ sky130_fd_sc_hd__a221o_1
XFILLER_71_137 VGND VGND VPWR VPWR sky130_fd_sc_hd__decap_4
XFILLER_25_521 VGND VGND VPWR VPWR sky130_fd_sc_hd__decap_8
XFILLER_69_66 VGND VGND VPWR VPWR sky130_fd_sc_hd__decap_4
XFILLER_4_469 VGND VGND VPWR VPWR sky130_fd_sc_hd__decap_6
XTAP_TAPCELL_ROW_7_274 VGND VPWR sky130_fd_sc_hd__tapvpwrvgnd_1
XFILLER_94_229 VGND VGND VPWR VPWR sky130_fd_sc_hd__fill_1
XFILLER_16_554 VGND VGND VPWR VPWR sky130_fd_sc_hd__decap_4
XTAP_TAPCELL_ROW_61_817 VGND VPWR sky130_fd_sc_hd__tapvpwrvgnd_1
XFILLER_31_513 VGND VGND VPWR VPWR sky130_fd_sc_hd__fill_2
XFILLER_79_6 VPWR VGND VPWR VGND sky130_ef_sc_hd__decap_12
Xhold208 array\[5\]\[1\] VGND VGND VPWR VPWR net974 sky130_fd_sc_hd__dlygate4sd3_1
Xhold219 array\[4\]\[18\] VGND VGND VPWR VPWR net985 sky130_fd_sc_hd__dlygate4sd3_1
X_4380_ clknet_leaf_3_clk _0491_ VGND VGND VPWR VPWR array\[2\]\[1\] sky130_fd_sc_hd__dfxtp_1
X_3400_ net1108 net259 _1449_ _1450_ VGND VGND VPWR VPWR _0233_ sky130_fd_sc_hd__o22a_1
X_3331_ net1181 net153 _1401_ _1402_ VGND VGND VPWR VPWR _0212_ sky130_fd_sc_hd__o22a_1
X_3262_ net662 net373 VGND VGND VPWR VPWR _1354_ sky130_fd_sc_hd__and2_1
XFILLER_85_218 VGND VGND VPWR VPWR sky130_fd_sc_hd__fill_1
X_3193_ net641 net373 VGND VGND VPWR VPWR _1308_ sky130_fd_sc_hd__and2_1
X_2213_ head\[1\] _0619_ VGND VGND VPWR VPWR _0620_ sky130_fd_sc_hd__xor2_1
XFILLER_38_101 VPWR VGND VPWR VGND sky130_ef_sc_hd__decap_12
XTAP_TAPCELL_ROW_77_972 VGND VPWR sky130_fd_sc_hd__tapvpwrvgnd_1
XFILLER_81_435 VGND VGND VPWR VPWR sky130_fd_sc_hd__decap_4
XTAP_TAPCELL_ROW_49_696 VGND VPWR sky130_fd_sc_hd__tapvpwrvgnd_1
XFILLER_34_362 VGND VGND VPWR VPWR sky130_fd_sc_hd__fill_2
XFILLER_34_373 VGND VGND VPWR VPWR sky130_fd_sc_hd__decap_4
X_2977_ net1139 _1157_ net165 VGND VGND VPWR VPWR _0103_ sky130_fd_sc_hd__mux2_1
X_4716_ clknet_leaf_20_clk _0247_ VGND VGND VPWR VPWR array\[11\]\[17\] sky130_fd_sc_hd__dfxtp_1
X_4647_ clknet_leaf_15_clk _0178_ VGND VGND VPWR VPWR array\[13\]\[12\] sky130_fd_sc_hd__dfxtp_1
X_4578_ clknet_leaf_60_clk _0109_ VGND VGND VPWR VPWR array\[15\]\[7\] sky130_fd_sc_hd__dfxtp_1
XFILLER_1_417 VGND VGND VPWR VPWR sky130_fd_sc_hd__decap_6
X_3529_ net619 net475 net360 net691 net252 VGND VGND VPWR VPWR _1539_ sky130_fd_sc_hd__a221o_1
XFILLER_39_25 VGND VGND VPWR VPWR sky130_fd_sc_hd__decap_4
XFILLER_69_281 VPWR VGND VPWR VGND sky130_ef_sc_hd__decap_12
XTAP_TAPCELL_ROW_4_244 VGND VPWR sky130_fd_sc_hd__tapvpwrvgnd_1
XFILLER_17_329 VGND VGND VPWR VPWR sky130_fd_sc_hd__fill_1
XFILLER_72_457 VGND VGND VPWR VPWR sky130_fd_sc_hd__decap_4
XFILLER_13_502 VGND VGND VPWR VPWR sky130_fd_sc_hd__fill_2
XFILLER_9_517 VPWR VGND VPWR VGND sky130_ef_sc_hd__decap_12
XFILLER_40_398 VGND VGND VPWR VPWR sky130_fd_sc_hd__fill_1
XFILLER_4_222 VGND VGND VPWR VPWR sky130_fd_sc_hd__decap_6
XFILLER_0_461 VPWR VGND VPWR VGND sky130_ef_sc_hd__decap_12
XFILLER_48_421 VGND VGND VPWR VPWR sky130_fd_sc_hd__decap_4
XFILLER_75_251 VGND VGND VPWR VPWR sky130_fd_sc_hd__fill_1
Xhold80 array\[5\]\[29\] VGND VGND VPWR VPWR net846 sky130_fd_sc_hd__dlygate4sd3_1
Xhold91 array\[15\]\[6\] VGND VGND VPWR VPWR net857 sky130_fd_sc_hd__dlygate4sd3_1
XFILLER_90_221 VGND VGND VPWR VPWR sky130_fd_sc_hd__decap_3
XFILLER_75_295 VGND VGND VPWR VPWR sky130_fd_sc_hd__fill_1
XTAP_TAPCELL_ROW_74_942 VGND VPWR sky130_fd_sc_hd__tapvpwrvgnd_1
XFILLER_16_340 VGND VGND VPWR VPWR sky130_fd_sc_hd__fill_1
XTAP_TAPCELL_ROW_46_666 VGND VPWR sky130_fd_sc_hd__tapvpwrvgnd_1
X_2900_ net1229 net202 _1100_ VGND VGND VPWR VPWR _0083_ sky130_fd_sc_hd__o21a_1
XFILLER_16_362 VGND VGND VPWR VPWR sky130_fd_sc_hd__fill_2
XFILLER_71_490 VGND VGND VPWR VPWR sky130_fd_sc_hd__decap_3
X_3880_ array\[10\]\[10\] net467 net450 array\[8\]\[10\] VGND VGND VPWR VPWR _1809_
+ sky130_fd_sc_hd__a22o_1
X_2831_ net729 net282 VGND VGND VPWR VPWR _1053_ sky130_fd_sc_hd__and2_1
X_2762_ net652 _1006_ VGND VGND VPWR VPWR _1008_ sky130_fd_sc_hd__or2_4
X_4501_ clknet_leaf_16_clk _0032_ VGND VGND VPWR VPWR array\[5\]\[26\] sky130_fd_sc_hd__dfxtp_1
XFILLER_8_561 VGND VGND VPWR VPWR sky130_fd_sc_hd__fill_1
X_2693_ net585 net290 _0959_ net388 VGND VGND VPWR VPWR _0960_ sky130_fd_sc_hd__a22o_1
X_4432_ clknet_leaf_0_clk _0543_ VGND VGND VPWR VPWR array\[3\]\[21\] sky130_fd_sc_hd__dfxtp_1
X_4363_ clknet_leaf_26_clk _0474_ VGND VGND VPWR VPWR array\[1\]\[16\] sky130_fd_sc_hd__dfxtp_1
X_4294_ net609 net429 net333 net681 VGND VGND VPWR VPWR _2145_ sky130_fd_sc_hd__a22o_1
X_3314_ net699 net174 VGND VGND VPWR VPWR _1391_ sky130_fd_sc_hd__and2_1
Xfanout529 net533 VGND VGND VPWR VPWR net529 sky130_fd_sc_hd__clkbuf_4
Xfanout518 net519 VGND VGND VPWR VPWR net518 sky130_fd_sc_hd__buf_4
Xfanout507 net508 VGND VGND VPWR VPWR net507 sky130_fd_sc_hd__clkbuf_2
X_3245_ net599 net487 net183 net737 _1342_ VGND VGND VPWR VPWR _1343_ sky130_fd_sc_hd__a221o_1
XTAP_TAPCELL_ROW_1_214 VGND VPWR sky130_fd_sc_hd__tapvpwrvgnd_1
X_3176_ net267 _1293_ VGND VGND VPWR VPWR _1294_ sky130_fd_sc_hd__nand2_1
XFILLER_39_465 VGND VGND VPWR VPWR sky130_fd_sc_hd__decap_4
Xclkbuf_leaf_61_clk clknet_3_0__leaf_clk VGND VGND VPWR VPWR clknet_leaf_61_clk sky130_fd_sc_hd__clkbuf_8
XFILLER_34_192 VGND VGND VPWR VPWR sky130_fd_sc_hd__decap_4
Xhold550 head\[2\] VGND VGND VPWR VPWR net1316 sky130_fd_sc_hd__dlygate4sd3_1
XFILLER_1_225 VPWR VGND VPWR VGND sky130_ef_sc_hd__decap_12
XFILLER_89_343 VGND VGND VPWR VPWR sky130_fd_sc_hd__fill_2
XFILLER_45_413 VPWR VGND VPWR VGND sky130_ef_sc_hd__decap_12
XFILLER_72_232 VGND VGND VPWR VPWR sky130_fd_sc_hd__decap_8
XFILLER_72_298 VGND VGND VPWR VPWR sky130_fd_sc_hd__fill_2
XTAP_TAPCELL_ROW_71_912 VGND VPWR sky130_fd_sc_hd__tapvpwrvgnd_1
XFILLER_82_77 VGND VGND VPWR VPWR sky130_fd_sc_hd__decap_6
Xclkbuf_leaf_52_clk clknet_3_2__leaf_clk VGND VGND VPWR VPWR clknet_leaf_52_clk sky130_fd_sc_hd__clkbuf_8
XTAP_TAPCELL_ROW_43_636 VGND VPWR sky130_fd_sc_hd__tapvpwrvgnd_1
XFILLER_15_93 VPWR VGND VPWR VGND sky130_ef_sc_hd__decap_12
XFILLER_15_82 VGND VGND VPWR VPWR sky130_fd_sc_hd__decap_3
XFILLER_15_71 VGND VGND VPWR VPWR sky130_fd_sc_hd__decap_3
XFILLER_40_195 VGND VGND VPWR VPWR sky130_fd_sc_hd__fill_1
XFILLER_5_553 VGND VGND VPWR VPWR sky130_fd_sc_hd__decap_6
XFILLER_76_560 VGND VGND VPWR VPWR sky130_fd_sc_hd__fill_2
X_3030_ net741 net193 _1192_ net379 VGND VGND VPWR VPWR _1193_ sky130_fd_sc_hd__a22o_1
XTAP_TAPCELL_ROW_59_791 VGND VPWR sky130_fd_sc_hd__tapvpwrvgnd_1
XFILLER_91_541 VPWR VGND VPWR VGND sky130_ef_sc_hd__decap_12
XFILLER_51_405 VGND VGND VPWR VPWR sky130_fd_sc_hd__decap_6
XFILLER_51_416 VPWR VGND VPWR VGND sky130_ef_sc_hd__decap_12
XFILLER_16_192 VGND VGND VPWR VPWR sky130_fd_sc_hd__decap_4
Xclkbuf_leaf_43_clk clknet_3_3__leaf_clk VGND VGND VPWR VPWR clknet_leaf_43_clk sky130_fd_sc_hd__clkbuf_8
X_3932_ net435 _1850_ _1854_ net355 VGND VGND VPWR VPWR _1857_ sky130_fd_sc_hd__a22o_1
X_3863_ array\[13\]\[8\] net557 net541 array\[15\]\[8\] _1793_ VGND VGND VPWR VPWR
+ _1794_ sky130_fd_sc_hd__a221o_1
XFILLER_31_140 VGND VGND VPWR VPWR sky130_fd_sc_hd__fill_1
X_2814_ net1018 _1008_ _1041_ _1042_ VGND VGND VPWR VPWR _0055_ sky130_fd_sc_hd__o22a_1
X_3794_ array\[14\]\[2\] net467 net450 array\[12\]\[2\] VGND VGND VPWR VPWR _1731_
+ sky130_fd_sc_hd__a22o_1
XFILLER_8_391 VGND VGND VPWR VPWR sky130_fd_sc_hd__decap_3
X_2745_ net835 _0994_ net295 VGND VGND VPWR VPWR _0034_ sky130_fd_sc_hd__mux2_1
X_2676_ net839 _0948_ net295 VGND VGND VPWR VPWR _0011_ sky130_fd_sc_hd__mux2_1
X_4415_ clknet_leaf_40_clk _0526_ VGND VGND VPWR VPWR array\[3\]\[4\] sky130_fd_sc_hd__dfxtp_1
X_4346_ clknet_leaf_62_clk _0457_ VGND VGND VPWR VPWR empty sky130_fd_sc_hd__dfxtp_1
Xfanout304 net305 VGND VGND VPWR VPWR net304 sky130_fd_sc_hd__clkbuf_4
Xfanout348 net350 VGND VGND VPWR VPWR net348 sky130_fd_sc_hd__clkbuf_4
Xfanout326 _0641_ VGND VGND VPWR VPWR net326 sky130_fd_sc_hd__clkbuf_4
Xfanout315 net318 VGND VGND VPWR VPWR net315 sky130_fd_sc_hd__buf_4
Xfanout337 net339 VGND VGND VPWR VPWR net337 sky130_fd_sc_hd__clkbuf_4
XFILLER_59_505 VGND VGND VPWR VPWR sky130_fd_sc_hd__fill_1
X_4277_ net585 net336 net332 net693 VGND VGND VPWR VPWR _2134_ sky130_fd_sc_hd__a22o_1
Xfanout359 net362 VGND VGND VPWR VPWR net359 sky130_fd_sc_hd__clkbuf_4
X_3228_ net1068 _1331_ net157 VGND VGND VPWR VPWR _0180_ sky130_fd_sc_hd__mux2_1
X_3159_ net888 net164 _1282_ VGND VGND VPWR VPWR _0160_ sky130_fd_sc_hd__o21a_1
XFILLER_82_530 VGND VGND VPWR VPWR sky130_fd_sc_hd__fill_2
XFILLER_36_26 VGND VGND VPWR VPWR sky130_fd_sc_hd__fill_2
XFILLER_54_265 VGND VGND VPWR VPWR sky130_fd_sc_hd__decap_8
Xclkbuf_leaf_34_clk clknet_3_6__leaf_clk VGND VGND VPWR VPWR clknet_leaf_34_clk sky130_fd_sc_hd__clkbuf_8
XTAP_TAPCELL_ROW_40_606 VGND VPWR sky130_fd_sc_hd__tapvpwrvgnd_1
XFILLER_10_379 VGND VGND VPWR VPWR sky130_fd_sc_hd__decap_4
XFILLER_2_501 VPWR VGND VPWR VGND sky130_ef_sc_hd__decap_12
XFILLER_7_3 VPWR VGND VPWR VGND sky130_ef_sc_hd__decap_12
XFILLER_2_545 VPWR VGND VPWR VGND sky130_ef_sc_hd__decap_12
Xhold380 array\[10\]\[4\] VGND VGND VPWR VPWR net1146 sky130_fd_sc_hd__dlygate4sd3_1
XFILLER_89_173 VGND VGND VPWR VPWR sky130_fd_sc_hd__fill_1
XFILLER_77_44 VPWR VGND VPWR VGND sky130_ef_sc_hd__decap_12
Xhold391 array\[0\]\[23\] VGND VGND VPWR VPWR net1157 sky130_fd_sc_hd__dlygate4sd3_1
XFILLER_45_276 VGND VGND VPWR VPWR sky130_fd_sc_hd__decap_4
XTAP_TAPCELL_ROW_56_761 VGND VPWR sky130_fd_sc_hd__tapvpwrvgnd_1
XFILLER_60_213 VGND VGND VPWR VPWR sky130_fd_sc_hd__decap_8
Xclkbuf_leaf_25_clk clknet_3_7__leaf_clk VGND VGND VPWR VPWR clknet_leaf_25_clk sky130_fd_sc_hd__clkbuf_8
XTAP_TAPCELL_ROW_28_485 VGND VPWR sky130_fd_sc_hd__tapvpwrvgnd_1
XFILLER_45_298 VGND VGND VPWR VPWR sky130_fd_sc_hd__decap_3
XFILLER_9_166 VGND VGND VPWR VPWR sky130_fd_sc_hd__fill_2
X_2530_ net724 net307 _0844_ net405 net311 VGND VGND VPWR VPWR _0845_ sky130_fd_sc_hd__a221o_1
XFILLER_61_6 VPWR VGND VPWR VGND sky130_ef_sc_hd__decap_12
XTAP_TAPCELL_ROW_93_1137 VGND VPWR sky130_fd_sc_hd__tapvpwrvgnd_1
X_2461_ net709 net304 _0798_ net402 net308 VGND VGND VPWR VPWR _0799_ sky130_fd_sc_hd__a221o_1
X_4200_ net956 net228 _2081_ _2082_ VGND VGND VPWR VPWR _0405_ sky130_fd_sc_hd__o22a_1
X_2392_ net1036 net209 _0749_ VGND VGND VPWR VPWR _0506_ sky130_fd_sc_hd__o21a_1
X_4131_ tail\[3\] net860 net652 VGND VGND VPWR VPWR _0384_ sky130_fd_sc_hd__mux2_1
X_4062_ array\[13\]\[26\] net547 net536 array\[15\]\[26\] _1974_ VGND VGND VPWR VPWR
+ _1975_ sky130_fd_sc_hd__a221o_1
X_3013_ net950 _1181_ net167 VGND VGND VPWR VPWR _0115_ sky130_fd_sc_hd__mux2_1
XFILLER_36_265 VPWR VGND VPWR VGND sky130_ef_sc_hd__decap_12
Xclkbuf_leaf_16_clk clknet_3_5__leaf_clk VGND VGND VPWR VPWR clknet_leaf_16_clk sky130_fd_sc_hd__clkbuf_8
XFILLER_17_490 VGND VGND VPWR VPWR sky130_fd_sc_hd__fill_1
X_3915_ array\[2\]\[13\] net459 net442 array\[0\]\[13\] VGND VGND VPWR VPWR _1841_
+ sky130_fd_sc_hd__a22o_1
X_4895_ clknet_leaf_4_clk _0426_ VGND VGND VPWR VPWR array\[6\]\[6\] sky130_fd_sc_hd__dfxtp_1
X_3846_ array\[10\]\[7\] net456 net439 array\[8\]\[7\] VGND VGND VPWR VPWR _1778_
+ sky130_fd_sc_hd__a22o_1
X_3777_ array\[5\]\[1\] net544 net528 array\[7\]\[1\] _1714_ VGND VGND VPWR VPWR _1715_
+ sky130_fd_sc_hd__a221o_1
X_2728_ net668 net594 net393 VGND VGND VPWR VPWR _0983_ sky130_fd_sc_hd__mux2_1
X_2659_ net387 _0935_ VGND VGND VPWR VPWR _0937_ sky130_fd_sc_hd__and2b_1
XFILLER_86_121 VGND VGND VPWR VPWR sky130_fd_sc_hd__decap_3
Xfanout156 _1371_ VGND VGND VPWR VPWR net156 sky130_fd_sc_hd__clkbuf_4
X_4329_ net715 net335 VGND VGND VPWR VPWR _2167_ sky130_fd_sc_hd__and2_1
Xfanout178 net180 VGND VGND VPWR VPWR net178 sky130_fd_sc_hd__buf_4
Xfanout189 net192 VGND VGND VPWR VPWR net189 sky130_fd_sc_hd__buf_4
Xfanout167 _1152_ VGND VGND VPWR VPWR net167 sky130_fd_sc_hd__buf_4
XFILLER_67_390 VGND VGND VPWR VPWR sky130_fd_sc_hd__fill_2
XFILLER_27_276 VGND VGND VPWR VPWR sky130_fd_sc_hd__decap_4
XFILLER_70_533 VGND VGND VPWR VPWR sky130_fd_sc_hd__decap_8
XTAP_TAPCELL_ROW_53_731 VGND VPWR sky130_fd_sc_hd__tapvpwrvgnd_1
XFILLER_63_46 VGND VGND VPWR VPWR sky130_fd_sc_hd__fill_2
XFILLER_63_57 VGND VGND VPWR VPWR sky130_fd_sc_hd__decap_6
XTAP_TAPCELL_ROW_25_455 VGND VPWR sky130_fd_sc_hd__tapvpwrvgnd_1
XFILLER_10_132 VGND VGND VPWR VPWR sky130_fd_sc_hd__fill_2
XFILLER_12_83 VGND VGND VPWR VPWR sky130_fd_sc_hd__fill_1
XFILLER_88_65 VPWR VGND VPWR VGND sky130_ef_sc_hd__decap_12
Xfanout690 net43 VGND VGND VPWR VPWR net690 sky130_fd_sc_hd__clkbuf_2
XFILLER_92_168 VGND VGND VPWR VPWR sky130_fd_sc_hd__decap_8
XFILLER_73_360 VGND VGND VPWR VPWR sky130_fd_sc_hd__fill_1
X_3700_ net759 net425 net346 net628 net243 VGND VGND VPWR VPWR _1662_ sky130_fd_sc_hd__a221o_1
X_4680_ clknet_leaf_11_clk _0211_ VGND VGND VPWR VPWR array\[12\]\[13\] sky130_fd_sc_hd__dfxtp_1
XFILLER_14_493 VGND VGND VPWR VPWR sky130_fd_sc_hd__fill_1
X_3631_ net105 _0636_ _0784_ VGND VGND VPWR VPWR _1610_ sky130_fd_sc_hd__and3_1
X_3562_ net593 net474 net362 net667 net253 VGND VGND VPWR VPWR _1561_ sky130_fd_sc_hd__a221o_1
X_2513_ net1313 net204 _0833_ VGND VGND VPWR VPWR _0543_ sky130_fd_sc_hd__o21a_1
X_3493_ net625 net473 net359 net697 VGND VGND VPWR VPWR _1515_ sky130_fd_sc_hd__a22o_1
X_2444_ net403 _0785_ VGND VGND VPWR VPWR _0786_ sky130_fd_sc_hd__nand2b_1
Xclkbuf_leaf_5_clk clknet_3_4__leaf_clk VGND VGND VPWR VPWR clknet_leaf_5_clk sky130_fd_sc_hd__clkbuf_8
X_2375_ net621 net693 net517 VGND VGND VPWR VPWR _0738_ sky130_fd_sc_hd__mux2_1
X_4114_ net358 _2017_ _2021_ net354 net216 VGND VGND VPWR VPWR _2023_ sky130_fd_sc_hd__a221o_1
XFILLER_83_113 VPWR VGND VPWR VGND sky130_ef_sc_hd__decap_12
X_4045_ net418 _1953_ _1957_ net358 VGND VGND VPWR VPWR _1960_ sky130_fd_sc_hd__a22o_1
XTAP_TAPCELL_ROW_67_878 VGND VPWR sky130_fd_sc_hd__tapvpwrvgnd_1
XFILLER_12_419 VGND VGND VPWR VPWR sky130_fd_sc_hd__fill_1
XTAP_TAPCELL_ROW_22_425 VGND VPWR sky130_fd_sc_hd__tapvpwrvgnd_1
XFILLER_33_27 VPWR VGND VPWR VGND sky130_ef_sc_hd__decap_12
XTAP_TAPCELL_ROW_50_701 VGND VPWR sky130_fd_sc_hd__tapvpwrvgnd_1
X_4878_ clknet_leaf_2_clk _0409_ VGND VGND VPWR VPWR array\[7\]\[21\] sky130_fd_sc_hd__dfxtp_1
X_3829_ array\[5\]\[5\] net557 net541 array\[7\]\[5\] _1762_ VGND VGND VPWR VPWR _1763_
+ sky130_fd_sc_hd__a221o_1
XFILLER_20_485 VGND VGND VPWR VPWR sky130_fd_sc_hd__fill_1
XFILLER_28_530 VGND VGND VPWR VPWR sky130_fd_sc_hd__fill_2
XTAP_TAPCELL_ROW_38_580 VGND VPWR sky130_fd_sc_hd__tapvpwrvgnd_1
XFILLER_55_382 VGND VGND VPWR VPWR sky130_fd_sc_hd__fill_1
XFILLER_55_393 VGND VGND VPWR VPWR sky130_fd_sc_hd__fill_1
XFILLER_15_279 VGND VGND VPWR VPWR sky130_fd_sc_hd__fill_1
XFILLER_90_77 VGND VGND VPWR VPWR sky130_fd_sc_hd__decap_6
XFILLER_23_290 VGND VGND VPWR VPWR sky130_fd_sc_hd__decap_4
XFILLER_23_82 VGND VGND VPWR VPWR sky130_fd_sc_hd__fill_1
XFILLER_11_485 VPWR VGND VPWR VGND sky130_ef_sc_hd__decap_12
XFILLER_7_445 VGND VGND VPWR VPWR sky130_fd_sc_hd__decap_3
XTAP_TAPCELL_ROW_90_1107 VGND VPWR sky130_fd_sc_hd__tapvpwrvgnd_1
XFILLER_78_485 VGND VGND VPWR VPWR sky130_fd_sc_hd__fill_2
XFILLER_78_474 VGND VGND VPWR VPWR sky130_fd_sc_hd__fill_2
XFILLER_0_53 VGND VGND VPWR VPWR sky130_fd_sc_hd__decap_3
XFILLER_53_308 VGND VGND VPWR VPWR sky130_fd_sc_hd__fill_2
XFILLER_80_149 VGND VGND VPWR VPWR sky130_fd_sc_hd__decap_4
XTAP_TAPCELL_ROW_64_848 VGND VPWR sky130_fd_sc_hd__tapvpwrvgnd_1
XFILLER_34_533 VGND VGND VPWR VPWR sky130_fd_sc_hd__fill_1
XFILLER_46_371 VGND VGND VPWR VPWR sky130_fd_sc_hd__fill_2
XFILLER_0_97 VGND VGND VPWR VPWR sky130_fd_sc_hd__decap_4
X_2993_ net633 net762 net493 VGND VGND VPWR VPWR _1168_ sky130_fd_sc_hd__mux2_1
X_4801_ clknet_leaf_52_clk _0332_ VGND VGND VPWR VPWR array\[9\]\[19\] sky130_fd_sc_hd__dfxtp_1
XFILLER_21_249 VGND VGND VPWR VPWR sky130_fd_sc_hd__decap_6
X_4732_ clknet_leaf_55_clk _0263_ VGND VGND VPWR VPWR array\[10\]\[1\] sky130_fd_sc_hd__dfxtp_1
XFILLER_9_84 VGND VGND VPWR VPWR sky130_fd_sc_hd__decap_4
X_4663_ clknet_leaf_50_clk _0194_ VGND VGND VPWR VPWR array\[13\]\[28\] sky130_fd_sc_hd__dfxtp_1
X_3614_ _1142_ _1143_ VGND VGND VPWR VPWR _1597_ sky130_fd_sc_hd__and2b_1
X_4594_ clknet_leaf_34_clk _0125_ VGND VGND VPWR VPWR array\[15\]\[23\] sky130_fd_sc_hd__dfxtp_1
X_3545_ net1263 net251 _1548_ _1549_ VGND VGND VPWR VPWR _0279_ sky130_fd_sc_hd__o22a_1
X_3476_ net579 net479 net365 net649 VGND VGND VPWR VPWR _1501_ sky130_fd_sc_hd__a22o_1
XFILLER_88_249 VGND VGND VPWR VPWR sky130_fd_sc_hd__decap_3
X_2427_ net721 net316 _0772_ net408 net313 VGND VGND VPWR VPWR _0773_ sky130_fd_sc_hd__a221o_1
X_2358_ net707 net317 _0726_ net409 net314 VGND VGND VPWR VPWR _0727_ sky130_fd_sc_hd__a221o_1
X_2289_ net746 net322 _0677_ net412 net330 VGND VGND VPWR VPWR _0678_ sky130_fd_sc_hd__a221o_1
XFILLER_84_477 VGND VGND VPWR VPWR sky130_fd_sc_hd__decap_6
X_4028_ array\[10\]\[23\] net470 net453 array\[8\]\[23\] VGND VGND VPWR VPWR _1944_
+ sky130_fd_sc_hd__a22o_1
XFILLER_71_127 VGND VGND VPWR VPWR sky130_fd_sc_hd__fill_2
XFILLER_37_393 VGND VGND VPWR VPWR sky130_fd_sc_hd__decap_4
XTAP_TAPCELL_ROW_35_550 VGND VPWR sky130_fd_sc_hd__tapvpwrvgnd_1
XFILLER_52_396 VGND VGND VPWR VPWR sky130_fd_sc_hd__decap_8
XFILLER_94_208 VGND VGND VPWR VPWR sky130_fd_sc_hd__fill_2
XTAP_TAPCELL_ROW_7_275 VGND VPWR sky130_fd_sc_hd__tapvpwrvgnd_1
XFILLER_47_113 VGND VGND VPWR VPWR sky130_fd_sc_hd__decap_3
XFILLER_85_55 VGND VGND VPWR VPWR sky130_fd_sc_hd__fill_1
XFILLER_18_60 VGND VGND VPWR VPWR sky130_fd_sc_hd__fill_1
XFILLER_28_360 VGND VGND VPWR VPWR sky130_fd_sc_hd__decap_4
XFILLER_18_93 VGND VGND VPWR VPWR sky130_fd_sc_hd__decap_3
XTAP_TAPCELL_ROW_61_818 VGND VPWR sky130_fd_sc_hd__tapvpwrvgnd_1
XFILLER_70_193 VGND VGND VPWR VPWR sky130_fd_sc_hd__decap_3
XFILLER_7_253 VGND VGND VPWR VPWR sky130_fd_sc_hd__fill_2
Xhold209 array\[3\]\[31\] VGND VGND VPWR VPWR net975 sky130_fd_sc_hd__dlygate4sd3_1
X_3330_ net615 net481 net367 net687 net177 VGND VGND VPWR VPWR _1402_ sky130_fd_sc_hd__a221o_1
X_3261_ net887 _1353_ net158 VGND VGND VPWR VPWR _0191_ sky130_fd_sc_hd__mux2_1
X_2212_ tail\[1\] tail\[0\] VGND VGND VPWR VPWR _0619_ sky130_fd_sc_hd__xnor2_1
X_3192_ net815 _1307_ net157 VGND VGND VPWR VPWR _0168_ sky130_fd_sc_hd__mux2_1
XFILLER_38_113 VGND VGND VPWR VPWR sky130_fd_sc_hd__decap_4
XTAP_TAPCELL_ROW_77_973 VGND VPWR sky130_fd_sc_hd__tapvpwrvgnd_1
XFILLER_81_447 VGND VGND VPWR VPWR sky130_fd_sc_hd__fill_1
XTAP_TAPCELL_ROW_49_697 VGND VPWR sky130_fd_sc_hd__tapvpwrvgnd_1
XFILLER_53_127 VGND VGND VPWR VPWR sky130_fd_sc_hd__fill_1
XTAP_TAPCELL_ROW_32_520 VGND VPWR sky130_fd_sc_hd__tapvpwrvgnd_1
X_2976_ net740 net193 _1156_ net379 VGND VGND VPWR VPWR _1157_ sky130_fd_sc_hd__a22o_1
X_4715_ clknet_leaf_21_clk _0246_ VGND VGND VPWR VPWR array\[11\]\[16\] sky130_fd_sc_hd__dfxtp_1
X_4646_ clknet_leaf_15_clk _0177_ VGND VGND VPWR VPWR array\[13\]\[11\] sky130_fd_sc_hd__dfxtp_1
X_4577_ clknet_leaf_8_clk _0108_ VGND VGND VPWR VPWR array\[15\]\[6\] sky130_fd_sc_hd__dfxtp_1
XFILLER_1_429 VPWR VGND VPWR VGND sky130_ef_sc_hd__decap_12
X_3528_ net764 net246 VGND VGND VPWR VPWR _1538_ sky130_fd_sc_hd__and2_1
X_3459_ net593 net480 net366 net667 net266 VGND VGND VPWR VPWR _1490_ sky130_fd_sc_hd__a221o_1
XFILLER_69_293 VPWR VGND VPWR VGND sky130_ef_sc_hd__decap_12
XTAP_TAPCELL_ROW_4_245 VGND VPWR sky130_fd_sc_hd__tapvpwrvgnd_1
XFILLER_29_113 VGND VGND VPWR VPWR sky130_fd_sc_hd__fill_2
XFILLER_72_436 VGND VGND VPWR VPWR sky130_fd_sc_hd__decap_3
XFILLER_72_414 VGND VGND VPWR VPWR sky130_fd_sc_hd__decap_6
XPHY_EDGE_ROW_64_Left_159 VGND VGND VPWR VPWR sky130_fd_sc_hd__decap_3
XFILLER_25_363 VGND VGND VPWR VPWR sky130_fd_sc_hd__decap_4
XFILLER_52_193 VGND VGND VPWR VPWR sky130_fd_sc_hd__decap_3
XFILLER_71_57 VGND VGND VPWR VPWR sky130_fd_sc_hd__decap_3
XFILLER_9_529 VPWR VGND VPWR VGND sky130_ef_sc_hd__decap_12
XPHY_EDGE_ROW_73_Left_168 VGND VGND VPWR VPWR sky130_fd_sc_hd__decap_3
XFILLER_20_50 VPWR VGND VPWR VGND sky130_ef_sc_hd__decap_12
XFILLER_20_83 VGND VGND VPWR VPWR sky130_fd_sc_hd__fill_1
XFILLER_0_473 VGND VGND VPWR VPWR sky130_fd_sc_hd__decap_3
Xhold81 array\[2\]\[30\] VGND VGND VPWR VPWR net847 sky130_fd_sc_hd__dlygate4sd3_1
Xhold70 array\[11\]\[31\] VGND VGND VPWR VPWR net836 sky130_fd_sc_hd__dlygate4sd3_1
Xhold92 array\[1\]\[0\] VGND VGND VPWR VPWR net858 sky130_fd_sc_hd__dlygate4sd3_1
XTAP_TAPCELL_ROW_74_943 VGND VPWR sky130_fd_sc_hd__tapvpwrvgnd_1
XPHY_EDGE_ROW_82_Left_177 VGND VGND VPWR VPWR sky130_fd_sc_hd__decap_3
XTAP_TAPCELL_ROW_46_667 VGND VPWR sky130_fd_sc_hd__tapvpwrvgnd_1
X_2830_ net949 _1008_ _1051_ _1052_ VGND VGND VPWR VPWR _0061_ sky130_fd_sc_hd__o22a_1
X_2761_ net652 _1006_ VGND VGND VPWR VPWR _1007_ sky130_fd_sc_hd__nor2_1
X_2692_ net693 net621 net392 VGND VGND VPWR VPWR _0959_ sky130_fd_sc_hd__mux2_1
X_4500_ clknet_leaf_44_clk _0031_ VGND VGND VPWR VPWR array\[5\]\[25\] sky130_fd_sc_hd__dfxtp_1
XPHY_EDGE_ROW_91_Left_186 VGND VGND VPWR VPWR sky130_fd_sc_hd__decap_3
XANTENNA_1 _0604_ VGND VGND VPWR VPWR sky130_fd_sc_hd__diode_2
X_4431_ clknet_leaf_9_clk _0542_ VGND VGND VPWR VPWR array\[3\]\[20\] sky130_fd_sc_hd__dfxtp_1
X_4362_ clknet_leaf_38_clk _0473_ VGND VGND VPWR VPWR array\[1\]\[15\] sky130_fd_sc_hd__dfxtp_1
X_3313_ net1062 net155 _1389_ _1390_ VGND VGND VPWR VPWR _0206_ sky130_fd_sc_hd__o22a_1
X_4293_ net1061 _2112_ _2143_ _2144_ VGND VGND VPWR VPWR _0436_ sky130_fd_sc_hd__o22a_1
Xfanout508 _0864_ VGND VGND VPWR VPWR net508 sky130_fd_sc_hd__buf_4
Xfanout519 net520 VGND VGND VPWR VPWR net519 sky130_fd_sc_hd__buf_4
X_3244_ net673 net373 VGND VGND VPWR VPWR _1342_ sky130_fd_sc_hd__and2_1
XFILLER_94_561 VGND VGND VPWR VPWR sky130_fd_sc_hd__fill_1
XTAP_TAPCELL_ROW_1_215 VGND VPWR sky130_fd_sc_hd__tapvpwrvgnd_1
X_3175_ _1137_ _1138_ _1139_ VGND VGND VPWR VPWR _1293_ sky130_fd_sc_hd__and3b_2
XFILLER_81_244 VGND VGND VPWR VPWR sky130_fd_sc_hd__decap_8
XFILLER_81_299 VGND VGND VPWR VPWR sky130_fd_sc_hd__fill_1
X_2959_ _1137_ _1138_ _1139_ VGND VGND VPWR VPWR _1141_ sky130_fd_sc_hd__nand3_1
X_4629_ clknet_leaf_15_clk _0160_ VGND VGND VPWR VPWR array\[14\]\[26\] sky130_fd_sc_hd__dfxtp_1
Xhold551 tail\[0\] VGND VGND VPWR VPWR net1317 sky130_fd_sc_hd__dlygate4sd3_1
Xhold540 array\[10\]\[21\] VGND VGND VPWR VPWR net1306 sky130_fd_sc_hd__dlygate4sd3_1
XFILLER_1_237 VPWR VGND VPWR VGND sky130_ef_sc_hd__decap_12
XFILLER_85_561 VGND VGND VPWR VPWR sky130_fd_sc_hd__fill_1
XFILLER_57_241 VGND VGND VPWR VPWR sky130_fd_sc_hd__decap_8
XFILLER_17_116 VGND VGND VPWR VPWR sky130_fd_sc_hd__fill_1
XFILLER_45_425 VPWR VGND VPWR VGND sky130_ef_sc_hd__decap_12
XFILLER_45_469 VGND VGND VPWR VPWR sky130_fd_sc_hd__fill_1
XTAP_TAPCELL_ROW_71_913 VGND VPWR sky130_fd_sc_hd__tapvpwrvgnd_1
XFILLER_32_108 VGND VGND VPWR VPWR sky130_fd_sc_hd__fill_1
XTAP_TAPCELL_ROW_43_637 VGND VPWR sky130_fd_sc_hd__tapvpwrvgnd_1
XFILLER_9_326 VGND VGND VPWR VPWR sky130_fd_sc_hd__decap_4
XFILLER_0_281 VGND VGND VPWR VPWR sky130_fd_sc_hd__fill_2
XTAP_TAPCELL_ROW_59_792 VGND VPWR sky130_fd_sc_hd__tapvpwrvgnd_1
XFILLER_91_553 VGND VGND VPWR VPWR sky130_fd_sc_hd__decap_6
XFILLER_51_428 VGND VGND VPWR VPWR sky130_fd_sc_hd__decap_8
XFILLER_16_182 VGND VGND VPWR VPWR sky130_fd_sc_hd__decap_3
X_3931_ array\[5\]\[14\] net544 net528 array\[7\]\[14\] _1855_ VGND VGND VPWR VPWR
+ _1856_ sky130_fd_sc_hd__a221o_1
XFILLER_44_491 VPWR VGND VPWR VGND sky130_ef_sc_hd__decap_12
X_3862_ array\[14\]\[8\] net471 net454 array\[12\]\[8\] VGND VGND VPWR VPWR _1793_
+ sky130_fd_sc_hd__a22o_1
X_2813_ net609 net503 net277 net681 net287 VGND VGND VPWR VPWR _1042_ sky130_fd_sc_hd__a221o_1
X_3793_ array\[5\]\[2\] net551 net531 array\[7\]\[2\] _1729_ VGND VGND VPWR VPWR _1730_
+ sky130_fd_sc_hd__a221o_1
X_2744_ net722 net291 _0993_ net389 VGND VGND VPWR VPWR _0994_ sky130_fd_sc_hd__a22o_1
X_2675_ net707 net291 _0947_ net389 VGND VGND VPWR VPWR _0948_ sky130_fd_sc_hd__a22o_1
X_4414_ clknet_leaf_9_clk _0525_ VGND VGND VPWR VPWR array\[3\]\[3\] sky130_fd_sc_hd__dfxtp_1
X_4345_ clknet_leaf_62_clk _0456_ VGND VGND VPWR VPWR _0003_ sky130_fd_sc_hd__dfxtp_1
Xfanout305 _0789_ VGND VGND VPWR VPWR net305 sky130_fd_sc_hd__clkbuf_4
Xfanout338 net339 VGND VGND VPWR VPWR net338 sky130_fd_sc_hd__clkbuf_2
Xfanout327 net328 VGND VGND VPWR VPWR net327 sky130_fd_sc_hd__clkbuf_4
Xfanout316 net317 VGND VGND VPWR VPWR net316 sky130_fd_sc_hd__clkbuf_4
Xfanout349 net350 VGND VGND VPWR VPWR net349 sky130_fd_sc_hd__clkbuf_4
X_4276_ net1030 net220 _2132_ _2133_ VGND VGND VPWR VPWR _0430_ sky130_fd_sc_hd__o22a_1
XFILLER_67_561 VGND VGND VPWR VPWR sky130_fd_sc_hd__fill_1
X_3227_ net615 net485 net181 net751 _1330_ VGND VGND VPWR VPWR _1331_ sky130_fd_sc_hd__a221o_1
X_3158_ net726 net188 _1281_ net192 VGND VGND VPWR VPWR _1282_ sky130_fd_sc_hd__a211o_1
XFILLER_27_436 VPWR VGND VPWR VGND sky130_ef_sc_hd__decap_12
XFILLER_36_49 VGND VGND VPWR VPWR sky130_fd_sc_hd__decap_3
X_3089_ net711 net185 _1235_ net189 VGND VGND VPWR VPWR _1236_ sky130_fd_sc_hd__a211o_1
XFILLER_14_108 VGND VGND VPWR VPWR sky130_fd_sc_hd__fill_1
XFILLER_42_417 VGND VGND VPWR VPWR sky130_fd_sc_hd__decap_3
XTAP_TAPCELL_ROW_40_607 VGND VPWR sky130_fd_sc_hd__tapvpwrvgnd_1
XFILLER_10_336 VGND VGND VPWR VPWR sky130_fd_sc_hd__decap_4
XFILLER_2_513 VPWR VGND VPWR VGND sky130_ef_sc_hd__decap_12
XFILLER_2_557 VGND VGND VPWR VPWR sky130_fd_sc_hd__decap_4
Xhold381 array\[5\]\[2\] VGND VGND VPWR VPWR net1147 sky130_fd_sc_hd__dlygate4sd3_1
Xhold370 array\[11\]\[12\] VGND VGND VPWR VPWR net1136 sky130_fd_sc_hd__dlygate4sd3_1
Xhold392 array\[12\]\[4\] VGND VGND VPWR VPWR net1158 sky130_fd_sc_hd__dlygate4sd3_1
XFILLER_92_328 VGND VGND VPWR VPWR sky130_fd_sc_hd__fill_1
XFILLER_45_200 VGND VGND VPWR VPWR sky130_fd_sc_hd__fill_1
XFILLER_93_55 VGND VGND VPWR VPWR sky130_fd_sc_hd__fill_1
XTAP_TAPCELL_ROW_56_762 VGND VPWR sky130_fd_sc_hd__tapvpwrvgnd_1
XFILLER_26_82 VGND VGND VPWR VPWR sky130_fd_sc_hd__fill_2
XTAP_TAPCELL_ROW_28_486 VGND VPWR sky130_fd_sc_hd__tapvpwrvgnd_1
XTAP_TAPCELL_ROW_93_1138 VGND VPWR sky130_fd_sc_hd__tapvpwrvgnd_1
X_2460_ net639 net569 net513 VGND VGND VPWR VPWR _0798_ sky130_fd_sc_hd__mux2_1
XFILLER_54_6 VPWR VGND VPWR VGND sky130_ef_sc_hd__decap_12
XFILLER_5_384 VGND VGND VPWR VPWR sky130_fd_sc_hd__decap_4
X_2391_ net747 net317 _0748_ net409 net314 VGND VGND VPWR VPWR _0749_ sky130_fd_sc_hd__a221o_1
X_4130_ tail\[2\] net900 net651 VGND VGND VPWR VPWR _0383_ sky130_fd_sc_hd__mux2_1
X_4061_ array\[14\]\[26\] net462 net445 array\[12\]\[26\] VGND VGND VPWR VPWR _1974_
+ sky130_fd_sc_hd__a22o_1
XFILLER_68_358 VGND VGND VPWR VPWR sky130_fd_sc_hd__decap_6
XFILLER_49_561 VGND VGND VPWR VPWR sky130_fd_sc_hd__fill_1
X_3012_ net754 net195 _1180_ net381 VGND VGND VPWR VPWR _1181_ sky130_fd_sc_hd__a22o_1
XFILLER_36_211 VGND VGND VPWR VPWR sky130_fd_sc_hd__fill_1
XFILLER_91_361 VGND VGND VPWR VPWR sky130_fd_sc_hd__fill_2
X_3914_ array\[5\]\[13\] net549 net536 array\[7\]\[13\] _1839_ VGND VGND VPWR VPWR
+ _1840_ sky130_fd_sc_hd__a221o_1
X_4894_ clknet_leaf_31_clk _0425_ VGND VGND VPWR VPWR array\[6\]\[5\] sky130_fd_sc_hd__dfxtp_1
XFILLER_22_29 VGND VGND VPWR VPWR sky130_fd_sc_hd__decap_6
X_3845_ array\[5\]\[7\] net544 net527 array\[7\]\[7\] _1776_ VGND VGND VPWR VPWR _1777_
+ sky130_fd_sc_hd__a221o_1
X_3776_ array\[6\]\[1\] net457 net440 array\[4\]\[1\] VGND VGND VPWR VPWR _1714_ sky130_fd_sc_hd__a22o_1
X_2727_ net1080 _0982_ net293 VGND VGND VPWR VPWR _0028_ sky130_fd_sc_hd__mux2_1
X_2658_ net654 net387 _0935_ VGND VGND VPWR VPWR _0936_ sky130_fd_sc_hd__or3_4
X_2589_ net623 net511 net397 net695 VGND VGND VPWR VPWR _0889_ sky130_fd_sc_hd__a22o_1
X_4328_ net995 net220 _2165_ _2166_ VGND VGND VPWR VPWR _0449_ sky130_fd_sc_hd__o22a_1
Xfanout157 _1299_ VGND VGND VPWR VPWR net157 sky130_fd_sc_hd__clkbuf_8
X_4259_ net570 net429 net333 net640 net223 VGND VGND VPWR VPWR _2123_ sky130_fd_sc_hd__a221o_1
Xfanout168 _1152_ VGND VGND VPWR VPWR net168 sky130_fd_sc_hd__clkbuf_4
Xfanout179 net180 VGND VGND VPWR VPWR net179 sky130_fd_sc_hd__buf_2
XTAP_TAPCELL_ROW_53_732 VGND VPWR sky130_fd_sc_hd__tapvpwrvgnd_1
XTAP_TAPCELL_ROW_25_456 VGND VPWR sky130_fd_sc_hd__tapvpwrvgnd_1
XFILLER_30_409 VGND VGND VPWR VPWR sky130_fd_sc_hd__decap_6
XFILLER_88_77 VGND VGND VPWR VPWR sky130_fd_sc_hd__decap_6
XFILLER_2_365 VGND VGND VPWR VPWR sky130_fd_sc_hd__decap_6
XFILLER_77_111 VGND VGND VPWR VPWR sky130_fd_sc_hd__fill_1
Xfanout680 net48 VGND VGND VPWR VPWR net680 sky130_fd_sc_hd__buf_1
Xfanout691 net42 VGND VGND VPWR VPWR net691 sky130_fd_sc_hd__buf_2
XFILLER_77_177 VGND VGND VPWR VPWR sky130_fd_sc_hd__decap_3
XFILLER_21_409 VGND VGND VPWR VPWR sky130_fd_sc_hd__decap_4
X_3630_ net212 _1595_ _1601_ _1609_ VGND VGND VPWR VPWR _0304_ sky130_fd_sc_hd__o31a_1
X_3561_ net731 net247 VGND VGND VPWR VPWR _1560_ sky130_fd_sc_hd__and2_1
X_2512_ net735 net305 _0832_ net403 net309 VGND VGND VPWR VPWR _0833_ sky130_fd_sc_hd__a221o_1
X_3492_ net473 _1222_ net501 VGND VGND VPWR VPWR _1514_ sky130_fd_sc_hd__and3b_1
X_2443_ _0637_ _0784_ VGND VGND VPWR VPWR _0785_ sky130_fd_sc_hd__nand2_1
X_2374_ net926 net208 _0737_ VGND VGND VPWR VPWR _0500_ sky130_fd_sc_hd__o21a_1
X_4113_ net438 _2015_ _2019_ net418 VGND VGND VPWR VPWR _2022_ sky130_fd_sc_hd__a22o_1
XFILLER_68_155 VGND VGND VPWR VPWR sky130_fd_sc_hd__decap_3
XFILLER_83_125 VPWR VGND VPWR VGND sky130_ef_sc_hd__decap_12
XFILLER_49_380 VGND VGND VPWR VPWR sky130_fd_sc_hd__decap_6
X_4044_ array\[5\]\[24\] net556 net539 array\[7\]\[24\] _1958_ VGND VGND VPWR VPWR
+ _1959_ sky130_fd_sc_hd__a221o_1
XTAP_TAPCELL_ROW_67_879 VGND VPWR sky130_fd_sc_hd__tapvpwrvgnd_1
XFILLER_33_39 VPWR VGND VPWR VGND sky130_ef_sc_hd__decap_12
XTAP_TAPCELL_ROW_50_702 VGND VPWR sky130_fd_sc_hd__tapvpwrvgnd_1
XFILLER_20_442 VGND VGND VPWR VPWR sky130_fd_sc_hd__fill_1
XTAP_TAPCELL_ROW_22_426 VGND VPWR sky130_fd_sc_hd__tapvpwrvgnd_1
X_4877_ clknet_leaf_6_clk _0408_ VGND VGND VPWR VPWR array\[7\]\[20\] sky130_fd_sc_hd__dfxtp_1
X_3828_ array\[6\]\[5\] net471 net454 array\[4\]\[5\] VGND VGND VPWR VPWR _1762_ sky130_fd_sc_hd__a22o_1
X_3759_ net715 net349 net421 VGND VGND VPWR VPWR _1700_ sky130_fd_sc_hd__and3_1
XFILLER_59_111 VGND VGND VPWR VPWR sky130_fd_sc_hd__fill_1
XFILLER_87_464 VPWR VGND VPWR VGND sky130_ef_sc_hd__decap_12
XFILLER_59_166 VGND VGND VPWR VPWR sky130_fd_sc_hd__fill_2
XFILLER_74_147 VGND VGND VPWR VPWR sky130_fd_sc_hd__fill_1
XFILLER_62_309 VGND VGND VPWR VPWR sky130_fd_sc_hd__decap_3
XTAP_TAPCELL_ROW_38_581 VGND VPWR sky130_fd_sc_hd__tapvpwrvgnd_1
XFILLER_70_331 VGND VGND VPWR VPWR sky130_fd_sc_hd__fill_2
XFILLER_70_397 VGND VGND VPWR VPWR sky130_fd_sc_hd__fill_1
XFILLER_11_497 VGND VGND VPWR VPWR sky130_fd_sc_hd__decap_6
XTAP_TAPCELL_ROW_90_1108 VGND VPWR sky130_fd_sc_hd__tapvpwrvgnd_1
XFILLER_24_7 VPWR VGND VPWR VGND sky130_ef_sc_hd__decap_12
XFILLER_38_306 VGND VGND VPWR VPWR sky130_fd_sc_hd__fill_2
XFILLER_38_317 VGND VGND VPWR VPWR sky130_fd_sc_hd__fill_1
XTAP_TAPCELL_ROW_64_849 VGND VPWR sky130_fd_sc_hd__tapvpwrvgnd_1
XFILLER_34_523 VGND VGND VPWR VPWR sky130_fd_sc_hd__fill_1
X_4800_ clknet_leaf_10_clk _0331_ VGND VGND VPWR VPWR array\[9\]\[18\] sky130_fd_sc_hd__dfxtp_1
X_2992_ net857 _1167_ net167 VGND VGND VPWR VPWR _0108_ sky130_fd_sc_hd__mux2_1
X_4731_ clknet_leaf_58_clk _0262_ VGND VGND VPWR VPWR array\[10\]\[0\] sky130_fd_sc_hd__dfxtp_1
X_4662_ clknet_leaf_29_clk _0193_ VGND VGND VPWR VPWR array\[13\]\[27\] sky130_fd_sc_hd__dfxtp_1
X_3613_ _1369_ _1593_ _1596_ _0614_ VGND VGND VPWR VPWR _0300_ sky130_fd_sc_hd__o2bb2a_1
X_4593_ clknet_leaf_59_clk _0124_ VGND VGND VPWR VPWR array\[15\]\[22\] sky130_fd_sc_hd__dfxtp_1
X_3544_ net609 net474 net361 net681 net252 VGND VGND VPWR VPWR _1549_ sky130_fd_sc_hd__a221o_1
X_3475_ net1195 net261 _1500_ VGND VGND VPWR VPWR _0258_ sky130_fd_sc_hd__o21a_1
X_2426_ net581 net657 net518 VGND VGND VPWR VPWR _0772_ sky130_fd_sc_hd__mux2_1
XFILLER_69_453 VGND VGND VPWR VPWR sky130_fd_sc_hd__fill_1
X_2357_ net567 net637 net519 VGND VGND VPWR VPWR _0726_ sky130_fd_sc_hd__mux2_1
XFILLER_28_17 VGND VGND VPWR VPWR sky130_fd_sc_hd__decap_8
X_2288_ net682 net610 net523 VGND VGND VPWR VPWR _0677_ sky130_fd_sc_hd__mux2_1
XFILLER_71_106 VGND VGND VPWR VPWR sky130_fd_sc_hd__fill_1
X_4027_ array\[1\]\[23\] net553 net532 array\[3\]\[23\] _1942_ VGND VGND VPWR VPWR
+ _1943_ sky130_fd_sc_hd__a221o_1
XFILLER_25_534 VGND VGND VPWR VPWR sky130_fd_sc_hd__decap_4
XTAP_TAPCELL_ROW_35_551 VGND VPWR sky130_fd_sc_hd__tapvpwrvgnd_1
XFILLER_20_250 VGND VGND VPWR VPWR sky130_fd_sc_hd__fill_2
XFILLER_60_26 VGND VGND VPWR VPWR sky130_fd_sc_hd__fill_2
XFILLER_79_206 VGND VGND VPWR VPWR sky130_fd_sc_hd__decap_4
XTAP_TAPCELL_ROW_7_276 VGND VPWR sky130_fd_sc_hd__tapvpwrvgnd_1
XFILLER_28_350 VGND VGND VPWR VPWR sky130_fd_sc_hd__fill_2
XFILLER_47_169 VGND VGND VPWR VPWR sky130_fd_sc_hd__fill_1
XTAP_TAPCELL_ROW_87_1070 VGND VPWR sky130_fd_sc_hd__tapvpwrvgnd_1
XFILLER_70_161 VPWR VGND VPWR VGND sky130_ef_sc_hd__decap_12
XFILLER_70_150 VGND VGND VPWR VPWR sky130_fd_sc_hd__decap_3
XTAP_TAPCELL_ROW_61_819 VGND VPWR sky130_fd_sc_hd__tapvpwrvgnd_1
X_3260_ net590 net486 net182 net728 _1352_ VGND VGND VPWR VPWR _1353_ sky130_fd_sc_hd__a221o_1
X_2211_ head\[0\] tail\[0\] VGND VGND VPWR VPWR _0618_ sky130_fd_sc_hd__xor2_1
X_3191_ net578 net486 net182 net718 _1306_ VGND VGND VPWR VPWR _1307_ sky130_fd_sc_hd__a221o_1
XFILLER_15_3 VPWR VGND VPWR VGND sky130_ef_sc_hd__decap_12
XTAP_TAPCELL_ROW_77_974 VGND VPWR sky130_fd_sc_hd__tapvpwrvgnd_1
XFILLER_66_456 VGND VGND VPWR VPWR sky130_fd_sc_hd__fill_1
XFILLER_26_309 VGND VGND VPWR VPWR sky130_fd_sc_hd__fill_1
XFILLER_19_372 VGND VGND VPWR VPWR sky130_fd_sc_hd__decap_4
XTAP_TAPCELL_ROW_49_698 VGND VPWR sky130_fd_sc_hd__tapvpwrvgnd_1
XFILLER_34_320 VGND VGND VPWR VPWR sky130_fd_sc_hd__decap_4
XTAP_TAPCELL_ROW_32_521 VGND VPWR sky130_fd_sc_hd__tapvpwrvgnd_1
X_2975_ net676 net602 net493 VGND VGND VPWR VPWR _1156_ sky130_fd_sc_hd__mux2_1
X_4714_ clknet_leaf_21_clk _0245_ VGND VGND VPWR VPWR array\[11\]\[15\] sky130_fd_sc_hd__dfxtp_1
X_4645_ clknet_leaf_46_clk _0176_ VGND VGND VPWR VPWR array\[13\]\[10\] sky130_fd_sc_hd__dfxtp_1
XFILLER_30_18 VGND VGND VPWR VPWR sky130_fd_sc_hd__decap_8
XFILLER_30_29 VPWR VGND VPWR VGND sky130_ef_sc_hd__decap_12
X_4576_ clknet_leaf_29_clk _0107_ VGND VGND VPWR VPWR array\[15\]\[5\] sky130_fd_sc_hd__dfxtp_1
X_3527_ net621 net475 net252 net1242 _1537_ VGND VGND VPWR VPWR _0273_ sky130_fd_sc_hd__a221o_1
XFILLER_89_559 VGND VGND VPWR VPWR sky130_fd_sc_hd__fill_1
X_3458_ net731 net258 VGND VGND VPWR VPWR _1489_ sky130_fd_sc_hd__and2_1
X_3389_ net698 net363 VGND VGND VPWR VPWR _1443_ sky130_fd_sc_hd__and2_1
X_2409_ net733 net315 _0760_ net406 net312 VGND VGND VPWR VPWR _0761_ sky130_fd_sc_hd__a221o_1
XTAP_TAPCELL_ROW_4_246 VGND VPWR sky130_fd_sc_hd__tapvpwrvgnd_1
XFILLER_29_169 VGND VGND VPWR VPWR sky130_fd_sc_hd__fill_1
XFILLER_13_559 VGND VGND VPWR VPWR sky130_fd_sc_hd__fill_1
XFILLER_20_62 VGND VGND VPWR VPWR sky130_fd_sc_hd__decap_8
XFILLER_0_441 VGND VGND VPWR VPWR sky130_fd_sc_hd__decap_6
Xhold60 array\[5\]\[26\] VGND VGND VPWR VPWR net826 sky130_fd_sc_hd__dlygate4sd3_1
Xhold71 array\[13\]\[7\] VGND VGND VPWR VPWR net837 sky130_fd_sc_hd__dlygate4sd3_1
Xhold82 array\[10\]\[14\] VGND VGND VPWR VPWR net848 sky130_fd_sc_hd__dlygate4sd3_1
Xhold93 array\[7\]\[27\] VGND VGND VPWR VPWR net859 sky130_fd_sc_hd__dlygate4sd3_1
XFILLER_75_275 VGND VGND VPWR VPWR sky130_fd_sc_hd__decap_4
XTAP_TAPCELL_ROW_74_944 VGND VPWR sky130_fd_sc_hd__tapvpwrvgnd_1
XFILLER_90_289 VGND VGND VPWR VPWR sky130_fd_sc_hd__decap_4
XFILLER_16_353 VGND VGND VPWR VPWR sky130_fd_sc_hd__fill_1
XTAP_TAPCELL_ROW_46_668 VGND VPWR sky130_fd_sc_hd__tapvpwrvgnd_1
XFILLER_71_481 VGND VGND VPWR VPWR sky130_fd_sc_hd__fill_1
X_2760_ _0861_ net501 _1005_ _0863_ net502 VGND VGND VPWR VPWR _1006_ sky130_fd_sc_hd__a221o_1
X_2691_ net990 _0958_ net295 VGND VGND VPWR VPWR _0016_ sky130_fd_sc_hd__mux2_1
XANTENNA_2 _0613_ VGND VGND VPWR VPWR sky130_fd_sc_hd__diode_2
X_4430_ clknet_leaf_58_clk _0541_ VGND VGND VPWR VPWR array\[3\]\[19\] sky130_fd_sc_hd__dfxtp_1
X_4361_ clknet_leaf_1_clk _0472_ VGND VGND VPWR VPWR array\[1\]\[14\] sky130_fd_sc_hd__dfxtp_1
X_3312_ net761 net484 net369 net632 net179 VGND VGND VPWR VPWR _1390_ sky130_fd_sc_hd__a221o_1
X_4292_ net611 net430 net334 net683 net224 VGND VGND VPWR VPWR _2144_ sky130_fd_sc_hd__a221o_1
Xfanout509 net510 VGND VGND VPWR VPWR net509 sky130_fd_sc_hd__clkbuf_4
X_3243_ net774 _1341_ net157 VGND VGND VPWR VPWR _0185_ sky130_fd_sc_hd__mux2_1
XTAP_TAPCELL_ROW_1_216 VGND VPWR sky130_fd_sc_hd__tapvpwrvgnd_1
X_3174_ net937 net162 _1292_ VGND VGND VPWR VPWR _0165_ sky130_fd_sc_hd__o21a_1
XTAP_TAPCELL_ROW_17_370 VGND VPWR sky130_fd_sc_hd__tapvpwrvgnd_1
XFILLER_22_334 VGND VGND VPWR VPWR sky130_fd_sc_hd__decap_3
X_2958_ _1137_ _1138_ _1139_ VGND VGND VPWR VPWR _1140_ sky130_fd_sc_hd__and3_1
X_2889_ net623 net695 net498 VGND VGND VPWR VPWR _1093_ sky130_fd_sc_hd__mux2_1
X_4628_ clknet_leaf_44_clk _0159_ VGND VGND VPWR VPWR array\[14\]\[25\] sky130_fd_sc_hd__dfxtp_1
Xhold530 array\[2\]\[9\] VGND VGND VPWR VPWR net1296 sky130_fd_sc_hd__dlygate4sd3_1
Xhold552 array\[12\]\[13\] VGND VGND VPWR VPWR net1318 sky130_fd_sc_hd__dlygate4sd3_1
XFILLER_1_216 VGND VGND VPWR VPWR sky130_fd_sc_hd__decap_8
XFILLER_1_205 VGND VGND VPWR VPWR sky130_fd_sc_hd__decap_4
Xhold541 array\[6\]\[0\] VGND VGND VPWR VPWR net1307 sky130_fd_sc_hd__dlygate4sd3_1
X_4559_ clknet_leaf_6_clk _0090_ VGND VGND VPWR VPWR array\[0\]\[20\] sky130_fd_sc_hd__dfxtp_1
XFILLER_1_249 VGND VGND VPWR VPWR sky130_fd_sc_hd__decap_4
XFILLER_89_389 VGND VGND VPWR VPWR sky130_fd_sc_hd__decap_3
XFILLER_89_367 VGND VGND VPWR VPWR sky130_fd_sc_hd__fill_1
XFILLER_77_518 VPWR VGND VPWR VGND sky130_ef_sc_hd__decap_12
XFILLER_66_47 VGND VGND VPWR VPWR sky130_fd_sc_hd__fill_1
XFILLER_45_437 VGND VGND VPWR VPWR sky130_fd_sc_hd__decap_8
XTAP_TAPCELL_ROW_84_1040 VGND VPWR sky130_fd_sc_hd__tapvpwrvgnd_1
XTAP_TAPCELL_ROW_71_914 VGND VPWR sky130_fd_sc_hd__tapvpwrvgnd_1
XTAP_TAPCELL_ROW_43_638 VGND VPWR sky130_fd_sc_hd__tapvpwrvgnd_1
XFILLER_9_305 VGND VGND VPWR VPWR sky130_fd_sc_hd__decap_3
XFILLER_40_197 VGND VGND VPWR VPWR sky130_fd_sc_hd__decap_8
XFILLER_31_50 VGND VGND VPWR VPWR sky130_fd_sc_hd__fill_2
XFILLER_76_540 VPWR VGND VPWR VGND sky130_ef_sc_hd__decap_12
XFILLER_0_293 VGND VGND VPWR VPWR sky130_fd_sc_hd__decap_4
XFILLER_48_253 VPWR VGND VPWR VGND sky130_ef_sc_hd__decap_12
XTAP_TAPCELL_ROW_59_793 VGND VPWR sky130_fd_sc_hd__tapvpwrvgnd_1
XFILLER_63_234 VGND VGND VPWR VPWR sky130_fd_sc_hd__fill_1
X_3930_ array\[6\]\[14\] net457 net440 array\[4\]\[14\] VGND VGND VPWR VPWR _1855_
+ sky130_fd_sc_hd__a22o_1
X_3861_ array\[5\]\[8\] net557 net541 array\[7\]\[8\] _1791_ VGND VGND VPWR VPWR _1792_
+ sky130_fd_sc_hd__a221o_1
XTAP_TAPCELL_ROW_14_340 VGND VPWR sky130_fd_sc_hd__tapvpwrvgnd_1
XFILLER_82_3 VPWR VGND VPWR VGND sky130_ef_sc_hd__decap_12
X_2812_ net745 net281 VGND VGND VPWR VPWR _1041_ sky130_fd_sc_hd__and2_1
X_3792_ array\[6\]\[2\] net465 net448 array\[4\]\[2\] VGND VGND VPWR VPWR _1729_ sky130_fd_sc_hd__a22o_1
X_2743_ net658 net582 net393 VGND VGND VPWR VPWR _0993_ sky130_fd_sc_hd__mux2_1
X_2674_ net637 net567 net393 VGND VGND VPWR VPWR _0947_ sky130_fd_sc_hd__mux2_1
X_4413_ clknet_leaf_38_clk _0524_ VGND VGND VPWR VPWR array\[3\]\[2\] sky130_fd_sc_hd__dfxtp_1
X_4344_ clknet_leaf_61_clk _0455_ VGND VGND VPWR VPWR _0002_ sky130_fd_sc_hd__dfxtp_1
Xfanout306 _0789_ VGND VGND VPWR VPWR net306 sky130_fd_sc_hd__buf_4
Xfanout328 net330 VGND VGND VPWR VPWR net328 sky130_fd_sc_hd__clkbuf_4
Xfanout317 net318 VGND VGND VPWR VPWR net317 sky130_fd_sc_hd__buf_4
X_4275_ net623 net429 net333 net695 net223 VGND VGND VPWR VPWR _2133_ sky130_fd_sc_hd__a221o_1
XFILLER_86_359 VGND VGND VPWR VPWR sky130_fd_sc_hd__decap_4
XFILLER_39_231 VGND VGND VPWR VPWR sky130_fd_sc_hd__fill_1
X_3226_ net687 net371 VGND VGND VPWR VPWR _1330_ sky130_fd_sc_hd__and2_1
X_3157_ net588 net489 net378 net662 VGND VGND VPWR VPWR _1281_ sky130_fd_sc_hd__a22o_1
X_3088_ net571 net490 net375 net641 VGND VGND VPWR VPWR _1235_ sky130_fd_sc_hd__a22o_1
XTAP_TAPCELL_ROW_40_608 VGND VPWR sky130_fd_sc_hd__tapvpwrvgnd_1
XFILLER_22_197 VGND VGND VPWR VPWR sky130_fd_sc_hd__decap_3
Xhold360 array\[10\]\[7\] VGND VGND VPWR VPWR net1126 sky130_fd_sc_hd__dlygate4sd3_1
XFILLER_2_525 VGND VGND VPWR VPWR sky130_fd_sc_hd__decap_6
Xhold371 array\[6\]\[1\] VGND VGND VPWR VPWR net1137 sky130_fd_sc_hd__dlygate4sd3_1
Xhold382 array\[11\]\[19\] VGND VGND VPWR VPWR net1148 sky130_fd_sc_hd__dlygate4sd3_1
Xhold393 array\[9\]\[14\] VGND VGND VPWR VPWR net1159 sky130_fd_sc_hd__dlygate4sd3_1
XFILLER_77_57 VPWR VGND VPWR VGND sky130_ef_sc_hd__decap_12
XFILLER_45_223 VGND VGND VPWR VPWR sky130_fd_sc_hd__fill_1
XTAP_TAPCELL_ROW_56_763 VGND VPWR sky130_fd_sc_hd__tapvpwrvgnd_1
XFILLER_26_470 VGND VGND VPWR VPWR sky130_fd_sc_hd__decap_6
XTAP_TAPCELL_ROW_28_487 VGND VPWR sky130_fd_sc_hd__tapvpwrvgnd_1
XFILLER_9_113 VPWR VGND VPWR VGND sky130_ef_sc_hd__decap_12
XTAP_TAPCELL_ROW_11_310 VGND VPWR sky130_fd_sc_hd__tapvpwrvgnd_1
XFILLER_42_82 VGND VGND VPWR VPWR sky130_fd_sc_hd__fill_2
XTAP_TAPCELL_ROW_93_1139 VGND VPWR sky130_fd_sc_hd__tapvpwrvgnd_1
XFILLER_47_6 VPWR VGND VPWR VGND sky130_ef_sc_hd__decap_12
X_2390_ net611 net683 net519 VGND VGND VPWR VPWR _0748_ sky130_fd_sc_hd__mux2_1
X_4060_ array\[1\]\[26\] net555 net536 array\[3\]\[26\] _1972_ VGND VGND VPWR VPWR
+ _1973_ sky130_fd_sc_hd__a221o_1
XFILLER_3_98 VGND VGND VPWR VPWR sky130_fd_sc_hd__fill_1
X_3011_ net689 net617 net495 VGND VGND VPWR VPWR _1180_ sky130_fd_sc_hd__mux2_1
XFILLER_51_237 VGND VGND VPWR VPWR sky130_fd_sc_hd__fill_1
X_3913_ array\[6\]\[13\] net459 net442 array\[4\]\[13\] VGND VGND VPWR VPWR _1839_
+ sky130_fd_sc_hd__a22o_1
X_4893_ clknet_leaf_42_clk _0424_ VGND VGND VPWR VPWR array\[6\]\[4\] sky130_fd_sc_hd__dfxtp_1
X_3844_ array\[6\]\[7\] net458 net441 array\[4\]\[7\] VGND VGND VPWR VPWR _1776_ sky130_fd_sc_hd__a22o_1
X_3775_ net842 net169 _1712_ _1713_ VGND VGND VPWR VPWR _0345_ sky130_fd_sc_hd__o22a_1
X_2726_ net734 net289 _0981_ net387 VGND VGND VPWR VPWR _0982_ sky130_fd_sc_hd__a22o_1
X_2657_ net105 _0636_ _0638_ VGND VGND VPWR VPWR _0935_ sky130_fd_sc_hd__and3_1
X_2588_ net1169 net299 _0887_ _0888_ VGND VGND VPWR VPWR _0563_ sky130_fd_sc_hd__o22a_1
X_4327_ net580 net429 net333 net650 net223 VGND VGND VPWR VPWR _2166_ sky130_fd_sc_hd__a221o_1
Xfanout158 _1299_ VGND VGND VPWR VPWR net158 sky130_fd_sc_hd__buf_2
Xfanout169 _0604_ VGND VGND VPWR VPWR net169 sky130_fd_sc_hd__buf_4
X_4258_ net710 net337 VGND VGND VPWR VPWR _2122_ sky130_fd_sc_hd__and2_1
XFILLER_86_167 VGND VGND VPWR VPWR sky130_fd_sc_hd__decap_3
XFILLER_74_307 VGND VGND VPWR VPWR sky130_fd_sc_hd__fill_1
X_3209_ net761 net488 net184 net702 _1318_ VGND VGND VPWR VPWR _1319_ sky130_fd_sc_hd__a221o_1
X_4189_ net1247 net225 _2074_ _2075_ VGND VGND VPWR VPWR _0401_ sky130_fd_sc_hd__o22a_1
XFILLER_27_223 VGND VGND VPWR VPWR sky130_fd_sc_hd__fill_1
XTAP_TAPCELL_ROW_53_733 VGND VPWR sky130_fd_sc_hd__tapvpwrvgnd_1
XTAP_TAPCELL_ROW_81_1010 VGND VPWR sky130_fd_sc_hd__tapvpwrvgnd_1
XTAP_TAPCELL_ROW_25_457 VGND VPWR sky130_fd_sc_hd__tapvpwrvgnd_1
XFILLER_42_248 VGND VGND VPWR VPWR sky130_fd_sc_hd__decap_4
XFILLER_23_462 VPWR VGND VPWR VGND sky130_ef_sc_hd__decap_12
Xhold190 array\[7\]\[17\] VGND VGND VPWR VPWR net956 sky130_fd_sc_hd__dlygate4sd3_1
Xfanout692 net42 VGND VGND VPWR VPWR net692 sky130_fd_sc_hd__dlymetal6s2s_1
Xfanout681 net47 VGND VGND VPWR VPWR net681 sky130_fd_sc_hd__buf_2
Xfanout670 net53 VGND VGND VPWR VPWR net670 sky130_fd_sc_hd__dlymetal6s2s_1
XPHY_EDGE_ROW_16_Right_16 VGND VGND VPWR VPWR sky130_fd_sc_hd__decap_3
XFILLER_61_513 VGND VGND VPWR VPWR sky130_fd_sc_hd__decap_6
XFILLER_41_270 VGND VGND VPWR VPWR sky130_fd_sc_hd__fill_1
X_3560_ net1173 net249 _1559_ VGND VGND VPWR VPWR _0284_ sky130_fd_sc_hd__o21a_1
XPHY_EDGE_ROW_25_Right_25 VGND VGND VPWR VPWR sky130_fd_sc_hd__decap_3
X_2511_ net671 net597 net514 VGND VGND VPWR VPWR _0832_ sky130_fd_sc_hd__mux2_1
X_3491_ _1508_ _1509_ VGND VGND VPWR VPWR _1513_ sky130_fd_sc_hd__and2_1
X_2442_ net103 net104 VGND VGND VPWR VPWR _0784_ sky130_fd_sc_hd__and2_1
X_2373_ net607 net316 _0736_ net408 net313 VGND VGND VPWR VPWR _0737_ sky130_fd_sc_hd__a221o_1
X_4112_ array\[5\]\[30\] net554 net538 array\[7\]\[30\] _2020_ VGND VGND VPWR VPWR
+ _2021_ sky130_fd_sc_hd__a221o_1
X_4043_ array\[6\]\[24\] net470 net453 array\[4\]\[24\] VGND VGND VPWR VPWR _1958_
+ sky130_fd_sc_hd__a22o_1
XFILLER_83_137 VGND VGND VPWR VPWR sky130_fd_sc_hd__fill_2
XPHY_EDGE_ROW_34_Right_34 VGND VGND VPWR VPWR sky130_fd_sc_hd__decap_3
XTAP_TAPCELL_ROW_50_703 VGND VPWR sky130_fd_sc_hd__tapvpwrvgnd_1
XTAP_TAPCELL_ROW_22_427 VGND VPWR sky130_fd_sc_hd__tapvpwrvgnd_1
X_4876_ clknet_leaf_56_clk _0407_ VGND VGND VPWR VPWR array\[7\]\[19\] sky130_fd_sc_hd__dfxtp_1
X_3827_ array\[1\]\[5\] net557 net541 array\[3\]\[5\] _1760_ VGND VGND VPWR VPWR _1761_
+ sky130_fd_sc_hd__a221o_1
XPHY_EDGE_ROW_43_Right_43 VGND VGND VPWR VPWR sky130_fd_sc_hd__decap_3
X_3758_ net1201 net238 _1698_ _1699_ VGND VGND VPWR VPWR _0342_ sky130_fd_sc_hd__o22a_1
X_2709_ net890 _0970_ net296 VGND VGND VPWR VPWR _0022_ sky130_fd_sc_hd__mux2_1
X_3689_ net1004 net238 _1653_ _1654_ VGND VGND VPWR VPWR _0318_ sky130_fd_sc_hd__o22a_1
XFILLER_58_15 VPWR VGND VPWR VGND sky130_ef_sc_hd__decap_12
XPHY_EDGE_ROW_52_Right_52 VGND VGND VPWR VPWR sky130_fd_sc_hd__decap_3
XTAP_TAPCELL_ROW_38_582 VGND VPWR sky130_fd_sc_hd__tapvpwrvgnd_1
XFILLER_55_362 VGND VGND VPWR VPWR sky130_fd_sc_hd__decap_8
XFILLER_11_421 VPWR VGND VPWR VGND sky130_ef_sc_hd__decap_12
XPHY_EDGE_ROW_4_Left_99 VGND VGND VPWR VPWR sky130_fd_sc_hd__decap_3
XPHY_EDGE_ROW_61_Right_61 VGND VGND VPWR VPWR sky130_fd_sc_hd__decap_3
XTAP_TAPCELL_ROW_90_1109 VGND VPWR sky130_fd_sc_hd__tapvpwrvgnd_1
XFILLER_78_421 VGND VGND VPWR VPWR sky130_fd_sc_hd__fill_1
XPHY_EDGE_ROW_70_Right_70 VGND VGND VPWR VPWR sky130_fd_sc_hd__decap_3
XFILLER_2_141 VPWR VGND VPWR VGND sky130_ef_sc_hd__decap_12
XFILLER_19_532 VGND VGND VPWR VPWR sky130_fd_sc_hd__decap_8
XFILLER_19_554 VGND VGND VPWR VPWR sky130_fd_sc_hd__decap_3
XFILLER_0_77 VGND VGND VPWR VPWR sky130_fd_sc_hd__decap_6
X_2991_ net705 net195 _1166_ net381 VGND VGND VPWR VPWR _1167_ sky130_fd_sc_hd__a22o_1
XFILLER_14_270 VGND VGND VPWR VPWR sky130_fd_sc_hd__fill_1
X_4730_ clknet_leaf_49_clk _0261_ VGND VGND VPWR VPWR array\[11\]\[31\] sky130_fd_sc_hd__dfxtp_1
X_4661_ clknet_leaf_15_clk _0192_ VGND VGND VPWR VPWR array\[13\]\[26\] sky130_fd_sc_hd__dfxtp_1
X_3612_ net211 _1595_ VGND VGND VPWR VPWR _1596_ sky130_fd_sc_hd__or2_1
X_4592_ clknet_leaf_0_clk _0123_ VGND VGND VPWR VPWR array\[15\]\[21\] sky130_fd_sc_hd__dfxtp_1
X_3543_ net745 net247 VGND VGND VPWR VPWR _1548_ sky130_fd_sc_hd__and2_1
X_3474_ net721 net257 _1499_ net265 VGND VGND VPWR VPWR _1500_ sky130_fd_sc_hd__a211o_1
X_2425_ net869 net209 _0771_ VGND VGND VPWR VPWR _0517_ sky130_fd_sc_hd__o21a_1
XFILLER_28_29 VPWR VGND VPWR VGND sky130_ef_sc_hd__decap_12
X_2356_ net1099 net208 _0725_ VGND VGND VPWR VPWR _0494_ sky130_fd_sc_hd__o21a_1
X_2287_ net908 net325 _0676_ VGND VGND VPWR VPWR _0474_ sky130_fd_sc_hd__o21a_1
X_4026_ array\[2\]\[23\] net466 net449 array\[0\]\[23\] VGND VGND VPWR VPWR _1942_
+ sky130_fd_sc_hd__a22o_1
XFILLER_52_321 VGND VGND VPWR VPWR sky130_fd_sc_hd__decap_8
XFILLER_52_343 VGND VGND VPWR VPWR sky130_fd_sc_hd__fill_1
XTAP_TAPCELL_ROW_35_552 VGND VPWR sky130_fd_sc_hd__tapvpwrvgnd_1
XFILLER_52_365 VGND VGND VPWR VPWR sky130_fd_sc_hd__decap_6
X_4859_ clknet_leaf_39_clk _0390_ VGND VGND VPWR VPWR array\[7\]\[2\] sky130_fd_sc_hd__dfxtp_1
Xclkbuf_3_0__f_clk clknet_0_clk VGND VGND VPWR VPWR clknet_3_0__leaf_clk sky130_fd_sc_hd__clkbuf_16
XFILLER_69_47 VGND VGND VPWR VPWR sky130_fd_sc_hd__fill_1
XFILLER_87_240 VGND VGND VPWR VPWR sky130_fd_sc_hd__decap_4
XTAP_TAPCELL_ROW_7_277 VGND VPWR sky130_fd_sc_hd__tapvpwrvgnd_1
XFILLER_85_57 VPWR VGND VPWR VGND sky130_ef_sc_hd__decap_12
XTAP_TAPCELL_ROW_87_1071 VGND VPWR sky130_fd_sc_hd__tapvpwrvgnd_1
XFILLER_28_395 VGND VGND VPWR VPWR sky130_fd_sc_hd__decap_8
XFILLER_31_505 VGND VGND VPWR VPWR sky130_fd_sc_hd__decap_8
XFILLER_70_173 VPWR VGND VPWR VGND sky130_ef_sc_hd__decap_12
XFILLER_7_222 VGND VGND VPWR VPWR sky130_fd_sc_hd__fill_2
Xwire197 net198 VGND VGND VPWR VPWR net197 sky130_fd_sc_hd__clkbuf_2
XFILLER_3_461 VPWR VGND VPWR VGND sky130_ef_sc_hd__decap_12
X_2210_ tail\[2\] _0610_ VGND VGND VPWR VPWR _0617_ sky130_fd_sc_hd__xnor2_1
XFILLER_78_240 VGND VGND VPWR VPWR sky130_fd_sc_hd__decap_3
X_3190_ net648 net371 VGND VGND VPWR VPWR _1306_ sky130_fd_sc_hd__and2_1
XTAP_TAPCELL_ROW_77_975 VGND VPWR sky130_fd_sc_hd__tapvpwrvgnd_1
XTAP_TAPCELL_ROW_49_699 VGND VPWR sky130_fd_sc_hd__tapvpwrvgnd_1
X_2974_ net1032 _1155_ net165 VGND VGND VPWR VPWR _0102_ sky130_fd_sc_hd__mux2_1
XTAP_TAPCELL_ROW_32_522 VGND VPWR sky130_fd_sc_hd__tapvpwrvgnd_1
XFILLER_61_195 VGND VGND VPWR VPWR sky130_fd_sc_hd__fill_2
X_4713_ clknet_leaf_3_clk _0244_ VGND VGND VPWR VPWR array\[11\]\[14\] sky130_fd_sc_hd__dfxtp_1
X_4644_ clknet_leaf_50_clk _0175_ VGND VGND VPWR VPWR array\[13\]\[9\] sky130_fd_sc_hd__dfxtp_1
X_4575_ clknet_leaf_43_clk _0106_ VGND VGND VPWR VPWR array\[15\]\[4\] sky130_fd_sc_hd__dfxtp_1
XFILLER_89_505 VPWR VGND VPWR VGND sky130_ef_sc_hd__decap_12
X_3526_ net585 net246 net360 net693 VGND VGND VPWR VPWR _1537_ sky130_fd_sc_hd__a22o_1
X_3457_ net971 net259 _1488_ VGND VGND VPWR VPWR _0252_ sky130_fd_sc_hd__o21a_1
X_3388_ net477 net501 net107 net756 VGND VGND VPWR VPWR _1442_ sky130_fd_sc_hd__and4b_4
X_2408_ net595 net669 net517 VGND VGND VPWR VPWR _0760_ sky130_fd_sc_hd__mux2_1
XFILLER_57_402 VGND VGND VPWR VPWR sky130_fd_sc_hd__fill_1
XFILLER_84_210 VGND VGND VPWR VPWR sky130_fd_sc_hd__fill_1
XTAP_TAPCELL_ROW_4_247 VGND VPWR sky130_fd_sc_hd__tapvpwrvgnd_1
X_2339_ net625 net697 net517 VGND VGND VPWR VPWR _0713_ sky130_fd_sc_hd__mux2_1
XPHY_EDGE_ROW_2_Right_2 VGND VGND VPWR VPWR sky130_fd_sc_hd__decap_3
XFILLER_57_457 VGND VGND VPWR VPWR sky130_fd_sc_hd__decap_6
XFILLER_57_479 VPWR VGND VPWR VGND sky130_ef_sc_hd__decap_12
XFILLER_72_405 VGND VGND VPWR VPWR sky130_fd_sc_hd__fill_1
X_4009_ array\[10\]\[21\] net457 net440 array\[8\]\[21\] VGND VGND VPWR VPWR _1927_
+ sky130_fd_sc_hd__a22o_1
XFILLER_55_38 VGND VGND VPWR VPWR sky130_fd_sc_hd__fill_2
Xclkbuf_leaf_64_clk clknet_3_0__leaf_clk VGND VGND VPWR VPWR clknet_leaf_64_clk sky130_fd_sc_hd__clkbuf_8
XFILLER_13_505 VPWR VGND VPWR VGND sky130_ef_sc_hd__decap_12
XFILLER_80_493 VPWR VGND VPWR VGND sky130_ef_sc_hd__decap_12
XFILLER_71_15 VPWR VGND VPWR VGND sky130_ef_sc_hd__decap_12
XFILLER_4_247 VGND VGND VPWR VPWR sky130_fd_sc_hd__decap_4
XFILLER_20_85 VPWR VGND VPWR VGND sky130_ef_sc_hd__decap_12
Xhold50 array\[5\]\[30\] VGND VGND VPWR VPWR net816 sky130_fd_sc_hd__dlygate4sd3_1
Xhold72 array\[13\]\[13\] VGND VGND VPWR VPWR net838 sky130_fd_sc_hd__dlygate4sd3_1
Xhold83 array\[15\]\[31\] VGND VGND VPWR VPWR net849 sky130_fd_sc_hd__dlygate4sd3_1
Xhold61 array\[13\]\[24\] VGND VGND VPWR VPWR net827 sky130_fd_sc_hd__dlygate4sd3_1
Xhold94 net118 VGND VGND VPWR VPWR net860 sky130_fd_sc_hd__dlygate4sd3_1
XTAP_TAPCELL_ROW_74_945 VGND VPWR sky130_fd_sc_hd__tapvpwrvgnd_1
Xclkbuf_leaf_55_clk clknet_3_1__leaf_clk VGND VGND VPWR VPWR clknet_leaf_55_clk sky130_fd_sc_hd__clkbuf_8
XFILLER_43_151 VGND VGND VPWR VPWR sky130_fd_sc_hd__fill_1
XFILLER_45_82 VGND VGND VPWR VPWR sky130_fd_sc_hd__decap_3
XTAP_TAPCELL_ROW_46_669 VGND VPWR sky130_fd_sc_hd__tapvpwrvgnd_1
XFILLER_31_335 VGND VGND VPWR VPWR sky130_fd_sc_hd__fill_1
XFILLER_43_195 VGND VGND VPWR VPWR sky130_fd_sc_hd__decap_4
XFILLER_8_531 VGND VGND VPWR VPWR sky130_fd_sc_hd__fill_1
XFILLER_77_6 VPWR VGND VPWR VGND sky130_ef_sc_hd__decap_12
X_2690_ net608 net291 _0957_ net389 VGND VGND VPWR VPWR _0958_ sky130_fd_sc_hd__a22o_1
XFILLER_61_81 VGND VGND VPWR VPWR sky130_fd_sc_hd__fill_1
XANTENNA_3 _0613_ VGND VGND VPWR VPWR sky130_fd_sc_hd__diode_2
X_4360_ clknet_leaf_13_clk _0471_ VGND VGND VPWR VPWR array\[1\]\[13\] sky130_fd_sc_hd__dfxtp_1
X_3311_ net702 net175 VGND VGND VPWR VPWR _1389_ sky130_fd_sc_hd__and2_1
X_4291_ net747 net338 VGND VGND VPWR VPWR _2143_ sky130_fd_sc_hd__and2_1
X_3242_ net603 net485 net181 net741 _1340_ VGND VGND VPWR VPWR _1341_ sky130_fd_sc_hd__a221o_1
X_3173_ net714 net186 _1291_ net190 VGND VGND VPWR VPWR _1292_ sky130_fd_sc_hd__a211o_1
XFILLER_94_530 VGND VGND VPWR VPWR sky130_fd_sc_hd__fill_2
XFILLER_39_446 VGND VGND VPWR VPWR sky130_fd_sc_hd__fill_2
XTAP_TAPCELL_ROW_1_217 VGND VPWR sky130_fd_sc_hd__tapvpwrvgnd_1
Xclkbuf_leaf_46_clk clknet_3_2__leaf_clk VGND VGND VPWR VPWR clknet_leaf_46_clk sky130_fd_sc_hd__clkbuf_8
XFILLER_81_279 VGND VGND VPWR VPWR sky130_fd_sc_hd__fill_1
XTAP_TAPCELL_ROW_17_371 VGND VPWR sky130_fd_sc_hd__tapvpwrvgnd_1
X_2957_ net525 _0635_ VGND VGND VPWR VPWR _1139_ sky130_fd_sc_hd__nand2_1
X_2888_ net996 net200 _1092_ VGND VGND VPWR VPWR _0079_ sky130_fd_sc_hd__o21a_1
X_4627_ clknet_leaf_32_clk _0158_ VGND VGND VPWR VPWR array\[14\]\[24\] sky130_fd_sc_hd__dfxtp_1
Xhold520 array\[9\]\[1\] VGND VGND VPWR VPWR net1286 sky130_fd_sc_hd__dlygate4sd3_1
Xhold542 array\[7\]\[11\] VGND VGND VPWR VPWR net1308 sky130_fd_sc_hd__dlygate4sd3_1
X_4558_ clknet_leaf_56_clk _0089_ VGND VGND VPWR VPWR array\[0\]\[19\] sky130_fd_sc_hd__dfxtp_1
Xhold531 array\[0\]\[21\] VGND VGND VPWR VPWR net1297 sky130_fd_sc_hd__dlygate4sd3_1
Xhold553 array\[12\]\[23\] VGND VGND VPWR VPWR net1319 sky130_fd_sc_hd__dlygate4sd3_1
XFILLER_89_335 VGND VGND VPWR VPWR sky130_fd_sc_hd__fill_1
X_3509_ net567 net474 net361 net637 net253 VGND VGND VPWR VPWR _1526_ sky130_fd_sc_hd__a221o_1
X_4489_ clknet_leaf_3_clk _0020_ VGND VGND VPWR VPWR array\[5\]\[14\] sky130_fd_sc_hd__dfxtp_1
XFILLER_66_26 VGND VGND VPWR VPWR sky130_fd_sc_hd__fill_2
XFILLER_85_541 VPWR VGND VPWR VGND sky130_ef_sc_hd__decap_12
XFILLER_57_276 VGND VGND VPWR VPWR sky130_fd_sc_hd__decap_4
XFILLER_45_449 VPWR VGND VPWR VGND sky130_ef_sc_hd__decap_12
Xclkbuf_leaf_37_clk clknet_3_6__leaf_clk VGND VGND VPWR VPWR clknet_leaf_37_clk sky130_fd_sc_hd__clkbuf_8
XTAP_TAPCELL_ROW_84_1041 VGND VPWR sky130_fd_sc_hd__tapvpwrvgnd_1
XTAP_TAPCELL_ROW_71_915 VGND VPWR sky130_fd_sc_hd__tapvpwrvgnd_1
XTAP_TAPCELL_ROW_43_639 VGND VPWR sky130_fd_sc_hd__tapvpwrvgnd_1
XFILLER_15_63 VGND VGND VPWR VPWR sky130_fd_sc_hd__decap_4
XFILLER_13_335 VGND VGND VPWR VPWR sky130_fd_sc_hd__fill_1
XFILLER_0_272 VGND VGND VPWR VPWR sky130_fd_sc_hd__decap_4
XFILLER_76_552 VGND VGND VPWR VPWR sky130_fd_sc_hd__decap_8
XFILLER_91_500 VGND VGND VPWR VPWR sky130_fd_sc_hd__decap_4
XFILLER_48_265 VGND VGND VPWR VPWR sky130_fd_sc_hd__decap_4
Xclkbuf_leaf_28_clk clknet_3_7__leaf_clk VGND VGND VPWR VPWR clknet_leaf_28_clk sky130_fd_sc_hd__clkbuf_8
XTAP_TAPCELL_ROW_59_794 VGND VPWR sky130_fd_sc_hd__tapvpwrvgnd_1
XFILLER_63_257 VGND VGND VPWR VPWR sky130_fd_sc_hd__decap_4
XFILLER_44_482 VGND VGND VPWR VPWR sky130_fd_sc_hd__fill_2
X_3860_ array\[6\]\[8\] net471 net454 array\[4\]\[8\] VGND VGND VPWR VPWR _1791_ sky130_fd_sc_hd__a22o_1
XFILLER_71_290 VGND VGND VPWR VPWR sky130_fd_sc_hd__fill_1
XTAP_TAPCELL_ROW_14_341 VGND VPWR sky130_fd_sc_hd__tapvpwrvgnd_1
X_3791_ array\[9\]\[2\] net551 net531 array\[11\]\[2\] _1727_ VGND VGND VPWR VPWR
+ _1728_ sky130_fd_sc_hd__a221o_1
X_2811_ net1127 net287 net281 net747 _1040_ VGND VGND VPWR VPWR _0054_ sky130_fd_sc_hd__a221o_1
X_2742_ net856 _0992_ net296 VGND VGND VPWR VPWR _0033_ sky130_fd_sc_hd__mux2_1
XFILLER_75_3 VPWR VGND VPWR VGND sky130_ef_sc_hd__decap_12
X_2673_ net844 _0946_ net295 VGND VGND VPWR VPWR _0010_ sky130_fd_sc_hd__mux2_1
X_4412_ clknet_leaf_19_clk _0523_ VGND VGND VPWR VPWR array\[3\]\[1\] sky130_fd_sc_hd__dfxtp_1
X_4343_ clknet_leaf_63_clk _0454_ VGND VGND VPWR VPWR _0001_ sky130_fd_sc_hd__dfxtp_1
Xfanout329 net330 VGND VGND VPWR VPWR net329 sky130_fd_sc_hd__clkbuf_4
Xfanout307 _0789_ VGND VGND VPWR VPWR net307 sky130_fd_sc_hd__clkbuf_2
X_4274_ net607 net337 VGND VGND VPWR VPWR _2132_ sky130_fd_sc_hd__and2_1
Xfanout318 _0712_ VGND VGND VPWR VPWR net318 sky130_fd_sc_hd__clkbuf_4
X_3225_ net838 _1329_ net159 VGND VGND VPWR VPWR _0179_ sky130_fd_sc_hd__mux2_1
XPHY_EDGE_ROW_6_Left_101 VGND VGND VPWR VPWR sky130_fd_sc_hd__decap_3
X_3156_ net1020 net162 _1280_ VGND VGND VPWR VPWR _0159_ sky130_fd_sc_hd__o21a_1
XFILLER_36_18 VGND VGND VPWR VPWR sky130_fd_sc_hd__decap_8
XFILLER_82_533 VPWR VGND VPWR VGND sky130_ef_sc_hd__decap_12
XFILLER_82_522 VGND VGND VPWR VPWR sky130_fd_sc_hd__decap_8
XFILLER_36_29 VGND VGND VPWR VPWR sky130_fd_sc_hd__decap_6
X_3087_ net1171 net162 _1234_ VGND VGND VPWR VPWR _0136_ sky130_fd_sc_hd__o21a_1
Xclkbuf_leaf_19_clk clknet_3_4__leaf_clk VGND VGND VPWR VPWR clknet_leaf_19_clk sky130_fd_sc_hd__clkbuf_8
XFILLER_22_110 VPWR VGND VPWR VGND sky130_ef_sc_hd__decap_12
XFILLER_50_452 VGND VGND VPWR VPWR sky130_fd_sc_hd__fill_1
XTAP_TAPCELL_ROW_40_609 VGND VPWR sky130_fd_sc_hd__tapvpwrvgnd_1
X_3989_ net415 _1903_ _1907_ net435 VGND VGND VPWR VPWR _1909_ sky130_fd_sc_hd__a22o_1
Xhold350 array\[8\]\[18\] VGND VGND VPWR VPWR net1116 sky130_fd_sc_hd__dlygate4sd3_1
Xhold361 array\[8\]\[16\] VGND VGND VPWR VPWR net1127 sky130_fd_sc_hd__dlygate4sd3_1
Xhold394 array\[10\]\[27\] VGND VGND VPWR VPWR net1160 sky130_fd_sc_hd__dlygate4sd3_1
Xhold372 array\[7\]\[29\] VGND VGND VPWR VPWR net1138 sky130_fd_sc_hd__dlygate4sd3_1
Xhold383 array\[14\]\[20\] VGND VGND VPWR VPWR net1149 sky130_fd_sc_hd__dlygate4sd3_1
XFILLER_77_69 VGND VGND VPWR VPWR sky130_fd_sc_hd__decap_4
XFILLER_18_416 VGND VGND VPWR VPWR sky130_fd_sc_hd__decap_4
XFILLER_93_57 VPWR VGND VPWR VGND sky130_ef_sc_hd__decap_12
XFILLER_85_393 VGND VGND VPWR VPWR sky130_fd_sc_hd__decap_6
XTAP_TAPCELL_ROW_56_764 VGND VPWR sky130_fd_sc_hd__tapvpwrvgnd_1
XTAP_TAPCELL_ROW_28_488 VGND VPWR sky130_fd_sc_hd__tapvpwrvgnd_1
XFILLER_9_125 VPWR VGND VPWR VGND sky130_ef_sc_hd__decap_12
XFILLER_41_463 VGND VGND VPWR VPWR sky130_fd_sc_hd__decap_3
XTAP_TAPCELL_ROW_11_311 VGND VPWR sky130_fd_sc_hd__tapvpwrvgnd_1
XPHY_EDGE_ROW_79_Left_174 VGND VGND VPWR VPWR sky130_fd_sc_hd__decap_3
X_3010_ net935 _1179_ net167 VGND VGND VPWR VPWR _0114_ sky130_fd_sc_hd__mux2_1
XFILLER_24_408 VPWR VGND VPWR VGND sky130_ef_sc_hd__decap_12
XFILLER_51_205 VGND VGND VPWR VPWR sky130_fd_sc_hd__fill_1
X_3912_ net825 net170 _1837_ _1838_ VGND VGND VPWR VPWR _0357_ sky130_fd_sc_hd__o22a_1
X_4892_ clknet_leaf_5_clk _0423_ VGND VGND VPWR VPWR array\[6\]\[3\] sky130_fd_sc_hd__dfxtp_1
XPHY_EDGE_ROW_88_Left_183 VGND VGND VPWR VPWR sky130_fd_sc_hd__decap_3
X_3843_ net771 net169 _1774_ _1775_ VGND VGND VPWR VPWR _0351_ sky130_fd_sc_hd__o22a_1
XFILLER_32_485 VPWR VGND VPWR VGND sky130_ef_sc_hd__decap_12
X_3774_ net415 _1707_ _1711_ net435 net213 VGND VGND VPWR VPWR _1713_ sky130_fd_sc_hd__a221o_1
X_2725_ net670 net596 net391 VGND VGND VPWR VPWR _0981_ sky130_fd_sc_hd__mux2_1
X_2656_ net698 net626 net391 VGND VGND VPWR VPWR _0934_ sky130_fd_sc_hd__mux2_1
Xclkbuf_leaf_8_clk clknet_3_4__leaf_clk VGND VGND VPWR VPWR clknet_leaf_8_clk sky130_fd_sc_hd__clkbuf_8
X_2587_ net758 net511 net397 net627 net302 VGND VGND VPWR VPWR _0888_ sky130_fd_sc_hd__a221o_1
X_4326_ net720 net337 VGND VGND VPWR VPWR _2165_ sky130_fd_sc_hd__and2_1
Xfanout159 _1299_ VGND VGND VPWR VPWR net159 sky130_fd_sc_hd__buf_4
X_4257_ net803 net218 _2120_ _2121_ VGND VGND VPWR VPWR _0423_ sky130_fd_sc_hd__o22a_1
X_3208_ net632 net374 VGND VGND VPWR VPWR _1318_ sky130_fd_sc_hd__and2_1
X_4188_ net618 net432 net341 net690 net230 VGND VGND VPWR VPWR _2075_ sky130_fd_sc_hd__a221o_1
X_3139_ net599 net490 net378 net673 VGND VGND VPWR VPWR _1269_ sky130_fd_sc_hd__a22o_1
XFILLER_82_363 VGND VGND VPWR VPWR sky130_fd_sc_hd__fill_1
XTAP_TAPCELL_ROW_81_1011 VGND VPWR sky130_fd_sc_hd__tapvpwrvgnd_1
XTAP_TAPCELL_ROW_25_458 VGND VPWR sky130_fd_sc_hd__tapvpwrvgnd_1
XTAP_TAPCELL_ROW_53_734 VGND VPWR sky130_fd_sc_hd__tapvpwrvgnd_1
XFILLER_23_474 VPWR VGND VPWR VGND sky130_ef_sc_hd__decap_12
XFILLER_2_323 VGND VGND VPWR VPWR sky130_fd_sc_hd__decap_3
Xhold180 array\[3\]\[30\] VGND VGND VPWR VPWR net946 sky130_fd_sc_hd__dlygate4sd3_1
XFILLER_5_3 VPWR VGND VPWR VGND sky130_ef_sc_hd__decap_12
Xhold191 array\[14\]\[30\] VGND VGND VPWR VPWR net957 sky130_fd_sc_hd__dlygate4sd3_1
XFILLER_77_113 VGND VGND VPWR VPWR sky130_fd_sc_hd__decap_6
Xfanout660 net58 VGND VGND VPWR VPWR net660 sky130_fd_sc_hd__dlymetal6s2s_1
Xfanout682 net47 VGND VGND VPWR VPWR net682 sky130_fd_sc_hd__buf_1
Xfanout693 net41 VGND VGND VPWR VPWR net693 sky130_fd_sc_hd__buf_2
Xfanout671 net52 VGND VGND VPWR VPWR net671 sky130_fd_sc_hd__clkbuf_2
XFILLER_37_61 VGND VGND VPWR VPWR sky130_fd_sc_hd__fill_1
XFILLER_61_503 VGND VGND VPWR VPWR sky130_fd_sc_hd__fill_1
XFILLER_14_463 VPWR VGND VPWR VGND sky130_ef_sc_hd__decap_12
XFILLER_14_452 VGND VGND VPWR VPWR sky130_fd_sc_hd__decap_4
X_3490_ net654 _1510_ VGND VGND VPWR VPWR _1512_ sky130_fd_sc_hd__or2_4
X_2510_ net1112 net205 _0831_ VGND VGND VPWR VPWR _0542_ sky130_fd_sc_hd__o21a_1
X_2441_ net756 net757 _0633_ net514 VGND VGND VPWR VPWR _0783_ sky130_fd_sc_hd__a31o_2
X_2372_ net623 net695 net518 VGND VGND VPWR VPWR _0736_ sky130_fd_sc_hd__mux2_1
X_4111_ array\[6\]\[30\] net468 net451 array\[4\]\[30\] VGND VGND VPWR VPWR _2020_
+ sky130_fd_sc_hd__a22o_1
XFILLER_83_105 VGND VGND VPWR VPWR sky130_fd_sc_hd__decap_6
XFILLER_37_500 VGND VGND VPWR VPWR sky130_fd_sc_hd__decap_4
X_4042_ array\[9\]\[24\] net556 net539 array\[11\]\[24\] _1956_ VGND VGND VPWR VPWR
+ _1957_ sky130_fd_sc_hd__a221o_1
XFILLER_64_363 VGND VGND VPWR VPWR sky130_fd_sc_hd__fill_1
XTAP_TAPCELL_ROW_50_704 VGND VPWR sky130_fd_sc_hd__tapvpwrvgnd_1
X_4875_ clknet_leaf_13_clk _0406_ VGND VGND VPWR VPWR array\[7\]\[18\] sky130_fd_sc_hd__dfxtp_1
XTAP_TAPCELL_ROW_22_428 VGND VPWR sky130_fd_sc_hd__tapvpwrvgnd_1
XFILLER_32_293 VGND VGND VPWR VPWR sky130_fd_sc_hd__fill_1
X_3826_ array\[2\]\[5\] net471 net454 array\[0\]\[5\] VGND VGND VPWR VPWR _1760_ sky130_fd_sc_hd__a22o_1
X_3757_ net579 net425 net346 net649 net243 VGND VGND VPWR VPWR _1699_ sky130_fd_sc_hd__a221o_1
X_2708_ net747 net292 _0969_ net389 VGND VGND VPWR VPWR _0970_ sky130_fd_sc_hd__a22o_1
X_3688_ net567 net426 net346 net637 net243 VGND VGND VPWR VPWR _1654_ sky130_fd_sc_hd__a221o_1
X_2639_ net1213 net303 _0868_ net723 _0921_ VGND VGND VPWR VPWR _0581_ sky130_fd_sc_hd__a221o_1
XFILLER_58_27 VGND VGND VPWR VPWR sky130_fd_sc_hd__fill_1
X_4309_ net596 net427 net331 net670 net221 VGND VGND VPWR VPWR _2155_ sky130_fd_sc_hd__a221o_1
XFILLER_47_308 VGND VGND VPWR VPWR sky130_fd_sc_hd__fill_2
XFILLER_74_138 VGND VGND VPWR VPWR sky130_fd_sc_hd__fill_2
XFILLER_28_522 VGND VGND VPWR VPWR sky130_fd_sc_hd__decap_8
XFILLER_28_533 VPWR VGND VPWR VGND sky130_ef_sc_hd__decap_12
XTAP_TAPCELL_ROW_38_583 VGND VPWR sky130_fd_sc_hd__tapvpwrvgnd_1
XFILLER_30_219 VGND VGND VPWR VPWR sky130_fd_sc_hd__decap_6
XFILLER_11_433 VPWR VGND VPWR VGND sky130_ef_sc_hd__decap_12
XFILLER_2_153 VPWR VGND VPWR VGND sky130_ef_sc_hd__decap_12
XFILLER_2_197 VGND VGND VPWR VPWR sky130_fd_sc_hd__decap_8
XFILLER_78_477 VGND VGND VPWR VPWR sky130_fd_sc_hd__decap_8
XFILLER_78_499 VGND VGND VPWR VPWR sky130_fd_sc_hd__fill_2
XFILLER_19_500 VGND VGND VPWR VPWR sky130_fd_sc_hd__decap_4
Xfanout490 _1221_ VGND VGND VPWR VPWR net490 sky130_fd_sc_hd__buf_2
XFILLER_93_458 VPWR VGND VPWR VGND sky130_ef_sc_hd__decap_12
XFILLER_80_119 VGND VGND VPWR VPWR sky130_fd_sc_hd__fill_1
XFILLER_73_193 VGND VGND VPWR VPWR sky130_fd_sc_hd__fill_1
X_2990_ net635 net565 net495 VGND VGND VPWR VPWR _1166_ sky130_fd_sc_hd__mux2_1
X_4660_ clknet_leaf_44_clk _0191_ VGND VGND VPWR VPWR array\[13\]\[25\] sky130_fd_sc_hd__dfxtp_1
X_3611_ head\[1\] net561 VGND VGND VPWR VPWR _1595_ sky130_fd_sc_hd__or2_1
X_4591_ clknet_leaf_9_clk _0122_ VGND VGND VPWR VPWR array\[15\]\[20\] sky130_fd_sc_hd__dfxtp_1
X_3542_ net1204 net251 _1546_ _1547_ VGND VGND VPWR VPWR _0278_ sky130_fd_sc_hd__o22a_1
X_3473_ net581 net479 net365 net657 VGND VGND VPWR VPWR _1499_ sky130_fd_sc_hd__a22o_1
X_2424_ net723 net317 _0770_ net409 net314 VGND VGND VPWR VPWR _0771_ sky130_fd_sc_hd__a221o_1
XFILLER_69_433 VGND VGND VPWR VPWR sky130_fd_sc_hd__decap_6
X_2355_ net709 net316 _0724_ net408 net313 VGND VGND VPWR VPWR _0725_ sky130_fd_sc_hd__a221o_1
XFILLER_84_425 VGND VGND VPWR VPWR sky130_fd_sc_hd__decap_3
X_2286_ net748 net321 _0675_ net412 net329 VGND VGND VPWR VPWR _0676_ sky130_fd_sc_hd__a221o_1
X_4025_ net843 net169 _1940_ _1941_ VGND VGND VPWR VPWR _0367_ sky130_fd_sc_hd__o22a_1
XFILLER_25_547 VGND VGND VPWR VPWR sky130_fd_sc_hd__fill_1
XTAP_TAPCELL_ROW_35_553 VGND VPWR sky130_fd_sc_hd__tapvpwrvgnd_1
X_4858_ clknet_leaf_3_clk _0389_ VGND VGND VPWR VPWR array\[7\]\[1\] sky130_fd_sc_hd__dfxtp_1
X_3809_ net355 _1739_ _1743_ net415 net214 VGND VGND VPWR VPWR _1745_ sky130_fd_sc_hd__a221o_1
XFILLER_4_407 VPWR VGND VPWR VGND sky130_ef_sc_hd__decap_12
X_4789_ clknet_leaf_60_clk _0320_ VGND VGND VPWR VPWR array\[9\]\[7\] sky130_fd_sc_hd__dfxtp_1
XFILLER_69_15 VPWR VGND VPWR VGND sky130_ef_sc_hd__decap_12
XTAP_TAPCELL_ROW_7_278 VGND VPWR sky130_fd_sc_hd__tapvpwrvgnd_1
XFILLER_75_436 VGND VGND VPWR VPWR sky130_fd_sc_hd__decap_4
XFILLER_75_425 VGND VGND VPWR VPWR sky130_fd_sc_hd__fill_2
XFILLER_85_69 VPWR VGND VPWR VGND sky130_ef_sc_hd__decap_12
XFILLER_90_406 VPWR VGND VPWR VGND sky130_ef_sc_hd__decap_12
XTAP_TAPCELL_ROW_87_1072 VGND VPWR sky130_fd_sc_hd__tapvpwrvgnd_1
XFILLER_16_558 VGND VGND VPWR VPWR sky130_fd_sc_hd__fill_1
XFILLER_70_141 VGND VGND VPWR VPWR sky130_fd_sc_hd__fill_1
XFILLER_70_185 VGND VGND VPWR VPWR sky130_fd_sc_hd__decap_8
XFILLER_34_73 VGND VGND VPWR VPWR sky130_fd_sc_hd__fill_2
XFILLER_50_94 VGND VGND VPWR VPWR sky130_fd_sc_hd__decap_6
XFILLER_3_473 VPWR VGND VPWR VGND sky130_ef_sc_hd__decap_12
XTAP_TAPCELL_ROW_77_976 VGND VPWR sky130_fd_sc_hd__tapvpwrvgnd_1
XFILLER_46_171 VPWR VGND VPWR VGND sky130_ef_sc_hd__decap_12
X_2973_ net629 net193 _1154_ net379 VGND VGND VPWR VPWR _1155_ sky130_fd_sc_hd__a22o_1
XTAP_TAPCELL_ROW_32_523 VGND VPWR sky130_fd_sc_hd__tapvpwrvgnd_1
X_4712_ clknet_leaf_9_clk _0243_ VGND VGND VPWR VPWR array\[11\]\[13\] sky130_fd_sc_hd__dfxtp_1
XFILLER_30_561 VGND VGND VPWR VPWR sky130_fd_sc_hd__fill_1
X_4643_ clknet_leaf_31_clk _0174_ VGND VGND VPWR VPWR array\[13\]\[8\] sky130_fd_sc_hd__dfxtp_1
X_4574_ clknet_leaf_9_clk _0105_ VGND VGND VPWR VPWR array\[15\]\[3\] sky130_fd_sc_hd__dfxtp_1
X_3525_ net1220 net249 _1536_ VGND VGND VPWR VPWR _0272_ sky130_fd_sc_hd__o21a_1
XFILLER_89_517 VPWR VGND VPWR VGND sky130_ef_sc_hd__decap_12
X_3456_ net733 net255 _1487_ net263 VGND VGND VPWR VPWR _1488_ sky130_fd_sc_hd__a211o_1
XFILLER_39_29 VGND VGND VPWR VPWR sky130_fd_sc_hd__fill_1
X_3387_ _1436_ _1437_ VGND VGND VPWR VPWR _1441_ sky130_fd_sc_hd__and2b_2
X_2407_ net1278 net207 _0759_ VGND VGND VPWR VPWR _0511_ sky130_fd_sc_hd__o21a_1
XTAP_TAPCELL_ROW_4_248 VGND VPWR sky130_fd_sc_hd__tapvpwrvgnd_1
XPHY_EDGE_ROW_24_Left_119 VGND VGND VPWR VPWR sky130_fd_sc_hd__decap_3
X_2338_ net406 _0711_ VGND VGND VPWR VPWR _0712_ sky130_fd_sc_hd__nor2_1
XFILLER_29_105 VGND VGND VPWR VPWR sky130_fd_sc_hd__fill_1
X_2269_ net928 net323 _0664_ VGND VGND VPWR VPWR _0468_ sky130_fd_sc_hd__o21a_1
X_4008_ array\[5\]\[21\] net545 net527 array\[7\]\[21\] _1925_ VGND VGND VPWR VPWR
+ _1926_ sky130_fd_sc_hd__a221o_1
XFILLER_13_517 VPWR VGND VPWR VGND sky130_ef_sc_hd__decap_12
XFILLER_71_27 VPWR VGND VPWR VGND sky130_ef_sc_hd__decap_12
XFILLER_21_561 VGND VGND VPWR VPWR sky130_fd_sc_hd__fill_1
XPHY_EDGE_ROW_33_Left_128 VGND VGND VPWR VPWR sky130_fd_sc_hd__decap_3
XFILLER_4_237 VGND VGND VPWR VPWR sky130_fd_sc_hd__decap_4
XFILLER_0_421 VPWR VGND VPWR VGND sky130_ef_sc_hd__decap_12
XFILLER_20_97 VPWR VGND VPWR VGND sky130_ef_sc_hd__decap_12
XFILLER_88_561 VGND VGND VPWR VPWR sky130_fd_sc_hd__fill_1
XPHY_EDGE_ROW_42_Left_137 VGND VGND VPWR VPWR sky130_fd_sc_hd__decap_3
Xhold40 array\[13\]\[31\] VGND VGND VPWR VPWR net806 sky130_fd_sc_hd__dlygate4sd3_1
Xhold73 array\[5\]\[5\] VGND VGND VPWR VPWR net839 sky130_fd_sc_hd__dlygate4sd3_1
Xhold51 array\[10\]\[0\] VGND VGND VPWR VPWR net817 sky130_fd_sc_hd__dlygate4sd3_1
Xhold62 array\[11\]\[10\] VGND VGND VPWR VPWR net828 sky130_fd_sc_hd__dlygate4sd3_1
XFILLER_29_84 VGND VGND VPWR VPWR sky130_fd_sc_hd__fill_2
Xhold84 array\[9\]\[13\] VGND VGND VPWR VPWR net850 sky130_fd_sc_hd__dlygate4sd3_1
Xhold95 array\[13\]\[1\] VGND VGND VPWR VPWR net861 sky130_fd_sc_hd__dlygate4sd3_1
XTAP_TAPCELL_ROW_74_946 VGND VPWR sky130_fd_sc_hd__tapvpwrvgnd_1
XPHY_EDGE_ROW_51_Left_146 VGND VGND VPWR VPWR sky130_fd_sc_hd__decap_3
XANTENNA_4 _0631_ VGND VGND VPWR VPWR sky130_fd_sc_hd__diode_2
X_3310_ net1262 net153 _1387_ _1388_ VGND VGND VPWR VPWR _0205_ sky130_fd_sc_hd__o22a_1
XFILLER_3_281 VPWR VGND VPWR VGND sky130_ef_sc_hd__decap_12
X_4290_ net1291 net224 net338 net750 _2142_ VGND VGND VPWR VPWR _0435_ sky130_fd_sc_hd__a221o_1
XPHY_EDGE_ROW_60_Left_155 VGND VGND VPWR VPWR sky130_fd_sc_hd__decap_3
XFILLER_79_561 VGND VGND VPWR VPWR sky130_fd_sc_hd__fill_1
X_3241_ net677 net371 VGND VGND VPWR VPWR _1340_ sky130_fd_sc_hd__and2_1
X_3172_ net574 net491 net376 net644 VGND VGND VPWR VPWR _1291_ sky130_fd_sc_hd__a22o_1
XFILLER_39_436 VGND VGND VPWR VPWR sky130_fd_sc_hd__fill_2
XTAP_TAPCELL_ROW_1_218 VGND VPWR sky130_fd_sc_hd__tapvpwrvgnd_1
XFILLER_81_225 VGND VGND VPWR VPWR sky130_fd_sc_hd__decap_4
XTAP_TAPCELL_ROW_17_372 VGND VPWR sky130_fd_sc_hd__tapvpwrvgnd_1
X_2956_ tail\[0\] net103 _0626_ VGND VGND VPWR VPWR _1138_ sky130_fd_sc_hd__mux2_1
X_2887_ net700 net272 _1091_ net385 net269 VGND VGND VPWR VPWR _1092_ sky130_fd_sc_hd__a221o_1
XFILLER_30_391 VGND VGND VPWR VPWR sky130_fd_sc_hd__fill_1
X_4626_ clknet_leaf_34_clk _0157_ VGND VGND VPWR VPWR array\[14\]\[23\] sky130_fd_sc_hd__dfxtp_1
Xhold510 array\[10\]\[19\] VGND VGND VPWR VPWR net1276 sky130_fd_sc_hd__dlygate4sd3_1
X_4557_ clknet_leaf_13_clk _0088_ VGND VGND VPWR VPWR array\[0\]\[18\] sky130_fd_sc_hd__dfxtp_1
Xhold521 array\[9\]\[16\] VGND VGND VPWR VPWR net1287 sky130_fd_sc_hd__dlygate4sd3_1
Xhold554 ready_check\[7\] VGND VGND VPWR VPWR net1320 sky130_fd_sc_hd__dlygate4sd3_1
Xhold532 array\[3\]\[19\] VGND VGND VPWR VPWR net1298 sky130_fd_sc_hd__dlygate4sd3_1
Xhold543 array\[7\]\[21\] VGND VGND VPWR VPWR net1309 sky130_fd_sc_hd__dlygate4sd3_1
X_4488_ clknet_leaf_13_clk _0019_ VGND VGND VPWR VPWR array\[5\]\[13\] sky130_fd_sc_hd__dfxtp_1
X_3508_ net707 net247 VGND VGND VPWR VPWR _1525_ sky130_fd_sc_hd__and2_1
X_3439_ net891 net262 _1476_ VGND VGND VPWR VPWR _0246_ sky130_fd_sc_hd__o21a_1
XFILLER_85_553 VGND VGND VPWR VPWR sky130_fd_sc_hd__decap_6
XTAP_TAPCELL_ROW_84_1042 VGND VPWR sky130_fd_sc_hd__tapvpwrvgnd_1
XFILLER_82_15 VPWR VGND VPWR VGND sky130_ef_sc_hd__decap_12
XTAP_TAPCELL_ROW_71_916 VGND VPWR sky130_fd_sc_hd__tapvpwrvgnd_1
XFILLER_60_409 VGND VGND VPWR VPWR sky130_fd_sc_hd__fill_2
XFILLER_31_30 VPWR VGND VPWR VGND sky130_ef_sc_hd__decap_12
XFILLER_76_531 VGND VGND VPWR VPWR sky130_fd_sc_hd__fill_1
XFILLER_48_277 VPWR VGND VPWR VGND sky130_ef_sc_hd__decap_12
XFILLER_36_428 VPWR VGND VPWR VGND sky130_ef_sc_hd__decap_12
XTAP_TAPCELL_ROW_59_795 VGND VPWR sky130_fd_sc_hd__tapvpwrvgnd_1
XFILLER_63_214 VGND VGND VPWR VPWR sky130_fd_sc_hd__decap_3
XFILLER_16_141 VGND VGND VPWR VPWR sky130_fd_sc_hd__fill_1
X_2810_ net611 net503 net277 net683 VGND VGND VPWR VPWR _1040_ sky130_fd_sc_hd__a22o_1
XTAP_TAPCELL_ROW_14_342 VGND VPWR sky130_fd_sc_hd__tapvpwrvgnd_1
XFILLER_31_166 VGND VGND VPWR VPWR sky130_fd_sc_hd__fill_2
X_3790_ array\[10\]\[2\] net465 net448 array\[8\]\[2\] VGND VGND VPWR VPWR _1727_
+ sky130_fd_sc_hd__a22o_1
X_2741_ net723 net292 _0991_ net390 VGND VGND VPWR VPWR _0992_ sky130_fd_sc_hd__a22o_1
XFILLER_12_380 VGND VGND VPWR VPWR sky130_fd_sc_hd__fill_2
XFILLER_8_362 VGND VGND VPWR VPWR sky130_fd_sc_hd__fill_2
XFILLER_8_351 VGND VGND VPWR VPWR sky130_fd_sc_hd__decap_3
XFILLER_68_3 VPWR VGND VPWR VGND sky130_ef_sc_hd__decap_12
XFILLER_8_384 VGND VGND VPWR VPWR sky130_fd_sc_hd__fill_2
X_4411_ clknet_leaf_57_clk _0522_ VGND VGND VPWR VPWR array\[3\]\[0\] sky130_fd_sc_hd__dfxtp_1
X_2672_ net709 net291 _0945_ net389 VGND VGND VPWR VPWR _0946_ sky130_fd_sc_hd__a22o_1
X_4342_ clknet_leaf_63_clk _0453_ VGND VGND VPWR VPWR _0000_ sky130_fd_sc_hd__dfxtp_1
Xfanout308 net309 VGND VGND VPWR VPWR net308 sky130_fd_sc_hd__clkbuf_4
Xfanout319 net320 VGND VGND VPWR VPWR net319 sky130_fd_sc_hd__clkbuf_4
X_4273_ net1280 net223 net337 net700 _2131_ VGND VGND VPWR VPWR _0429_ sky130_fd_sc_hd__a221o_1
X_3224_ net617 net487 net183 net754 _1328_ VGND VGND VPWR VPWR _1329_ sky130_fd_sc_hd__a221o_1
.ends

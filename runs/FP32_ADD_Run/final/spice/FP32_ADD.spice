* NGSPICE file created from FP32_ADD.ext - technology: sky130A

* Black-box entry subcircuit for sky130_fd_sc_hd__fill_1 abstract view
.subckt sky130_fd_sc_hd__fill_1 VGND VNB VPB VPWR
.ends

* Black-box entry subcircuit for sky130_fd_sc_hd__decap_8 abstract view
.subckt sky130_fd_sc_hd__decap_8 VGND VNB VPB VPWR
.ends

* Black-box entry subcircuit for sky130_ef_sc_hd__decap_12 abstract view
.subckt sky130_ef_sc_hd__decap_12 VPWR VGND VPB VNB
.ends

* Black-box entry subcircuit for sky130_fd_sc_hd__xor2_1 abstract view
.subckt sky130_fd_sc_hd__xor2_1 A B VGND VNB VPB VPWR X
.ends

* Black-box entry subcircuit for sky130_fd_sc_hd__nand2b_1 abstract view
.subckt sky130_fd_sc_hd__nand2b_1 A_N B VGND VNB VPB VPWR Y
.ends

* Black-box entry subcircuit for sky130_fd_sc_hd__o21ai_1 abstract view
.subckt sky130_fd_sc_hd__o21ai_1 A1 A2 B1 VGND VNB VPB VPWR Y
.ends

* Black-box entry subcircuit for sky130_fd_sc_hd__or2_1 abstract view
.subckt sky130_fd_sc_hd__or2_1 A B VGND VNB VPB VPWR X
.ends

* Black-box entry subcircuit for sky130_fd_sc_hd__tapvpwrvgnd_1 abstract view
.subckt sky130_fd_sc_hd__tapvpwrvgnd_1 VGND VPWR
.ends

* Black-box entry subcircuit for sky130_fd_sc_hd__dfxtp_1 abstract view
.subckt sky130_fd_sc_hd__dfxtp_1 CLK D VGND VNB VPB VPWR Q
.ends

* Black-box entry subcircuit for sky130_fd_sc_hd__decap_6 abstract view
.subckt sky130_fd_sc_hd__decap_6 VGND VNB VPB VPWR
.ends

* Black-box entry subcircuit for sky130_fd_sc_hd__decap_3 abstract view
.subckt sky130_fd_sc_hd__decap_3 VGND VNB VPB VPWR
.ends

* Black-box entry subcircuit for sky130_fd_sc_hd__and2_1 abstract view
.subckt sky130_fd_sc_hd__and2_1 A B VGND VNB VPB VPWR X
.ends

* Black-box entry subcircuit for sky130_fd_sc_hd__mux2_1 abstract view
.subckt sky130_fd_sc_hd__mux2_1 A0 A1 S VGND VNB VPB VPWR X
.ends

* Black-box entry subcircuit for sky130_fd_sc_hd__and3_1 abstract view
.subckt sky130_fd_sc_hd__and3_1 A B C VGND VNB VPB VPWR X
.ends

* Black-box entry subcircuit for sky130_fd_sc_hd__o221a_1 abstract view
.subckt sky130_fd_sc_hd__o221a_1 A1 A2 B1 B2 C1 VGND VNB VPB VPWR X
.ends

* Black-box entry subcircuit for sky130_fd_sc_hd__or4_1 abstract view
.subckt sky130_fd_sc_hd__or4_1 A B C D VGND VNB VPB VPWR X
.ends

* Black-box entry subcircuit for sky130_fd_sc_hd__clkbuf_4 abstract view
.subckt sky130_fd_sc_hd__clkbuf_4 A VGND VNB VPB VPWR X
.ends

* Black-box entry subcircuit for sky130_fd_sc_hd__buf_2 abstract view
.subckt sky130_fd_sc_hd__buf_2 A VGND VNB VPB VPWR X
.ends

* Black-box entry subcircuit for sky130_fd_sc_hd__clkbuf_2 abstract view
.subckt sky130_fd_sc_hd__clkbuf_2 A VGND VNB VPB VPWR X
.ends

* Black-box entry subcircuit for sky130_fd_sc_hd__a21oi_1 abstract view
.subckt sky130_fd_sc_hd__a21oi_1 A1 A2 B1 VGND VNB VPB VPWR Y
.ends

* Black-box entry subcircuit for sky130_fd_sc_hd__o21a_1 abstract view
.subckt sky130_fd_sc_hd__o21a_1 A1 A2 B1 VGND VNB VPB VPWR X
.ends

* Black-box entry subcircuit for sky130_fd_sc_hd__decap_4 abstract view
.subckt sky130_fd_sc_hd__decap_4 VGND VNB VPB VPWR
.ends

* Black-box entry subcircuit for sky130_fd_sc_hd__or2_2 abstract view
.subckt sky130_fd_sc_hd__or2_2 A B VGND VNB VPB VPWR X
.ends

* Black-box entry subcircuit for sky130_fd_sc_hd__fill_2 abstract view
.subckt sky130_fd_sc_hd__fill_2 VGND VNB VPB VPWR
.ends

* Black-box entry subcircuit for sky130_fd_sc_hd__o211a_1 abstract view
.subckt sky130_fd_sc_hd__o211a_1 A1 A2 B1 C1 VGND VNB VPB VPWR X
.ends

* Black-box entry subcircuit for sky130_fd_sc_hd__nand2_1 abstract view
.subckt sky130_fd_sc_hd__nand2_1 A B VGND VNB VPB VPWR Y
.ends

* Black-box entry subcircuit for sky130_fd_sc_hd__nor2_1 abstract view
.subckt sky130_fd_sc_hd__nor2_1 A B VGND VNB VPB VPWR Y
.ends

* Black-box entry subcircuit for sky130_fd_sc_hd__or3_1 abstract view
.subckt sky130_fd_sc_hd__or3_1 A B C VGND VNB VPB VPWR X
.ends

* Black-box entry subcircuit for sky130_fd_sc_hd__inv_2 abstract view
.subckt sky130_fd_sc_hd__inv_2 A VGND VNB VPB VPWR Y
.ends

* Black-box entry subcircuit for sky130_fd_sc_hd__a22oi_2 abstract view
.subckt sky130_fd_sc_hd__a22oi_2 A1 A2 B1 B2 VGND VNB VPB VPWR Y
.ends

* Black-box entry subcircuit for sky130_fd_sc_hd__o22a_1 abstract view
.subckt sky130_fd_sc_hd__o22a_1 A1 A2 B1 B2 VGND VNB VPB VPWR X
.ends

* Black-box entry subcircuit for sky130_fd_sc_hd__a21o_1 abstract view
.subckt sky130_fd_sc_hd__a21o_1 A1 A2 B1 VGND VNB VPB VPWR X
.ends

* Black-box entry subcircuit for sky130_fd_sc_hd__nor3_1 abstract view
.subckt sky130_fd_sc_hd__nor3_1 A B C VGND VNB VPB VPWR Y
.ends

* Black-box entry subcircuit for sky130_fd_sc_hd__a2bb2o_1 abstract view
.subckt sky130_fd_sc_hd__a2bb2o_1 A1_N A2_N B1 B2 VGND VNB VPB VPWR X
.ends

* Black-box entry subcircuit for sky130_fd_sc_hd__and2b_1 abstract view
.subckt sky130_fd_sc_hd__and2b_1 A_N B VGND VNB VPB VPWR X
.ends

* Black-box entry subcircuit for sky130_fd_sc_hd__a22o_1 abstract view
.subckt sky130_fd_sc_hd__a22o_1 A1 A2 B1 B2 VGND VNB VPB VPWR X
.ends

* Black-box entry subcircuit for sky130_fd_sc_hd__a211oi_1 abstract view
.subckt sky130_fd_sc_hd__a211oi_1 A1 A2 B1 C1 VGND VNB VPB VPWR Y
.ends

* Black-box entry subcircuit for sky130_fd_sc_hd__dlygate4sd3_1 abstract view
.subckt sky130_fd_sc_hd__dlygate4sd3_1 A VGND VNB VPB VPWR X
.ends

* Black-box entry subcircuit for sky130_fd_sc_hd__o31a_1 abstract view
.subckt sky130_fd_sc_hd__o31a_1 A1 A2 A3 B1 VGND VNB VPB VPWR X
.ends

* Black-box entry subcircuit for sky130_fd_sc_hd__nand3_1 abstract view
.subckt sky130_fd_sc_hd__nand3_1 A B C VGND VNB VPB VPWR Y
.ends

* Black-box entry subcircuit for sky130_fd_sc_hd__buf_1 abstract view
.subckt sky130_fd_sc_hd__buf_1 A VGND VNB VPB VPWR X
.ends

* Black-box entry subcircuit for sky130_fd_sc_hd__and3_2 abstract view
.subckt sky130_fd_sc_hd__and3_2 A B C VGND VNB VPB VPWR X
.ends

* Black-box entry subcircuit for sky130_fd_sc_hd__or4b_1 abstract view
.subckt sky130_fd_sc_hd__or4b_1 A B C D_N VGND VNB VPB VPWR X
.ends

* Black-box entry subcircuit for sky130_fd_sc_hd__a31o_1 abstract view
.subckt sky130_fd_sc_hd__a31o_1 A1 A2 A3 B1 VGND VNB VPB VPWR X
.ends

* Black-box entry subcircuit for sky130_fd_sc_hd__nor2_2 abstract view
.subckt sky130_fd_sc_hd__nor2_2 A B VGND VNB VPB VPWR Y
.ends

* Black-box entry subcircuit for sky130_fd_sc_hd__or3_2 abstract view
.subckt sky130_fd_sc_hd__or3_2 A B C VGND VNB VPB VPWR X
.ends

* Black-box entry subcircuit for sky130_fd_sc_hd__xnor2_1 abstract view
.subckt sky130_fd_sc_hd__xnor2_1 A B VGND VNB VPB VPWR Y
.ends

* Black-box entry subcircuit for sky130_fd_sc_hd__a311o_1 abstract view
.subckt sky130_fd_sc_hd__a311o_1 A1 A2 A3 B1 C1 VGND VNB VPB VPWR X
.ends

* Black-box entry subcircuit for sky130_fd_sc_hd__o32a_1 abstract view
.subckt sky130_fd_sc_hd__o32a_1 A1 A2 A3 B1 B2 VGND VNB VPB VPWR X
.ends

* Black-box entry subcircuit for sky130_fd_sc_hd__o311a_1 abstract view
.subckt sky130_fd_sc_hd__o311a_1 A1 A2 A3 B1 C1 VGND VNB VPB VPWR X
.ends

* Black-box entry subcircuit for sky130_fd_sc_hd__o41a_1 abstract view
.subckt sky130_fd_sc_hd__o41a_1 A1 A2 A3 A4 B1 VGND VNB VPB VPWR X
.ends

* Black-box entry subcircuit for sky130_fd_sc_hd__o2111a_1 abstract view
.subckt sky130_fd_sc_hd__o2111a_1 A1 A2 B1 C1 D1 VGND VNB VPB VPWR X
.ends

* Black-box entry subcircuit for sky130_fd_sc_hd__nor3_2 abstract view
.subckt sky130_fd_sc_hd__nor3_2 A B C VGND VNB VPB VPWR Y
.ends

* Black-box entry subcircuit for sky130_fd_sc_hd__a21bo_1 abstract view
.subckt sky130_fd_sc_hd__a21bo_1 A1 A2 B1_N VGND VNB VPB VPWR X
.ends

* Black-box entry subcircuit for sky130_fd_sc_hd__a2111o_1 abstract view
.subckt sky130_fd_sc_hd__a2111o_1 A1 A2 B1 C1 D1 VGND VNB VPB VPWR X
.ends

* Black-box entry subcircuit for sky130_fd_sc_hd__or3b_1 abstract view
.subckt sky130_fd_sc_hd__or3b_1 A B C_N VGND VNB VPB VPWR X
.ends

* Black-box entry subcircuit for sky130_fd_sc_hd__or4_2 abstract view
.subckt sky130_fd_sc_hd__or4_2 A B C D VGND VNB VPB VPWR X
.ends

* Black-box entry subcircuit for sky130_fd_sc_hd__and4_1 abstract view
.subckt sky130_fd_sc_hd__and4_1 A B C D VGND VNB VPB VPWR X
.ends

* Black-box entry subcircuit for sky130_fd_sc_hd__dfxtp_2 abstract view
.subckt sky130_fd_sc_hd__dfxtp_2 CLK D VGND VNB VPB VPWR Q
.ends

* Black-box entry subcircuit for sky130_fd_sc_hd__clkbuf_8 abstract view
.subckt sky130_fd_sc_hd__clkbuf_8 A VGND VNB VPB VPWR X
.ends

* Black-box entry subcircuit for sky130_fd_sc_hd__a211o_1 abstract view
.subckt sky130_fd_sc_hd__a211o_1 A1 A2 B1 C1 VGND VNB VPB VPWR X
.ends

* Black-box entry subcircuit for sky130_fd_sc_hd__o2bb2a_1 abstract view
.subckt sky130_fd_sc_hd__o2bb2a_1 A1_N A2_N B1 B2 VGND VNB VPB VPWR X
.ends

* Black-box entry subcircuit for sky130_fd_sc_hd__clkinvlp_4 abstract view
.subckt sky130_fd_sc_hd__clkinvlp_4 A VGND VNB VPB VPWR Y
.ends

* Black-box entry subcircuit for sky130_fd_sc_hd__o21bai_1 abstract view
.subckt sky130_fd_sc_hd__o21bai_1 A1 A2 B1_N VGND VNB VPB VPWR Y
.ends

* Black-box entry subcircuit for sky130_fd_sc_hd__a221o_1 abstract view
.subckt sky130_fd_sc_hd__a221o_1 A1 A2 B1 B2 C1 VGND VNB VPB VPWR X
.ends

* Black-box entry subcircuit for sky130_fd_sc_hd__or4bb_1 abstract view
.subckt sky130_fd_sc_hd__or4bb_1 A B C_N D_N VGND VNB VPB VPWR X
.ends

* Black-box entry subcircuit for sky130_fd_sc_hd__or4b_2 abstract view
.subckt sky130_fd_sc_hd__or4b_2 A B C D_N VGND VNB VPB VPWR X
.ends

* Black-box entry subcircuit for sky130_fd_sc_hd__and4bb_1 abstract view
.subckt sky130_fd_sc_hd__and4bb_1 A_N B_N C D VGND VNB VPB VPWR X
.ends

* Black-box entry subcircuit for sky130_fd_sc_hd__inv_6 abstract view
.subckt sky130_fd_sc_hd__inv_6 A VGND VNB VPB VPWR Y
.ends

* Black-box entry subcircuit for sky130_fd_sc_hd__a31oi_1 abstract view
.subckt sky130_fd_sc_hd__a31oi_1 A1 A2 A3 B1 VGND VNB VPB VPWR Y
.ends

* Black-box entry subcircuit for sky130_fd_sc_hd__nand3b_1 abstract view
.subckt sky130_fd_sc_hd__nand3b_1 A_N B C VGND VNB VPB VPWR Y
.ends

* Black-box entry subcircuit for sky130_fd_sc_hd__and3b_1 abstract view
.subckt sky130_fd_sc_hd__and3b_1 A_N B C VGND VNB VPB VPWR X
.ends

* Black-box entry subcircuit for sky130_fd_sc_hd__clkinv_8 abstract view
.subckt sky130_fd_sc_hd__clkinv_8 A VGND VNB VPB VPWR Y
.ends

* Black-box entry subcircuit for sky130_fd_sc_hd__a22oi_1 abstract view
.subckt sky130_fd_sc_hd__a22oi_1 A1 A2 B1 B2 VGND VNB VPB VPWR Y
.ends

* Black-box entry subcircuit for sky130_fd_sc_hd__a21boi_1 abstract view
.subckt sky130_fd_sc_hd__a21boi_1 A1 A2 B1_N VGND VNB VPB VPWR Y
.ends

* Black-box entry subcircuit for sky130_fd_sc_hd__clkinv_16 abstract view
.subckt sky130_fd_sc_hd__clkinv_16 A VGND VNB VPB VPWR Y
.ends

* Black-box entry subcircuit for sky130_fd_sc_hd__dlymetal6s2s_1 abstract view
.subckt sky130_fd_sc_hd__dlymetal6s2s_1 A VGND VNB VPB VPWR X
.ends

* Black-box entry subcircuit for sky130_fd_sc_hd__clkbuf_16 abstract view
.subckt sky130_fd_sc_hd__clkbuf_16 A VGND VNB VPB VPWR X
.ends

* Black-box entry subcircuit for sky130_fd_sc_hd__a32o_1 abstract view
.subckt sky130_fd_sc_hd__a32o_1 A1 A2 A3 B1 B2 VGND VNB VPB VPWR X
.ends

* Black-box entry subcircuit for sky130_fd_sc_hd__or4_4 abstract view
.subckt sky130_fd_sc_hd__or4_4 A B C D VGND VNB VPB VPWR X
.ends

* Black-box entry subcircuit for sky130_fd_sc_hd__inv_16 abstract view
.subckt sky130_fd_sc_hd__inv_16 A VGND VNB VPB VPWR Y
.ends

* Black-box entry subcircuit for sky130_fd_sc_hd__inv_12 abstract view
.subckt sky130_fd_sc_hd__inv_12 A VGND VNB VPB VPWR Y
.ends

* Black-box entry subcircuit for sky130_fd_sc_hd__mux4_1 abstract view
.subckt sky130_fd_sc_hd__mux4_1 A0 A1 A2 A3 S0 S1 VGND VNB VPB VPWR X
.ends

* Black-box entry subcircuit for sky130_fd_sc_hd__o21ba_1 abstract view
.subckt sky130_fd_sc_hd__o21ba_1 A1 A2 B1_N VGND VNB VPB VPWR X
.ends

* Black-box entry subcircuit for sky130_fd_sc_hd__nor4_1 abstract view
.subckt sky130_fd_sc_hd__nor4_1 A B C D VGND VNB VPB VPWR Y
.ends

* Black-box entry subcircuit for sky130_fd_sc_hd__mux2_2 abstract view
.subckt sky130_fd_sc_hd__mux2_2 A0 A1 S VGND VNB VPB VPWR X
.ends

* Black-box entry subcircuit for sky130_fd_sc_hd__bufinv_16 abstract view
.subckt sky130_fd_sc_hd__bufinv_16 A VGND VNB VPB VPWR Y
.ends

* Black-box entry subcircuit for sky130_fd_sc_hd__o31ai_1 abstract view
.subckt sky130_fd_sc_hd__o31ai_1 A1 A2 A3 B1 VGND VNB VPB VPWR Y
.ends

* Black-box entry subcircuit for sky130_fd_sc_hd__o211ai_1 abstract view
.subckt sky130_fd_sc_hd__o211ai_1 A1 A2 B1 C1 VGND VNB VPB VPWR Y
.ends

* Black-box entry subcircuit for sky130_fd_sc_hd__clkinv_2 abstract view
.subckt sky130_fd_sc_hd__clkinv_2 A VGND VNB VPB VPWR Y
.ends

* Black-box entry subcircuit for sky130_fd_sc_hd__inv_8 abstract view
.subckt sky130_fd_sc_hd__inv_8 A VGND VNB VPB VPWR Y
.ends

* Black-box entry subcircuit for sky130_fd_sc_hd__and4b_1 abstract view
.subckt sky130_fd_sc_hd__and4b_1 A_N B C D VGND VNB VPB VPWR X
.ends

* Black-box entry subcircuit for sky130_fd_sc_hd__or3_4 abstract view
.subckt sky130_fd_sc_hd__or3_4 A B C VGND VNB VPB VPWR X
.ends

* Black-box entry subcircuit for sky130_fd_sc_hd__clkbuf_1 abstract view
.subckt sky130_fd_sc_hd__clkbuf_1 A VGND VNB VPB VPWR X
.ends

* Black-box entry subcircuit for sky130_fd_sc_hd__nor2_4 abstract view
.subckt sky130_fd_sc_hd__nor2_4 A B VGND VNB VPB VPWR Y
.ends

* Black-box entry subcircuit for sky130_fd_sc_hd__nand2_2 abstract view
.subckt sky130_fd_sc_hd__nand2_2 A B VGND VNB VPB VPWR Y
.ends

* Black-box entry subcircuit for sky130_fd_sc_hd__nand4_2 abstract view
.subckt sky130_fd_sc_hd__nand4_2 A B C D VGND VNB VPB VPWR Y
.ends

* Black-box entry subcircuit for sky130_fd_sc_hd__or4bb_2 abstract view
.subckt sky130_fd_sc_hd__or4bb_2 A B C_N D_N VGND VNB VPB VPWR X
.ends

* Black-box entry subcircuit for sky130_fd_sc_hd__and2_2 abstract view
.subckt sky130_fd_sc_hd__and2_2 A B VGND VNB VPB VPWR X
.ends

* Black-box entry subcircuit for sky130_fd_sc_hd__a31oi_2 abstract view
.subckt sky130_fd_sc_hd__a31oi_2 A1 A2 A3 B1 VGND VNB VPB VPWR Y
.ends

* Black-box entry subcircuit for sky130_fd_sc_hd__buf_4 abstract view
.subckt sky130_fd_sc_hd__buf_4 A VGND VNB VPB VPWR X
.ends

* Black-box entry subcircuit for sky130_fd_sc_hd__o2111ai_1 abstract view
.subckt sky130_fd_sc_hd__o2111ai_1 A1 A2 B1 C1 D1 VGND VNB VPB VPWR Y
.ends

* Black-box entry subcircuit for sky130_fd_sc_hd__nand4_1 abstract view
.subckt sky130_fd_sc_hd__nand4_1 A B C D VGND VNB VPB VPWR Y
.ends

* Black-box entry subcircuit for sky130_fd_sc_hd__xor2_2 abstract view
.subckt sky130_fd_sc_hd__xor2_2 A B VGND VNB VPB VPWR X
.ends

* Black-box entry subcircuit for sky130_fd_sc_hd__nor3b_1 abstract view
.subckt sky130_fd_sc_hd__nor3b_1 A B C_N VGND VNB VPB VPWR Y
.ends

* Black-box entry subcircuit for sky130_fd_sc_hd__o21a_2 abstract view
.subckt sky130_fd_sc_hd__o21a_2 A1 A2 B1 VGND VNB VPB VPWR X
.ends

.subckt FP32_ADD VGND VPWR clk exp[0] exp[1] exp[2] exp[3] exp[4] exp[5] exp[6] exp[7]
+ expa[0] expa[1] expa[2] expa[3] expa[4] expa[5] expa[6] expa[7] expb[0] expb[1]
+ expb[2] expb[3] expb[4] expb[5] expb[6] expb[7] mantisaA[0] mantisaA[10] mantisaA[11]
+ mantisaA[12] mantisaA[13] mantisaA[14] mantisaA[15] mantisaA[16] mantisaA[17] mantisaA[18]
+ mantisaA[19] mantisaA[1] mantisaA[20] mantisaA[21] mantisaA[22] mantisaA[2] mantisaA[3]
+ mantisaA[4] mantisaA[5] mantisaA[6] mantisaA[7] mantisaA[8] mantisaA[9] mantisaB[0]
+ mantisaB[10] mantisaB[11] mantisaB[12] mantisaB[13] mantisaB[14] mantisaB[15] mantisaB[16]
+ mantisaB[17] mantisaB[18] mantisaB[19] mantisaB[1] mantisaB[20] mantisaB[21] mantisaB[22]
+ mantisaB[2] mantisaB[3] mantisaB[4] mantisaB[5] mantisaB[6] mantisaB[7] mantisaB[8]
+ mantisaB[9] mantisa[0] mantisa[10] mantisa[11] mantisa[12] mantisa[13] mantisa[14]
+ mantisa[15] mantisa[16] mantisa[17] mantisa[18] mantisa[19] mantisa[1] mantisa[20]
+ mantisa[21] mantisa[22] mantisa[2] mantisa[3] mantisa[4] mantisa[5] mantisa[6] mantisa[7]
+ mantisa[8] mantisa[9] op sign signa signb
XFILLER_79_391 VGND VGND VPWR VPWR sky130_fd_sc_hd__fill_1
XFILLER_36_19 VGND VGND VPWR VPWR sky130_fd_sc_hd__decap_8
XFILLER_39_266 VPWR VGND VPWR VGND sky130_ef_sc_hd__decap_12
X_3155_ _1042_ _1046_ VGND VGND VPWR VPWR _1047_ sky130_fd_sc_hd__xor2_1
X_2106_ net7 net15 VGND VGND VPWR VPWR _1767_ sky130_fd_sc_hd__nand2b_1
X_3086_ mantisaBshift\[26\] _0989_ net241 VGND VGND VPWR VPWR _0992_ sky130_fd_sc_hd__o21ai_1
X_2037_ expmiddled\[2\] expadd\[2\] VGND VGND VPWR VPWR _1728_ sky130_fd_sc_hd__or2_1
XTAP_TAPCELL_ROW_37_467 VGND VPWR sky130_fd_sc_hd__tapvpwrvgnd_1
X_3988_ clknet_leaf_26_clk net300 VGND VGND VPWR VPWR expmiddleb\[6\] sky130_fd_sc_hd__dfxtp_1
X_2939_ mantisaBshift\[3\] _0871_ VGND VGND VPWR VPWR _0872_ sky130_fd_sc_hd__xor2_1
XTAP_TAPCELL_ROW_20_334 VGND VPWR sky130_fd_sc_hd__tapvpwrvgnd_1
XFILLER_77_317 VPWR VGND VPWR VGND sky130_ef_sc_hd__decap_12
XFILLER_45_225 VGND VGND VPWR VPWR sky130_fd_sc_hd__decap_8
XFILLER_26_472 VGND VGND VPWR VPWR sky130_fd_sc_hd__fill_1
XFILLER_13_111 VGND VGND VPWR VPWR sky130_fd_sc_hd__fill_1
XFILLER_13_188 VGND VGND VPWR VPWR sky130_fd_sc_hd__decap_6
XFILLER_9_137 VGND VGND VPWR VPWR sky130_fd_sc_hd__decap_3
XTAP_TAPCELL_ROW_79_813 VGND VPWR sky130_fd_sc_hd__tapvpwrvgnd_1
XTAP_TAPCELL_ROW_79_802 VGND VPWR sky130_fd_sc_hd__tapvpwrvgnd_1
XFILLER_67_70 VGND VGND VPWR VPWR sky130_fd_sc_hd__fill_1
XFILLER_36_225 VPWR VGND VPWR VGND sky130_ef_sc_hd__decap_12
XFILLER_17_461 VPWR VGND VPWR VGND sky130_ef_sc_hd__decap_12
X_3911_ clknet_leaf_29_clk _0034_ VGND VGND VPWR VPWR expmiddle\[1\] sky130_fd_sc_hd__dfxtp_1
X_3842_ net192 _1613_ VGND VGND VPWR VPWR _0261_ sky130_fd_sc_hd__and2_1
X_3773_ _1545_ _1547_ net262 VGND VGND VPWR VPWR _1589_ sky130_fd_sc_hd__mux2_1
X_2724_ mantisaresult\[8\] net152 net130 VGND VGND VPWR VPWR _0667_ sky130_fd_sc_hd__and3_1
X_2655_ _1625_ _0580_ _0586_ _0597_ _0584_ VGND VGND VPWR VPWR _0598_ sky130_fd_sc_hd__o221a_1
X_2586_ _0426_ _0489_ _0521_ _0524_ VGND VGND VPWR VPWR _0529_ sky130_fd_sc_hd__or4_1
Xfanout116 net121 VGND VGND VPWR VPWR net116 sky130_fd_sc_hd__clkbuf_4
Xfanout138 net140 VGND VGND VPWR VPWR net138 sky130_fd_sc_hd__buf_2
Xfanout127 _0630_ VGND VGND VPWR VPWR net127 sky130_fd_sc_hd__clkbuf_2
Xfanout105 _1835_ VGND VGND VPWR VPWR net105 sky130_fd_sc_hd__clkbuf_2
XFILLER_59_328 VGND VGND VPWR VPWR sky130_fd_sc_hd__decap_8
Xfanout149 _0604_ VGND VGND VPWR VPWR net149 sky130_fd_sc_hd__buf_2
X_3207_ net244 _1092_ _1093_ VGND VGND VPWR VPWR _1094_ sky130_fd_sc_hd__a21oi_1
XFILLER_74_309 VPWR VGND VPWR VGND sky130_ef_sc_hd__decap_12
X_3138_ mantisaBshift\[36\] _1030_ net249 VGND VGND VPWR VPWR _1033_ sky130_fd_sc_hd__o21ai_1
X_3069_ _0972_ _0978_ net125 VGND VGND VPWR VPWR _0979_ sky130_fd_sc_hd__o21a_1
XFILLER_42_206 VGND VGND VPWR VPWR sky130_fd_sc_hd__fill_1
XFILLER_23_431 VGND VGND VPWR VPWR sky130_fd_sc_hd__decap_4
XFILLER_35_291 VGND VGND VPWR VPWR sky130_fd_sc_hd__decap_8
XFILLER_6_129 VGND VGND VPWR VPWR sky130_fd_sc_hd__decap_8
XFILLER_2_324 VGND VGND VPWR VPWR sky130_fd_sc_hd__fill_1
XFILLER_77_125 VPWR VGND VPWR VGND sky130_ef_sc_hd__decap_12
XFILLER_58_383 VGND VGND VPWR VPWR sky130_fd_sc_hd__decap_4
XFILLER_18_247 VGND VGND VPWR VPWR sky130_fd_sc_hd__decap_4
XFILLER_53_72 VGND VGND VPWR VPWR sky130_fd_sc_hd__fill_1
XTAP_TAPCELL_ROW_31_418 VGND VPWR sky130_fd_sc_hd__tapvpwrvgnd_1
X_2440_ mantisaresult\[36\] _0313_ _0318_ VGND VGND VPWR VPWR _0383_ sky130_fd_sc_hd__and3_1
X_2371_ mantisaresult\[32\] mantisaresult\[33\] VGND VGND VPWR VPWR _0314_ sky130_fd_sc_hd__or2_2
X_4110_ clknet_leaf_26_clk _0217_ VGND VGND VPWR VPWR mantisaBshift\[12\] sky130_fd_sc_hd__dfxtp_1
XFILLER_1_390 VGND VGND VPWR VPWR sky130_fd_sc_hd__fill_2
X_4041_ clknet_leaf_11_clk _0152_ VGND VGND VPWR VPWR mantisaresult\[43\] sky130_fd_sc_hd__dfxtp_1
XTAP_TAPCELL_ROW_47_551 VGND VPWR sky130_fd_sc_hd__tapvpwrvgnd_1
XFILLER_64_375 VGND VGND VPWR VPWR sky130_fd_sc_hd__decap_3
XFILLER_20_401 VGND VGND VPWR VPWR sky130_fd_sc_hd__decap_6
X_3825_ net252 _1544_ _1611_ net192 VGND VGND VPWR VPWR _1612_ sky130_fd_sc_hd__o211a_1
X_3756_ _1574_ _1575_ net256 VGND VGND VPWR VPWR _1576_ sky130_fd_sc_hd__mux2_1
X_2707_ mantisaresult\[33\] net156 VGND VGND VPWR VPWR _0650_ sky130_fd_sc_hd__nand2_1
X_3687_ _1422_ _1426_ net270 VGND VGND VPWR VPWR _1514_ sky130_fd_sc_hd__mux2_1
X_2638_ _0534_ _0554_ VGND VGND VPWR VPWR _0581_ sky130_fd_sc_hd__nor2_1
X_2569_ mantisaresult\[29\] _0293_ _0511_ VGND VGND VPWR VPWR _0512_ sky130_fd_sc_hd__or3_1
XFILLER_59_169 VGND VGND VPWR VPWR sky130_fd_sc_hd__fill_1
XFILLER_74_27 VGND VGND VPWR VPWR sky130_fd_sc_hd__fill_1
XTAP_TAPCELL_ROW_2_187 VGND VPWR sky130_fd_sc_hd__tapvpwrvgnd_1
XTAP_TAPCELL_ROW_53_598 VGND VPWR sky130_fd_sc_hd__tapvpwrvgnd_1
XFILLER_70_389 VPWR VGND VPWR VGND sky130_ef_sc_hd__decap_12
XFILLER_7_449 VPWR VGND VPWR VGND sky130_ef_sc_hd__decap_12
XFILLER_7_416 VGND VGND VPWR VPWR sky130_fd_sc_hd__fill_1
XFILLER_23_86 VGND VGND VPWR VPWR sky130_fd_sc_hd__decap_3
XFILLER_2_121 VPWR VGND VPWR VGND sky130_ef_sc_hd__decap_12
XFILLER_78_401 VPWR VGND VPWR VGND sky130_ef_sc_hd__decap_12
XFILLER_2_165 VPWR VGND VPWR VGND sky130_ef_sc_hd__decap_12
XFILLER_78_445 VPWR VGND VPWR VGND sky130_ef_sc_hd__decap_12
XFILLER_38_309 VGND VGND VPWR VPWR sky130_fd_sc_hd__fill_1
XFILLER_65_128 VGND VGND VPWR VPWR sky130_fd_sc_hd__decap_4
XFILLER_65_139 VPWR VGND VPWR VGND sky130_ef_sc_hd__decap_12
XFILLER_0_57 VGND VGND VPWR VPWR sky130_fd_sc_hd__decap_8
XFILLER_46_353 VGND VGND VPWR VPWR sky130_fd_sc_hd__decap_3
XTAP_TAPCELL_ROW_44_521 VGND VPWR sky130_fd_sc_hd__tapvpwrvgnd_1
XFILLER_61_345 VGND VGND VPWR VPWR sky130_fd_sc_hd__decap_8
XFILLER_61_367 VPWR VGND VPWR VGND sky130_ef_sc_hd__decap_12
XFILLER_14_250 VGND VGND VPWR VPWR sky130_fd_sc_hd__fill_2
X_1940_ mantisaresult\[20\] VGND VGND VPWR VPWR _1635_ sky130_fd_sc_hd__inv_2
XFILLER_9_77 VGND VGND VPWR VPWR sky130_fd_sc_hd__fill_1
XFILLER_9_55 VGND VGND VPWR VPWR sky130_fd_sc_hd__fill_1
X_3610_ mantisaB0\[10\] _1420_ _1440_ net273 VGND VGND VPWR VPWR _1441_ sky130_fd_sc_hd__a22oi_2
X_3541_ net333 net207 _1374_ _1376_ VGND VGND VPWR VPWR _0205_ sky130_fd_sc_hd__o22a_1
X_3472_ net349 net213 _1319_ VGND VGND VPWR VPWR _0192_ sky130_fd_sc_hd__a21o_1
X_2423_ _0331_ _0332_ _0365_ VGND VGND VPWR VPWR _0366_ sky130_fd_sc_hd__nor3_1
X_2354_ mantisaresult\[61\] mantisaresult\[60\] VGND VGND VPWR VPWR _0297_ sky130_fd_sc_hd__nor2_1
X_2285_ net27 _1911_ net101 VGND VGND VPWR VPWR _1912_ sky130_fd_sc_hd__mux2_1
X_4024_ clknet_leaf_23_clk _0135_ VGND VGND VPWR VPWR mantisaresult\[27\] sky130_fd_sc_hd__dfxtp_1
XFILLER_56_139 VGND VGND VPWR VPWR sky130_fd_sc_hd__fill_1
XFILLER_64_150 VGND VGND VPWR VPWR sky130_fd_sc_hd__decap_8
XFILLER_12_209 VGND VGND VPWR VPWR sky130_fd_sc_hd__fill_1
XFILLER_20_242 VGND VGND VPWR VPWR sky130_fd_sc_hd__fill_2
XFILLER_20_253 VPWR VGND VPWR VGND sky130_ef_sc_hd__decap_12
XTAP_TAPCELL_ROW_50_568 VGND VPWR sky130_fd_sc_hd__tapvpwrvgnd_1
X_3808_ net190 _1567_ VGND VGND VPWR VPWR _0242_ sky130_fd_sc_hd__nor2_1
XFILLER_60_29 VGND VGND VPWR VPWR sky130_fd_sc_hd__decap_6
XFILLER_20_297 VGND VGND VPWR VPWR sky130_fd_sc_hd__fill_1
X_3739_ net186 _1559_ _1561_ net184 VGND VGND VPWR VPWR _0218_ sky130_fd_sc_hd__a2bb2o_1
XFILLER_79_209 VPWR VGND VPWR VGND sky130_ef_sc_hd__decap_12
XTAP_TAPCELL_ROW_7_224 VGND VPWR sky130_fd_sc_hd__tapvpwrvgnd_1
XTAP_TAPCELL_ROW_58_635 VGND VPWR sky130_fd_sc_hd__tapvpwrvgnd_1
XFILLER_34_41 VGND VGND VPWR VPWR sky130_fd_sc_hd__fill_1
XTAP_TAPCELL_ROW_41_502 VGND VPWR sky130_fd_sc_hd__tapvpwrvgnd_1
XFILLER_70_197 VGND VGND VPWR VPWR sky130_fd_sc_hd__fill_1
XFILLER_3_441 VGND VGND VPWR VPWR sky130_fd_sc_hd__decap_6
XFILLER_78_253 VPWR VGND VPWR VGND sky130_ef_sc_hd__decap_12
XFILLER_15_6 VGND VGND VPWR VPWR sky130_fd_sc_hd__fill_2
X_2070_ net209 net340 VGND VGND VPWR VPWR _0010_ sky130_fd_sc_hd__and2b_1
X_2972_ mantisaresult\[6\] net231 _0899_ _0900_ VGND VGND VPWR VPWR _0112_ sky130_fd_sc_hd__a22o_1
XTAP_TAPCELL_ROW_12_270 VGND VPWR sky130_fd_sc_hd__tapvpwrvgnd_1
X_3524_ _0925_ _1359_ _1360_ net129 VGND VGND VPWR VPWR _1361_ sky130_fd_sc_hd__a211oi_1
X_3455_ _0850_ _1083_ _0854_ _0938_ VGND VGND VPWR VPWR _1312_ sky130_fd_sc_hd__a2bb2o_1
X_2406_ _0331_ _0332_ VGND VGND VPWR VPWR _0349_ sky130_fd_sc_hd__nor2_1
XTAP_TAPCELL_ROW_4_205 VGND VPWR sky130_fd_sc_hd__tapvpwrvgnd_1
X_3386_ mantisaAshift\[60\] mantisaBshift\[60\] VGND VGND VPWR VPWR _1256_ sky130_fd_sc_hd__and2_1
X_2337_ _0285_ net368 net171 VGND VGND VPWR VPWR _0092_ sky130_fd_sc_hd__mux2_1
X_2268_ _1900_ net283 net173 VGND VGND VPWR VPWR _0062_ sky130_fd_sc_hd__mux2_1
X_4007_ clknet_leaf_26_clk _0118_ VGND VGND VPWR VPWR mantisaresult\[12\] sky130_fd_sc_hd__dfxtp_1
XFILLER_55_18 VGND VGND VPWR VPWR sky130_fd_sc_hd__decap_8
X_2199_ net177 _1854_ _1855_ VGND VGND VPWR VPWR _0038_ sky130_fd_sc_hd__a21oi_1
XFILLER_25_334 VGND VGND VPWR VPWR sky130_fd_sc_hd__fill_2
XFILLER_25_389 VGND VGND VPWR VPWR sky130_fd_sc_hd__decap_3
XFILLER_52_175 VGND VGND VPWR VPWR sky130_fd_sc_hd__decap_3
XFILLER_71_28 VGND VGND VPWR VPWR sky130_fd_sc_hd__decap_4
XFILLER_20_32 VGND VGND VPWR VPWR sky130_fd_sc_hd__fill_1
Xhold41 expmiddleb\[0\] VGND VGND VPWR VPWR net315 sky130_fd_sc_hd__dlygate4sd3_1
XFILLER_48_404 VGND VGND VPWR VPWR sky130_fd_sc_hd__decap_6
Xhold30 mantisaA0\[2\] VGND VGND VPWR VPWR net304 sky130_fd_sc_hd__dlygate4sd3_1
Xhold52 four_man\[40\] VGND VGND VPWR VPWR net326 sky130_fd_sc_hd__dlygate4sd3_1
Xhold74 mantisaB0\[5\] VGND VGND VPWR VPWR net348 sky130_fd_sc_hd__dlygate4sd3_1
Xhold63 four_man\[59\] VGND VGND VPWR VPWR net337 sky130_fd_sc_hd__dlygate4sd3_1
Xhold85 expmiddled\[3\] VGND VGND VPWR VPWR net359 sky130_fd_sc_hd__dlygate4sd3_1
Xhold96 mantisaBshift\[35\] VGND VGND VPWR VPWR net370 sky130_fd_sc_hd__dlygate4sd3_1
XTAP_TAPCELL_ROW_18_318 VGND VPWR sky130_fd_sc_hd__tapvpwrvgnd_1
XFILLER_31_337 VGND VGND VPWR VPWR sky130_fd_sc_hd__decap_4
X_3240_ _1122_ VGND VGND VPWR VPWR _1123_ sky130_fd_sc_hd__inv_2
X_3171_ _1050_ _1053_ _1060_ VGND VGND VPWR VPWR _1061_ sky130_fd_sc_hd__a21o_1
XFILLER_13_3 VGND VGND VPWR VPWR sky130_fd_sc_hd__fill_2
X_2122_ net4 net12 VGND VGND VPWR VPWR _1783_ sky130_fd_sc_hd__and2b_1
XTAP_TAPCELL_ROW_77_785 VGND VPWR sky130_fd_sc_hd__tapvpwrvgnd_1
X_2053_ net212 _1741_ VGND VGND VPWR VPWR _0006_ sky130_fd_sc_hd__or2_1
X_2955_ net140 _0775_ _0886_ VGND VGND VPWR VPWR _0887_ sky130_fd_sc_hd__o21ai_1
XTAP_TAPCELL_ROW_60_652 VGND VPWR sky130_fd_sc_hd__tapvpwrvgnd_1
X_2886_ _0633_ _0814_ _0825_ net158 VGND VGND VPWR VPWR _0826_ sky130_fd_sc_hd__o211a_1
X_3507_ net325 net207 _1343_ _1345_ VGND VGND VPWR VPWR _0202_ sky130_fd_sc_hd__o22a_1
X_3438_ net331 net207 _1301_ _1303_ VGND VGND VPWR VPWR _0175_ sky130_fd_sc_hd__o22a_1
X_3369_ mantisaBshift\[57\] mantisaAshift\[57\] VGND VGND VPWR VPWR _1241_ sky130_fd_sc_hd__and2b_1
XFILLER_57_267 VGND VGND VPWR VPWR sky130_fd_sc_hd__fill_1
XFILLER_38_470 VGND VGND VPWR VPWR sky130_fd_sc_hd__decap_3
XFILLER_72_259 VGND VGND VPWR VPWR sky130_fd_sc_hd__fill_1
XFILLER_15_32 VGND VGND VPWR VPWR sky130_fd_sc_hd__decap_8
XFILLER_25_164 VGND VGND VPWR VPWR sky130_fd_sc_hd__decap_4
XFILLER_13_337 VGND VGND VPWR VPWR sky130_fd_sc_hd__decap_8
XTAP_TAPCELL_ROW_23_354 VGND VPWR sky130_fd_sc_hd__tapvpwrvgnd_1
XFILLER_40_189 VGND VGND VPWR VPWR sky130_fd_sc_hd__decap_6
Xoutput75 net75 VGND VGND VPWR VPWR mantisa[10] sky130_fd_sc_hd__buf_2
Xoutput86 net86 VGND VGND VPWR VPWR mantisa[20] sky130_fd_sc_hd__buf_2
Xoutput97 net97 VGND VGND VPWR VPWR sign sky130_fd_sc_hd__buf_2
XFILLER_36_418 VGND VGND VPWR VPWR sky130_fd_sc_hd__fill_2
XFILLER_56_83 VGND VGND VPWR VPWR sky130_fd_sc_hd__fill_1
XFILLER_56_94 VGND VGND VPWR VPWR sky130_fd_sc_hd__decap_3
XFILLER_63_259 VGND VGND VPWR VPWR sky130_fd_sc_hd__decap_8
XTAP_TAPCELL_ROW_74_766 VGND VPWR sky130_fd_sc_hd__tapvpwrvgnd_1
XFILLER_44_462 VGND VGND VPWR VPWR sky130_fd_sc_hd__decap_6
XFILLER_71_281 VPWR VGND VPWR VGND sky130_ef_sc_hd__decap_12
X_2740_ mantisaresult\[17\] net153 VGND VGND VPWR VPWR _0683_ sky130_fd_sc_hd__nand2_1
X_2671_ _1648_ _0610_ net130 _0613_ VGND VGND VPWR VPWR _0614_ sky130_fd_sc_hd__o31a_1
XFILLER_8_363 VGND VGND VPWR VPWR sky130_fd_sc_hd__fill_1
X_3223_ _1096_ _1100_ _1097_ VGND VGND VPWR VPWR _1108_ sky130_fd_sc_hd__o21ai_1
X_3154_ _1043_ _1045_ net249 VGND VGND VPWR VPWR _1046_ sky130_fd_sc_hd__mux2_1
X_2105_ net7 net15 VGND VGND VPWR VPWR _1766_ sky130_fd_sc_hd__and2b_1
X_3085_ _0990_ _0991_ net384 net233 VGND VGND VPWR VPWR _0134_ sky130_fd_sc_hd__a2bb2o_1
XFILLER_39_278 VGND VGND VPWR VPWR sky130_fd_sc_hd__fill_2
X_2036_ expmiddled\[2\] expadd\[2\] VGND VGND VPWR VPWR _1727_ sky130_fd_sc_hd__nand2_1
XFILLER_54_259 VPWR VGND VPWR VGND sky130_ef_sc_hd__decap_12
XTAP_TAPCELL_ROW_37_468 VGND VPWR sky130_fd_sc_hd__tapvpwrvgnd_1
XFILLER_22_134 VGND VGND VPWR VPWR sky130_fd_sc_hd__decap_6
XFILLER_50_454 VGND VGND VPWR VPWR sky130_fd_sc_hd__decap_8
X_3987_ clknet_leaf_17_clk _0103_ VGND VGND VPWR VPWR four_man\[44\] sky130_fd_sc_hd__dfxtp_1
X_2938_ mantisaBshift\[0\] mantisaBshift\[1\] mantisaBshift\[2\] net239 VGND VGND
+ VPWR VPWR _0871_ sky130_fd_sc_hd__o31a_1
XTAP_TAPCELL_ROW_20_335 VGND VPWR sky130_fd_sc_hd__tapvpwrvgnd_1
X_2869_ _0734_ _0736_ net120 VGND VGND VPWR VPWR _0809_ sky130_fd_sc_hd__mux2_1
XFILLER_77_329 VGND VGND VPWR VPWR sky130_fd_sc_hd__decap_6
XFILLER_26_97 VGND VGND VPWR VPWR sky130_fd_sc_hd__decap_6
XFILLER_41_421 VPWR VGND VPWR VGND sky130_ef_sc_hd__decap_12
XFILLER_53_281 VGND VGND VPWR VPWR sky130_fd_sc_hd__fill_1
XTAP_TAPCELL_ROW_71_736 VGND VPWR sky130_fd_sc_hd__tapvpwrvgnd_1
XFILLER_42_85 VGND VGND VPWR VPWR sky130_fd_sc_hd__decap_3
XTAP_TAPCELL_ROW_79_814 VGND VPWR sky130_fd_sc_hd__tapvpwrvgnd_1
XTAP_TAPCELL_ROW_79_803 VGND VPWR sky130_fd_sc_hd__tapvpwrvgnd_1
XFILLER_3_57 VPWR VGND VPWR VGND sky130_ef_sc_hd__decap_12
XFILLER_36_204 VPWR VGND VPWR VGND sky130_ef_sc_hd__decap_12
XFILLER_36_237 VPWR VGND VPWR VGND sky130_ef_sc_hd__decap_12
X_3910_ clknet_leaf_29_clk _0033_ VGND VGND VPWR VPWR expmiddle\[0\] sky130_fd_sc_hd__dfxtp_1
X_3841_ net189 _1610_ VGND VGND VPWR VPWR _0260_ sky130_fd_sc_hd__nor2_1
X_3772_ net186 _1588_ VGND VGND VPWR VPWR _0224_ sky130_fd_sc_hd__nor2_1
X_2723_ mantisaresult\[8\] net152 VGND VGND VPWR VPWR _0666_ sky130_fd_sc_hd__nand2_1
XFILLER_8_160 VGND VGND VPWR VPWR sky130_fd_sc_hd__decap_6
X_2654_ _1626_ _0585_ _0589_ _0595_ _0596_ VGND VGND VPWR VPWR _0597_ sky130_fd_sc_hd__o221a_1
X_2585_ _0496_ _0508_ _0526_ VGND VGND VPWR VPWR _0528_ sky130_fd_sc_hd__nand3_1
Xfanout106 _0743_ VGND VGND VPWR VPWR net106 sky130_fd_sc_hd__buf_2
Xfanout117 net121 VGND VGND VPWR VPWR net117 sky130_fd_sc_hd__clkbuf_4
Xfanout128 net129 VGND VGND VPWR VPWR net128 sky130_fd_sc_hd__buf_2
XFILLER_59_307 VGND VGND VPWR VPWR sky130_fd_sc_hd__decap_8
Xfanout139 net140 VGND VGND VPWR VPWR net139 sky130_fd_sc_hd__buf_1
XFILLER_47_19 VGND VGND VPWR VPWR sky130_fd_sc_hd__fill_2
X_3206_ net244 _1090_ VGND VGND VPWR VPWR _1093_ sky130_fd_sc_hd__nor2_1
XFILLER_67_351 VGND VGND VPWR VPWR sky130_fd_sc_hd__fill_1
X_3137_ mantisaresult\[36\] net205 _1031_ _1032_ VGND VGND VPWR VPWR _0145_ sky130_fd_sc_hd__o22a_1
X_3068_ _0627_ _0756_ _0925_ _0977_ VGND VGND VPWR VPWR _0978_ sky130_fd_sc_hd__a22o_1
X_2019_ _1707_ _1710_ _1713_ VGND VGND VPWR VPWR _1714_ sky130_fd_sc_hd__and3_2
XFILLER_50_251 VGND VGND VPWR VPWR sky130_fd_sc_hd__fill_1
XFILLER_6_119 VGND VGND VPWR VPWR sky130_fd_sc_hd__fill_2
XFILLER_2_358 VGND VGND VPWR VPWR sky130_fd_sc_hd__decap_6
XFILLER_77_137 VPWR VGND VPWR VGND sky130_ef_sc_hd__decap_12
XFILLER_58_340 VPWR VGND VPWR VGND sky130_ef_sc_hd__decap_12
XFILLER_37_41 VGND VGND VPWR VPWR sky130_fd_sc_hd__decap_8
XFILLER_18_226 VPWR VGND VPWR VGND sky130_ef_sc_hd__decap_12
XFILLER_73_321 VPWR VGND VPWR VGND sky130_ef_sc_hd__decap_12
XFILLER_14_421 VPWR VGND VPWR VGND sky130_ef_sc_hd__decap_12
XFILLER_14_410 VGND VGND VPWR VPWR sky130_fd_sc_hd__decap_8
XTAP_TAPCELL_ROW_31_419 VGND VPWR sky130_fd_sc_hd__tapvpwrvgnd_1
X_2370_ net188 _0312_ VGND VGND VPWR VPWR _0313_ sky130_fd_sc_hd__nor2_1
XFILLER_49_351 VGND VGND VPWR VPWR sky130_fd_sc_hd__decap_4
X_4040_ clknet_leaf_12_clk _0151_ VGND VGND VPWR VPWR mantisaresult\[42\] sky130_fd_sc_hd__dfxtp_1
XFILLER_17_281 VGND VGND VPWR VPWR sky130_fd_sc_hd__decap_6
XFILLER_17_292 VPWR VGND VPWR VGND sky130_ef_sc_hd__decap_12
X_3824_ net252 _1539_ VGND VGND VPWR VPWR _1611_ sky130_fd_sc_hd__nand2_1
X_3755_ net262 _1495_ VGND VGND VPWR VPWR _1575_ sky130_fd_sc_hd__or2_1
X_2706_ _0648_ _0640_ net140 VGND VGND VPWR VPWR _0649_ sky130_fd_sc_hd__mux2_1
X_3686_ net257 _1512_ VGND VGND VPWR VPWR _1513_ sky130_fd_sc_hd__or2_1
X_2637_ _0579_ VGND VGND VPWR VPWR _0580_ sky130_fd_sc_hd__inv_2
XPHY_EDGE_ROW_12_Right_12 VGND VGND VPWR VPWR sky130_fd_sc_hd__decap_3
X_2568_ mantisaresult\[28\] _0314_ mantisaresult\[27\] mantisaresult\[26\] VGND VGND
+ VPWR VPWR _0511_ sky130_fd_sc_hd__or4b_1
XFILLER_58_29 VPWR VGND VPWR VGND sky130_ef_sc_hd__decap_12
X_2499_ mantisaresult\[4\] _0437_ VGND VGND VPWR VPWR _0442_ sky130_fd_sc_hd__or2_1
XFILLER_59_148 VGND VGND VPWR VPWR sky130_fd_sc_hd__decap_3
XTAP_TAPCELL_ROW_2_188 VGND VPWR sky130_fd_sc_hd__tapvpwrvgnd_1
XPHY_EDGE_ROW_21_Right_21 VGND VGND VPWR VPWR sky130_fd_sc_hd__decap_3
XFILLER_70_302 VGND VGND VPWR VPWR sky130_fd_sc_hd__decap_6
XTAP_TAPCELL_ROW_53_599 VGND VPWR sky130_fd_sc_hd__tapvpwrvgnd_1
XFILLER_23_32 VPWR VGND VPWR VGND sky130_ef_sc_hd__decap_12
XFILLER_23_284 VPWR VGND VPWR VGND sky130_ef_sc_hd__decap_12
XFILLER_7_439 VGND VGND VPWR VPWR sky130_fd_sc_hd__decap_8
XPHY_EDGE_ROW_30_Right_30 VGND VGND VPWR VPWR sky130_fd_sc_hd__decap_3
XFILLER_2_133 VGND VGND VPWR VPWR sky130_fd_sc_hd__decap_6
XFILLER_78_413 VGND VGND VPWR VPWR sky130_fd_sc_hd__decap_6
XFILLER_2_177 VPWR VGND VPWR VGND sky130_ef_sc_hd__decap_12
XFILLER_78_457 VPWR VGND VPWR VGND sky130_ef_sc_hd__decap_12
XFILLER_46_321 VGND VGND VPWR VPWR sky130_fd_sc_hd__fill_2
XFILLER_0_69 VGND VGND VPWR VPWR sky130_fd_sc_hd__decap_4
XTAP_TAPCELL_ROW_44_522 VGND VPWR sky130_fd_sc_hd__tapvpwrvgnd_1
XFILLER_61_335 VGND VGND VPWR VPWR sky130_fd_sc_hd__fill_1
XFILLER_64_83 VGND VGND VPWR VPWR sky130_fd_sc_hd__fill_1
XFILLER_61_379 VGND VGND VPWR VPWR sky130_fd_sc_hd__fill_2
X_3540_ mantisaresult\[58\] net195 net164 _1375_ VGND VGND VPWR VPWR _1376_ sky130_fd_sc_hd__a31o_1
XFILLER_6_450 VPWR VGND VPWR VGND sky130_ef_sc_hd__decap_12
X_3471_ net343 net213 _1319_ VGND VGND VPWR VPWR _0191_ sky130_fd_sc_hd__a21o_1
X_2422_ mantisaresult\[17\] _0359_ _0364_ VGND VGND VPWR VPWR _0365_ sky130_fd_sc_hd__or3_1
XFILLER_69_402 VGND VGND VPWR VPWR sky130_fd_sc_hd__decap_3
X_2353_ mantisaresult\[63\] mantisaresult\[62\] VGND VGND VPWR VPWR _0296_ sky130_fd_sc_hd__or2_1
X_4023_ clknet_leaf_2_clk _0134_ VGND VGND VPWR VPWR mantisaresult\[26\] sky130_fd_sc_hd__dfxtp_1
X_2284_ net50 net168 VGND VGND VPWR VPWR _1911_ sky130_fd_sc_hd__and2_1
XFILLER_37_332 VGND VGND VPWR VPWR sky130_fd_sc_hd__decap_4
XFILLER_49_192 VGND VGND VPWR VPWR sky130_fd_sc_hd__fill_1
XFILLER_64_195 VGND VGND VPWR VPWR sky130_fd_sc_hd__fill_1
XFILLER_20_221 VPWR VGND VPWR VGND sky130_ef_sc_hd__decap_12
XTAP_TAPCELL_ROW_15_290 VGND VPWR sky130_fd_sc_hd__tapvpwrvgnd_1
XFILLER_20_265 VGND VGND VPWR VPWR sky130_fd_sc_hd__decap_4
XTAP_TAPCELL_ROW_50_569 VGND VPWR sky130_fd_sc_hd__tapvpwrvgnd_1
X_3807_ net190 _1559_ VGND VGND VPWR VPWR _0241_ sky130_fd_sc_hd__nor2_1
X_1999_ _1691_ _1693_ VGND VGND VPWR VPWR _1694_ sky130_fd_sc_hd__nor2_2
X_3738_ net261 net268 _1514_ VGND VGND VPWR VPWR _1561_ sky130_fd_sc_hd__and3_1
X_3669_ _1419_ _1498_ VGND VGND VPWR VPWR _0211_ sky130_fd_sc_hd__nor2_1
XTAP_TAPCELL_ROW_7_225 VGND VPWR sky130_fd_sc_hd__tapvpwrvgnd_1
XFILLER_75_405 VPWR VGND VPWR VGND sky130_ef_sc_hd__decap_12
XFILLER_75_449 VPWR VGND VPWR VGND sky130_ef_sc_hd__decap_12
XTAP_TAPCELL_ROW_58_636 VGND VPWR sky130_fd_sc_hd__tapvpwrvgnd_1
XFILLER_28_365 VGND VGND VPWR VPWR sky130_fd_sc_hd__fill_1
XFILLER_43_346 VGND VGND VPWR VPWR sky130_fd_sc_hd__decap_8
XTAP_TAPCELL_ROW_41_503 VGND VPWR sky130_fd_sc_hd__tapvpwrvgnd_1
XFILLER_11_254 VGND VGND VPWR VPWR sky130_fd_sc_hd__decap_8
XFILLER_50_85 VPWR VGND VPWR VGND sky130_ef_sc_hd__decap_12
XFILLER_78_265 VPWR VGND VPWR VGND sky130_ef_sc_hd__decap_12
XFILLER_19_321 VPWR VGND VPWR VGND sky130_ef_sc_hd__decap_12
XFILLER_34_324 VGND VGND VPWR VPWR sky130_fd_sc_hd__decap_6
XFILLER_61_143 VPWR VGND VPWR VGND sky130_ef_sc_hd__decap_12
X_2971_ mantisaBshift\[6\] _0898_ net232 VGND VGND VPWR VPWR _0900_ sky130_fd_sc_hd__a21oi_1
XTAP_TAPCELL_ROW_12_271 VGND VPWR sky130_fd_sc_hd__tapvpwrvgnd_1
X_3523_ _0603_ _0722_ _0921_ _1016_ VGND VGND VPWR VPWR _1360_ sky130_fd_sc_hd__a22o_1
X_3454_ net149 _0861_ _0936_ VGND VGND VPWR VPWR _1311_ sky130_fd_sc_hd__and3_1
X_2405_ _0306_ _0340_ _0345_ VGND VGND VPWR VPWR _0348_ sky130_fd_sc_hd__or3_2
XTAP_TAPCELL_ROW_4_206 VGND VPWR sky130_fd_sc_hd__tapvpwrvgnd_1
X_3385_ mantisaAshift\[60\] mantisaBshift\[60\] VGND VGND VPWR VPWR _1255_ sky130_fd_sc_hd__or2_1
X_2336_ _1913_ net29 net100 VGND VGND VPWR VPWR _0285_ sky130_fd_sc_hd__mux2_1
X_2267_ net21 _1899_ net103 VGND VGND VPWR VPWR _1900_ sky130_fd_sc_hd__mux2_1
X_4006_ clknet_leaf_24_clk _0117_ VGND VGND VPWR VPWR mantisaresult\[11\] sky130_fd_sc_hd__dfxtp_1
XFILLER_72_419 VGND VGND VPWR VPWR sky130_fd_sc_hd__fill_1
X_2198_ expmiddle\[5\] net177 VGND VGND VPWR VPWR _1855_ sky130_fd_sc_hd__nor2_1
XTAP_TAPCELL_ROW_63_672 VGND VPWR sky130_fd_sc_hd__tapvpwrvgnd_1
XFILLER_20_11 VGND VGND VPWR VPWR sky130_fd_sc_hd__decap_3
XFILLER_0_401 VGND VGND VPWR VPWR sky130_fd_sc_hd__fill_1
Xhold31 expmiddlea\[1\] VGND VGND VPWR VPWR net305 sky130_fd_sc_hd__dlygate4sd3_1
XFILLER_29_53 VGND VGND VPWR VPWR sky130_fd_sc_hd__decap_3
Xhold20 mantisaA0\[18\] VGND VGND VPWR VPWR net294 sky130_fd_sc_hd__dlygate4sd3_1
XFILLER_75_213 VGND VGND VPWR VPWR sky130_fd_sc_hd__decap_6
Xhold42 expmiddleb\[6\] VGND VGND VPWR VPWR net316 sky130_fd_sc_hd__dlygate4sd3_1
Xhold53 four_man\[42\] VGND VGND VPWR VPWR net327 sky130_fd_sc_hd__dlygate4sd3_1
Xhold64 four_man\[52\] VGND VGND VPWR VPWR net338 sky130_fd_sc_hd__dlygate4sd3_1
Xhold75 expadd\[7\] VGND VGND VPWR VPWR net349 sky130_fd_sc_hd__dlygate4sd3_1
Xhold97 mantisaB0\[2\] VGND VGND VPWR VPWR net371 sky130_fd_sc_hd__dlygate4sd3_1
Xhold86 mantisaB0\[7\] VGND VGND VPWR VPWR net360 sky130_fd_sc_hd__dlygate4sd3_1
XTAP_TAPCELL_ROW_18_319 VGND VPWR sky130_fd_sc_hd__tapvpwrvgnd_1
XFILLER_16_324 VGND VGND VPWR VPWR sky130_fd_sc_hd__fill_1
XFILLER_16_335 VGND VGND VPWR VPWR sky130_fd_sc_hd__fill_2
XFILLER_71_441 VGND VGND VPWR VPWR sky130_fd_sc_hd__decap_6
XFILLER_24_390 VPWR VGND VPWR VGND sky130_ef_sc_hd__decap_12
XFILLER_3_261 VPWR VGND VPWR VGND sky130_ef_sc_hd__decap_12
X_3170_ mantisaBshift\[41\] mantisaAshift\[41\] VGND VGND VPWR VPWR _1060_ sky130_fd_sc_hd__and2b_1
X_2121_ net12 net4 VGND VGND VPWR VPWR _1782_ sky130_fd_sc_hd__nand2b_1
X_2052_ _1739_ _1740_ VGND VGND VPWR VPWR _1741_ sky130_fd_sc_hd__xnor2_1
XFILLER_54_419 VGND VGND VPWR VPWR sky130_fd_sc_hd__fill_1
XTAP_TAPCELL_ROW_77_786 VGND VPWR sky130_fd_sc_hd__tapvpwrvgnd_1
XFILLER_19_151 VGND VGND VPWR VPWR sky130_fd_sc_hd__fill_1
XFILLER_34_110 VGND VGND VPWR VPWR sky130_fd_sc_hd__fill_1
XFILLER_15_390 VGND VGND VPWR VPWR sky130_fd_sc_hd__fill_2
X_2954_ net140 _0769_ VGND VGND VPWR VPWR _0886_ sky130_fd_sc_hd__nand2_1
XTAP_TAPCELL_ROW_60_653 VGND VPWR sky130_fd_sc_hd__tapvpwrvgnd_1
X_2885_ net128 _0824_ _0804_ VGND VGND VPWR VPWR _0825_ sky130_fd_sc_hd__a21oi_1
XPHY_EDGE_ROW_6_Right_6 VGND VGND VPWR VPWR sky130_fd_sc_hd__decap_3
X_3506_ mantisaresult\[55\] net195 net165 _1344_ net216 VGND VGND VPWR VPWR _1345_
+ sky130_fd_sc_hd__a311o_1
X_3437_ net219 net197 net164 _1302_ VGND VGND VPWR VPWR _1303_ sky130_fd_sc_hd__a31o_1
X_3368_ _1218_ _1232_ VGND VGND VPWR VPWR _1240_ sky130_fd_sc_hd__nand2_1
XFILLER_57_213 VGND VGND VPWR VPWR sky130_fd_sc_hd__fill_2
X_2319_ _0276_ net372 net173 VGND VGND VPWR VPWR _0083_ sky130_fd_sc_hd__mux2_1
X_3299_ mantisaAshift\[53\] mantisaBshift\[53\] VGND VGND VPWR VPWR _1177_ sky130_fd_sc_hd__or2_1
XTAP_TAPCELL_ROW_23_355 VGND VPWR sky130_fd_sc_hd__tapvpwrvgnd_1
XFILLER_40_168 VGND VGND VPWR VPWR sky130_fd_sc_hd__decap_4
XFILLER_21_393 VPWR VGND VPWR VGND sky130_ef_sc_hd__decap_12
XFILLER_31_54 VGND VGND VPWR VPWR sky130_fd_sc_hd__fill_2
Xoutput76 net76 VGND VGND VPWR VPWR mantisa[11] sky130_fd_sc_hd__buf_2
Xoutput87 net87 VGND VGND VPWR VPWR mantisa[21] sky130_fd_sc_hd__buf_2
XFILLER_0_253 VPWR VGND VPWR VGND sky130_ef_sc_hd__decap_12
XFILLER_29_471 VGND VGND VPWR VPWR sky130_fd_sc_hd__fill_2
XFILLER_16_121 VGND VGND VPWR VPWR sky130_fd_sc_hd__decap_8
XFILLER_16_110 VGND VGND VPWR VPWR sky130_fd_sc_hd__decap_3
XFILLER_44_441 VGND VGND VPWR VPWR sky130_fd_sc_hd__fill_1
XTAP_TAPCELL_ROW_74_767 VGND VPWR sky130_fd_sc_hd__tapvpwrvgnd_1
XFILLER_31_113 VGND VGND VPWR VPWR sky130_fd_sc_hd__fill_1
XFILLER_71_293 VPWR VGND VPWR VGND sky130_ef_sc_hd__decap_12
XPHY_EDGE_ROW_59_Right_59 VGND VGND VPWR VPWR sky130_fd_sc_hd__decap_3
X_2670_ mantisaresult\[0\] net111 VGND VGND VPWR VPWR _0613_ sky130_fd_sc_hd__nand2_1
XFILLER_75_6 VGND VGND VPWR VPWR sky130_fd_sc_hd__decap_4
X_3222_ _1105_ _1106_ VGND VGND VPWR VPWR _1107_ sky130_fd_sc_hd__nand2_1
XFILLER_79_393 VPWR VGND VPWR VGND sky130_ef_sc_hd__decap_12
X_3153_ _1005_ _1029_ _1044_ mantisaBshift\[39\] _1678_ VGND VGND VPWR VPWR _1045_
+ sky130_fd_sc_hd__o32a_1
XPHY_EDGE_ROW_68_Right_68 VGND VGND VPWR VPWR sky130_fd_sc_hd__decap_3
X_2104_ _1763_ _1764_ VGND VGND VPWR VPWR _1765_ sky130_fd_sc_hd__nand2b_1
X_3084_ net241 mantisaBshift\[26\] _0989_ net233 VGND VGND VPWR VPWR _0991_ sky130_fd_sc_hd__a31o_1
X_2035_ net212 _1726_ VGND VGND VPWR VPWR _0003_ sky130_fd_sc_hd__or2_1
XFILLER_54_249 VGND VGND VPWR VPWR sky130_fd_sc_hd__decap_3
XTAP_TAPCELL_ROW_37_469 VGND VPWR sky130_fd_sc_hd__tapvpwrvgnd_1
XFILLER_50_433 VGND VGND VPWR VPWR sky130_fd_sc_hd__fill_1
XPHY_EDGE_ROW_77_Right_77 VGND VGND VPWR VPWR sky130_fd_sc_hd__decap_3
X_3986_ clknet_leaf_26_clk net298 VGND VGND VPWR VPWR expmiddleb\[5\] sky130_fd_sc_hd__dfxtp_1
X_2937_ mantisaresult\[2\] _0870_ net201 VGND VGND VPWR VPWR _0107_ sky130_fd_sc_hd__mux2_1
XFILLER_10_319 VGND VGND VPWR VPWR sky130_fd_sc_hd__decap_4
X_2868_ _0807_ _0805_ net143 VGND VGND VPWR VPWR _0808_ sky130_fd_sc_hd__mux2_1
X_2799_ _0732_ _0740_ net124 VGND VGND VPWR VPWR _0741_ sky130_fd_sc_hd__mux2_1
XPHY_EDGE_ROW_15_Left_95 VGND VGND VPWR VPWR sky130_fd_sc_hd__decap_3
XFILLER_26_21 VGND VGND VPWR VPWR sky130_fd_sc_hd__decap_6
XFILLER_26_430 VPWR VGND VPWR VGND sky130_ef_sc_hd__decap_12
XFILLER_13_113 VGND VGND VPWR VPWR sky130_fd_sc_hd__decap_3
XFILLER_41_433 VPWR VGND VPWR VGND sky130_ef_sc_hd__decap_12
XTAP_TAPCELL_ROW_71_737 VGND VPWR sky130_fd_sc_hd__tapvpwrvgnd_1
XTAP_TAPCELL_ROW_79_815 VGND VPWR sky130_fd_sc_hd__tapvpwrvgnd_1
XTAP_TAPCELL_ROW_79_804 VGND VPWR sky130_fd_sc_hd__tapvpwrvgnd_1
XFILLER_3_69 VPWR VGND VPWR VGND sky130_ef_sc_hd__decap_12
XFILLER_76_363 VGND VGND VPWR VPWR sky130_fd_sc_hd__fill_1
XFILLER_36_216 VGND VGND VPWR VPWR sky130_fd_sc_hd__fill_2
XFILLER_36_249 VGND VGND VPWR VPWR sky130_fd_sc_hd__decap_3
X_3840_ net258 _1500_ _1571_ VGND VGND VPWR VPWR _0259_ sky130_fd_sc_hd__nor3_1
X_3771_ net253 _1585_ _1587_ VGND VGND VPWR VPWR _1588_ sky130_fd_sc_hd__a21o_1
X_2722_ _0649_ _0664_ net123 VGND VGND VPWR VPWR _0665_ sky130_fd_sc_hd__mux2_1
X_2653_ expmiddlec\[2\] _0587_ VGND VGND VPWR VPWR _0596_ sky130_fd_sc_hd__nand2_1
X_2584_ _1632_ _0373_ _0525_ _0526_ _0503_ VGND VGND VPWR VPWR _0527_ sky130_fd_sc_hd__o311a_1
Xfanout107 net108 VGND VGND VPWR VPWR net107 sky130_fd_sc_hd__buf_2
Xfanout129 _0629_ VGND VGND VPWR VPWR net129 sky130_fd_sc_hd__buf_2
Xfanout118 net119 VGND VGND VPWR VPWR net118 sky130_fd_sc_hd__clkbuf_4
X_3205_ _1067_ _1070_ _1091_ VGND VGND VPWR VPWR _1092_ sky130_fd_sc_hd__a21o_1
X_3136_ net249 _1677_ _1030_ net235 VGND VGND VPWR VPWR _1032_ sky130_fd_sc_hd__a31o_1
X_3067_ _0976_ VGND VGND VPWR VPWR _0977_ sky130_fd_sc_hd__inv_2
X_2018_ _1711_ _1712_ VGND VGND VPWR VPWR _1713_ sky130_fd_sc_hd__nor2_1
XFILLER_10_116 VGND VGND VPWR VPWR sky130_fd_sc_hd__fill_1
XFILLER_50_285 VGND VGND VPWR VPWR sky130_fd_sc_hd__fill_2
X_3969_ clknet_leaf_0_clk _0092_ VGND VGND VPWR VPWR mantisaB0\[20\] sky130_fd_sc_hd__dfxtp_1
XFILLER_2_348 VGND VGND VPWR VPWR sky130_fd_sc_hd__decap_6
XFILLER_5_6 VPWR VGND VPWR VGND sky130_ef_sc_hd__decap_12
XFILLER_77_149 VGND VGND VPWR VPWR sky130_fd_sc_hd__decap_3
XFILLER_58_352 VPWR VGND VPWR VGND sky130_ef_sc_hd__decap_12
XFILLER_37_53 VGND VGND VPWR VPWR sky130_fd_sc_hd__decap_3
XFILLER_73_333 VGND VGND VPWR VPWR sky130_fd_sc_hd__decap_3
XFILLER_14_433 VPWR VGND VPWR VGND sky130_ef_sc_hd__decap_12
XFILLER_53_52 VGND VGND VPWR VPWR sky130_fd_sc_hd__decap_4
XFILLER_78_93 VGND VGND VPWR VPWR sky130_fd_sc_hd__decap_3
XFILLER_38_6 VGND VGND VPWR VPWR sky130_fd_sc_hd__decap_4
XFILLER_64_300 VGND VGND VPWR VPWR sky130_fd_sc_hd__fill_2
XFILLER_64_399 VPWR VGND VPWR VGND sky130_ef_sc_hd__decap_12
X_3823_ _1419_ _1610_ _1609_ VGND VGND VPWR VPWR _0253_ sky130_fd_sc_hd__o21ai_1
XFILLER_32_285 VGND VGND VPWR VPWR sky130_fd_sc_hd__decap_3
X_3754_ _1474_ _1485_ net262 VGND VGND VPWR VPWR _1574_ sky130_fd_sc_hd__mux2_1
X_2705_ _0647_ VGND VGND VPWR VPWR _0648_ sky130_fd_sc_hd__inv_2
X_3685_ _1508_ _1511_ net261 VGND VGND VPWR VPWR _1512_ sky130_fd_sc_hd__mux2_1
X_2636_ _0543_ _0576_ VGND VGND VPWR VPWR _0579_ sky130_fd_sc_hd__xor2_1
X_2567_ _0428_ _0453_ _0509_ _0508_ _0496_ VGND VGND VPWR VPWR _0510_ sky130_fd_sc_hd__o311a_1
X_2498_ _0292_ _0361_ _0439_ _0440_ _0438_ VGND VGND VPWR VPWR _0441_ sky130_fd_sc_hd__o41a_1
XFILLER_59_105 VGND VGND VPWR VPWR sky130_fd_sc_hd__decap_6
XPHY_EDGE_ROW_27_Left_107 VGND VGND VPWR VPWR sky130_fd_sc_hd__decap_3
XTAP_TAPCELL_ROW_2_189 VGND VPWR sky130_fd_sc_hd__tapvpwrvgnd_1
X_3119_ net124 _0740_ _1017_ VGND VGND VPWR VPWR _1018_ sky130_fd_sc_hd__o21a_1
X_4099_ clknet_leaf_16_clk _0206_ VGND VGND VPWR VPWR four_man\[58\] sky130_fd_sc_hd__dfxtp_1
XFILLER_70_325 VGND VGND VPWR VPWR sky130_fd_sc_hd__fill_1
XFILLER_23_11 VGND VGND VPWR VPWR sky130_fd_sc_hd__fill_1
XFILLER_11_447 VGND VGND VPWR VPWR sky130_fd_sc_hd__fill_1
XFILLER_23_44 VGND VGND VPWR VPWR sky130_fd_sc_hd__fill_2
XFILLER_23_296 VGND VGND VPWR VPWR sky130_fd_sc_hd__decap_4
XPHY_EDGE_ROW_36_Left_116 VGND VGND VPWR VPWR sky130_fd_sc_hd__decap_3
XFILLER_3_3 VPWR VGND VPWR VGND sky130_ef_sc_hd__decap_12
XFILLER_2_189 VGND VGND VPWR VPWR sky130_fd_sc_hd__decap_6
XFILLER_78_469 VGND VGND VPWR VPWR sky130_fd_sc_hd__decap_4
XFILLER_48_41 VGND VGND VPWR VPWR sky130_fd_sc_hd__fill_2
XPHY_EDGE_ROW_45_Left_125 VGND VGND VPWR VPWR sky130_fd_sc_hd__decap_3
XFILLER_48_85 VGND VGND VPWR VPWR sky130_fd_sc_hd__fill_1
XFILLER_0_15 VPWR VGND VPWR VGND sky130_ef_sc_hd__decap_12
XTAP_TAPCELL_ROW_44_523 VGND VPWR sky130_fd_sc_hd__tapvpwrvgnd_1
XFILLER_14_230 VPWR VGND VPWR VGND sky130_ef_sc_hd__decap_12
XFILLER_9_68 VGND VGND VPWR VPWR sky130_fd_sc_hd__decap_3
XPHY_EDGE_ROW_54_Left_134 VGND VGND VPWR VPWR sky130_fd_sc_hd__decap_3
XFILLER_6_462 VGND VGND VPWR VPWR sky130_fd_sc_hd__decap_8
X_3470_ net352 net213 _1319_ _1320_ VGND VGND VPWR VPWR _0190_ sky130_fd_sc_hd__a22o_1
X_2421_ mantisaresult\[18\] _0362_ VGND VGND VPWR VPWR _0364_ sky130_fd_sc_hd__or2_1
X_2352_ _0293_ _0294_ VGND VGND VPWR VPWR _0295_ sky130_fd_sc_hd__nor2_1
XFILLER_36_3 VGND VGND VPWR VPWR sky130_fd_sc_hd__fill_1
XFILLER_69_425 VGND VGND VPWR VPWR sky130_fd_sc_hd__fill_1
XPHY_EDGE_ROW_63_Left_143 VGND VGND VPWR VPWR sky130_fd_sc_hd__decap_3
X_2283_ _1910_ net294 net174 VGND VGND VPWR VPWR _0067_ sky130_fd_sc_hd__mux2_1
X_4022_ clknet_leaf_23_clk _0133_ VGND VGND VPWR VPWR mantisaresult\[25\] sky130_fd_sc_hd__dfxtp_1
XFILLER_64_185 VGND VGND VPWR VPWR sky130_fd_sc_hd__decap_3
XPHY_EDGE_ROW_72_Left_152 VGND VGND VPWR VPWR sky130_fd_sc_hd__decap_3
XFILLER_20_233 VGND VGND VPWR VPWR sky130_fd_sc_hd__decap_4
XTAP_TAPCELL_ROW_15_291 VGND VPWR sky130_fd_sc_hd__tapvpwrvgnd_1
X_3806_ net190 _1549_ VGND VGND VPWR VPWR _0240_ sky130_fd_sc_hd__nor2_1
X_3737_ net268 _1514_ VGND VGND VPWR VPWR _1560_ sky130_fd_sc_hd__nand2_1
X_1998_ _1689_ _1690_ _1692_ VGND VGND VPWR VPWR _1693_ sky130_fd_sc_hd__or3_1
X_3668_ net256 _1475_ _1497_ VGND VGND VPWR VPWR _1498_ sky130_fd_sc_hd__o21ai_1
X_2619_ _0353_ _0483_ _0561_ _0381_ _0394_ VGND VGND VPWR VPWR _0562_ sky130_fd_sc_hd__o2111a_1
X_3599_ net250 mantisaB0\[7\] VGND VGND VPWR VPWR _1430_ sky130_fd_sc_hd__and2b_1
XTAP_TAPCELL_ROW_7_226 VGND VPWR sky130_fd_sc_hd__tapvpwrvgnd_1
XFILLER_75_417 VPWR VGND VPWR VGND sky130_ef_sc_hd__decap_12
XFILLER_18_44 VGND VGND VPWR VPWR sky130_fd_sc_hd__fill_2
XTAP_TAPCELL_ROW_58_637 VGND VPWR sky130_fd_sc_hd__tapvpwrvgnd_1
XFILLER_55_141 VPWR VGND VPWR VGND sky130_ef_sc_hd__decap_12
XFILLER_70_122 VGND VGND VPWR VPWR sky130_fd_sc_hd__fill_2
XFILLER_51_391 VGND VGND VPWR VPWR sky130_fd_sc_hd__fill_1
XFILLER_11_244 VGND VGND VPWR VPWR sky130_fd_sc_hd__fill_1
XFILLER_50_42 VGND VGND VPWR VPWR sky130_fd_sc_hd__fill_1
XFILLER_50_97 VGND VGND VPWR VPWR sky130_fd_sc_hd__decap_6
XFILLER_78_211 VGND VGND VPWR VPWR sky130_fd_sc_hd__fill_1
XFILLER_78_222 VPWR VGND VPWR VGND sky130_ef_sc_hd__decap_12
XFILLER_59_84 VGND VGND VPWR VPWR sky130_fd_sc_hd__decap_4
XFILLER_78_277 VPWR VGND VPWR VGND sky130_ef_sc_hd__decap_12
XPHY_EDGE_ROW_3_Left_83 VGND VGND VPWR VPWR sky130_fd_sc_hd__decap_3
XFILLER_19_311 VGND VGND VPWR VPWR sky130_fd_sc_hd__fill_2
XFILLER_19_333 VGND VGND VPWR VPWR sky130_fd_sc_hd__decap_3
XFILLER_46_141 VGND VGND VPWR VPWR sky130_fd_sc_hd__decap_8
X_2970_ mantisaBshift\[6\] _0898_ VGND VGND VPWR VPWR _0899_ sky130_fd_sc_hd__or2_1
XFILLER_61_155 VGND VGND VPWR VPWR sky130_fd_sc_hd__decap_8
XFILLER_61_177 VGND VGND VPWR VPWR sky130_fd_sc_hd__fill_1
X_3522_ _1358_ _1306_ net147 VGND VGND VPWR VPWR _1359_ sky130_fd_sc_hd__mux2_1
X_3453_ _1308_ _1309_ net125 VGND VGND VPWR VPWR _1310_ sky130_fd_sc_hd__o21a_1
X_2404_ _0306_ _0340_ _0345_ VGND VGND VPWR VPWR _0347_ sky130_fd_sc_hd__nor3_2
X_3384_ mantisaAshift\[60\] mantisaBshift\[60\] VGND VGND VPWR VPWR _1254_ sky130_fd_sc_hd__nor2_1
XFILLER_69_222 VGND VGND VPWR VPWR sky130_fd_sc_hd__fill_2
XTAP_TAPCELL_ROW_4_207 VGND VPWR sky130_fd_sc_hd__tapvpwrvgnd_1
X_2335_ _0284_ net350 net171 VGND VGND VPWR VPWR _0091_ sky130_fd_sc_hd__mux2_1
XFILLER_57_439 VGND VGND VPWR VPWR sky130_fd_sc_hd__fill_1
X_2266_ net44 net169 VGND VGND VPWR VPWR _1899_ sky130_fd_sc_hd__and2_1
X_2197_ _1831_ _1853_ VGND VGND VPWR VPWR _1854_ sky130_fd_sc_hd__xnor2_1
X_4005_ clknet_leaf_24_clk _0116_ VGND VGND VPWR VPWR mantisaresult\[10\] sky130_fd_sc_hd__dfxtp_1
XFILLER_25_325 VGND VGND VPWR VPWR sky130_fd_sc_hd__fill_1
XFILLER_37_185 VPWR VGND VPWR VGND sky130_ef_sc_hd__decap_12
XFILLER_40_306 VGND VGND VPWR VPWR sky130_fd_sc_hd__fill_2
XTAP_TAPCELL_ROW_63_673 VGND VPWR sky130_fd_sc_hd__tapvpwrvgnd_1
XFILLER_33_380 VGND VGND VPWR VPWR sky130_fd_sc_hd__decap_4
Xhold10 mantisaA0\[11\] VGND VGND VPWR VPWR net284 sky130_fd_sc_hd__dlygate4sd3_1
Xhold32 signA0 VGND VGND VPWR VPWR net306 sky130_fd_sc_hd__dlygate4sd3_1
Xhold21 mantisaA0\[8\] VGND VGND VPWR VPWR net295 sky130_fd_sc_hd__dlygate4sd3_1
Xhold43 expmiddleb\[2\] VGND VGND VPWR VPWR net317 sky130_fd_sc_hd__dlygate4sd3_1
XFILLER_48_439 VGND VGND VPWR VPWR sky130_fd_sc_hd__decap_4
Xhold65 four_man\[45\] VGND VGND VPWR VPWR net339 sky130_fd_sc_hd__dlygate4sd3_1
Xhold54 four_man\[49\] VGND VGND VPWR VPWR net328 sky130_fd_sc_hd__dlygate4sd3_1
Xhold87 expmiddled\[6\] VGND VGND VPWR VPWR net361 sky130_fd_sc_hd__dlygate4sd3_1
Xhold76 mantisaB0\[19\] VGND VGND VPWR VPWR net350 sky130_fd_sc_hd__dlygate4sd3_1
Xhold98 mantisaB0\[11\] VGND VGND VPWR VPWR net372 sky130_fd_sc_hd__dlygate4sd3_1
XFILLER_28_174 VGND VGND VPWR VPWR sky130_fd_sc_hd__decap_4
XFILLER_43_144 VGND VGND VPWR VPWR sky130_fd_sc_hd__decap_8
XFILLER_43_166 VGND VGND VPWR VPWR sky130_fd_sc_hd__fill_2
XFILLER_3_273 VGND VGND VPWR VPWR sky130_fd_sc_hd__decap_4
X_2120_ net12 net4 VGND VGND VPWR VPWR _1781_ sky130_fd_sc_hd__and2b_1
X_2051_ _1733_ _1735_ _1732_ VGND VGND VPWR VPWR _1740_ sky130_fd_sc_hd__a21bo_1
XTAP_TAPCELL_ROW_77_787 VGND VPWR sky130_fd_sc_hd__tapvpwrvgnd_1
XFILLER_47_472 VGND VGND VPWR VPWR sky130_fd_sc_hd__fill_1
XFILLER_74_291 VPWR VGND VPWR VGND sky130_ef_sc_hd__decap_12
XFILLER_15_380 VGND VGND VPWR VPWR sky130_fd_sc_hd__fill_2
X_2953_ _0768_ _0765_ net138 VGND VGND VPWR VPWR _0885_ sky130_fd_sc_hd__mux2_1
XTAP_TAPCELL_ROW_60_654 VGND VPWR sky130_fd_sc_hd__tapvpwrvgnd_1
X_2884_ _0819_ _0823_ net124 VGND VGND VPWR VPWR _0824_ sky130_fd_sc_hd__mux2_1
X_3505_ mantisaresult\[54\] net195 net161 VGND VGND VPWR VPWR _1344_ sky130_fd_sc_hd__and3_1
X_3436_ mantisaresult\[51\] net197 net160 net215 VGND VGND VPWR VPWR _1302_ sky130_fd_sc_hd__a31o_1
X_3367_ _1237_ _1238_ VGND VGND VPWR VPWR _1239_ sky130_fd_sc_hd__nand2b_1
X_2318_ _1895_ net19 net104 VGND VGND VPWR VPWR _0276_ sky130_fd_sc_hd__mux2_1
X_3298_ mantisaAshift\[53\] mantisaBshift\[53\] VGND VGND VPWR VPWR _1176_ sky130_fd_sc_hd__and2_1
X_2249_ net37 _1887_ net104 VGND VGND VPWR VPWR _1888_ sky130_fd_sc_hd__mux2_1
XFILLER_25_133 VGND VGND VPWR VPWR sky130_fd_sc_hd__decap_6
XFILLER_15_78 VGND VGND VPWR VPWR sky130_fd_sc_hd__decap_8
XTAP_TAPCELL_ROW_23_356 VGND VPWR sky130_fd_sc_hd__tapvpwrvgnd_1
XFILLER_0_221 VGND VGND VPWR VPWR sky130_fd_sc_hd__decap_3
Xoutput66 net66 VGND VGND VPWR VPWR exp[0] sky130_fd_sc_hd__buf_2
Xoutput77 net77 VGND VGND VPWR VPWR mantisa[12] sky130_fd_sc_hd__buf_2
Xoutput88 net88 VGND VGND VPWR VPWR mantisa[22] sky130_fd_sc_hd__buf_2
XFILLER_0_265 VPWR VGND VPWR VGND sky130_ef_sc_hd__decap_12
XFILLER_56_74 VGND VGND VPWR VPWR sky130_fd_sc_hd__fill_1
XFILLER_63_206 VGND VGND VPWR VPWR sky130_fd_sc_hd__fill_2
XFILLER_31_169 VPWR VGND VPWR VGND sky130_ef_sc_hd__decap_12
XFILLER_68_6 VGND VGND VPWR VPWR sky130_fd_sc_hd__decap_8
XFILLER_79_350 VGND VGND VPWR VPWR sky130_fd_sc_hd__decap_8
X_3221_ mantisaAshift\[46\] mantisaBshift\[46\] VGND VGND VPWR VPWR _1106_ sky130_fd_sc_hd__nand2_1
X_3152_ _1678_ mantisaBshift\[39\] mantisaBshift\[36\] mantisaBshift\[37\] mantisaBshift\[38\]
+ VGND VGND VPWR VPWR _1044_ sky130_fd_sc_hd__a2111o_1
X_2103_ net8 net16 VGND VGND VPWR VPWR _1764_ sky130_fd_sc_hd__nand2b_1
X_3083_ net241 _0989_ mantisaBshift\[26\] VGND VGND VPWR VPWR _0990_ sky130_fd_sc_hd__a21oi_1
X_2034_ _1721_ _1725_ VGND VGND VPWR VPWR _1726_ sky130_fd_sc_hd__xnor2_1
X_3985_ clknet_leaf_27_clk net308 VGND VGND VPWR VPWR expmiddleb\[4\] sky130_fd_sc_hd__dfxtp_1
X_2936_ mantisaBshift\[2\] _0869_ VGND VGND VPWR VPWR _0870_ sky130_fd_sc_hd__xnor2_1
XFILLER_10_309 VGND VGND VPWR VPWR sky130_fd_sc_hd__decap_6
X_2867_ _0729_ _0733_ net117 VGND VGND VPWR VPWR _0807_ sky130_fd_sc_hd__mux2_1
X_2798_ net146 _0735_ _0739_ VGND VGND VPWR VPWR _0740_ sky130_fd_sc_hd__a21oi_1
XFILLER_77_18 VGND VGND VPWR VPWR sky130_fd_sc_hd__fill_1
X_3419_ mantisaAshift\[61\] mantisaBshift\[61\] mantisaAshift\[62\] mantisaBshift\[62\]
+ VGND VGND VPWR VPWR _1286_ sky130_fd_sc_hd__a22o_1
XFILLER_26_442 VGND VGND VPWR VPWR sky130_fd_sc_hd__decap_3
XFILLER_26_464 VGND VGND VPWR VPWR sky130_fd_sc_hd__decap_8
XTAP_TAPCELL_ROW_71_738 VGND VPWR sky130_fd_sc_hd__tapvpwrvgnd_1
XFILLER_41_445 VGND VGND VPWR VPWR sky130_fd_sc_hd__decap_3
XFILLER_13_169 VGND VGND VPWR VPWR sky130_fd_sc_hd__decap_4
XFILLER_5_335 VGND VGND VPWR VPWR sky130_fd_sc_hd__fill_1
XTAP_TAPCELL_ROW_79_805 VGND VPWR sky130_fd_sc_hd__tapvpwrvgnd_1
XFILLER_3_15 VPWR VGND VPWR VGND sky130_ef_sc_hd__decap_12
XFILLER_68_309 VPWR VGND VPWR VGND sky130_ef_sc_hd__decap_12
XFILLER_44_272 VGND VGND VPWR VPWR sky130_fd_sc_hd__fill_1
X_3770_ net253 _1586_ VGND VGND VPWR VPWR _1587_ sky130_fd_sc_hd__nor2_1
X_2721_ _0663_ _0656_ net144 VGND VGND VPWR VPWR _0664_ sky130_fd_sc_hd__mux2_1
X_2652_ _0592_ _0594_ _0590_ VGND VGND VPWR VPWR _0595_ sky130_fd_sc_hd__a21oi_1
XFILLER_8_195 VGND VGND VPWR VPWR sky130_fd_sc_hd__fill_1
X_2583_ _0428_ _0453_ _0509_ VGND VGND VPWR VPWR _0526_ sky130_fd_sc_hd__or3_1
Xfanout108 _0615_ VGND VGND VPWR VPWR net108 sky130_fd_sc_hd__buf_2
Xfanout119 net120 VGND VGND VPWR VPWR net119 sky130_fd_sc_hd__clkbuf_4
X_3204_ mantisaBshift\[43\] mantisaAshift\[43\] VGND VGND VPWR VPWR _1091_ sky130_fd_sc_hd__and2b_1
XFILLER_79_191 VGND VGND VPWR VPWR sky130_fd_sc_hd__decap_4
XFILLER_27_206 VGND VGND VPWR VPWR sky130_fd_sc_hd__fill_1
X_3135_ net249 _1030_ _1677_ VGND VGND VPWR VPWR _1031_ sky130_fd_sc_hd__a21oi_1
X_3066_ _0975_ _0837_ net144 VGND VGND VPWR VPWR _0976_ sky130_fd_sc_hd__mux2_1
X_2017_ net44 net43 net46 net45 VGND VGND VPWR VPWR _1712_ sky130_fd_sc_hd__or4_1
X_3968_ clknet_leaf_0_clk _0091_ VGND VGND VPWR VPWR mantisaB0\[19\] sky130_fd_sc_hd__dfxtp_1
XFILLER_50_253 VPWR VGND VPWR VGND sky130_ef_sc_hd__decap_12
XFILLER_10_139 VGND VGND VPWR VPWR sky130_fd_sc_hd__fill_1
X_2919_ _0811_ _0856_ net118 VGND VGND VPWR VPWR _0857_ sky130_fd_sc_hd__mux2_1
X_3899_ clknet_leaf_15_clk _0022_ VGND VGND VPWR VPWR net77 sky130_fd_sc_hd__dfxtp_1
XFILLER_12_57 VGND VGND VPWR VPWR sky130_fd_sc_hd__fill_2
XFILLER_14_445 VPWR VGND VPWR VGND sky130_ef_sc_hd__decap_12
XFILLER_41_264 VPWR VGND VPWR VGND sky130_ef_sc_hd__decap_12
XFILLER_53_64 VGND VGND VPWR VPWR sky130_fd_sc_hd__decap_8
XFILLER_1_382 VGND VGND VPWR VPWR sky130_fd_sc_hd__decap_8
XFILLER_1_393 VPWR VGND VPWR VGND sky130_ef_sc_hd__decap_12
XFILLER_49_364 VGND VGND VPWR VPWR sky130_fd_sc_hd__decap_8
XFILLER_49_375 VPWR VGND VPWR VGND sky130_ef_sc_hd__decap_12
XFILLER_17_250 VGND VGND VPWR VPWR sky130_fd_sc_hd__decap_6
XFILLER_32_253 VPWR VGND VPWR VGND sky130_ef_sc_hd__decap_12
X_3822_ net259 _1530_ VGND VGND VPWR VPWR _1610_ sky130_fd_sc_hd__or2_1
XTAP_TAPCELL_ROW_30_410 VGND VPWR sky130_fd_sc_hd__tapvpwrvgnd_1
XFILLER_20_459 VPWR VGND VPWR VGND sky130_ef_sc_hd__decap_12
X_3753_ net187 _1572_ _1573_ net184 VGND VGND VPWR VPWR _0220_ sky130_fd_sc_hd__a2bb2o_1
X_2704_ _0643_ _0646_ net117 VGND VGND VPWR VPWR _0647_ sky130_fd_sc_hd__mux2_1
X_3684_ _1509_ _1510_ net268 VGND VGND VPWR VPWR _1511_ sky130_fd_sc_hd__mux2_1
X_2635_ _0554_ _0577_ VGND VGND VPWR VPWR _0578_ sky130_fd_sc_hd__and2b_1
X_2566_ mantisaresult\[13\] _0434_ mantisaresult\[12\] mantisaresult\[11\] VGND VGND
+ VPWR VPWR _0509_ sky130_fd_sc_hd__or4b_1
X_2497_ mantisaresult\[7\] mantisaresult\[6\] mantisaresult\[5\] VGND VGND VPWR VPWR
+ _0440_ sky130_fd_sc_hd__or3b_1
X_3118_ net124 _1016_ _0633_ VGND VGND VPWR VPWR _1017_ sky130_fd_sc_hd__a21oi_1
XFILLER_55_334 VGND VGND VPWR VPWR sky130_fd_sc_hd__fill_2
XFILLER_67_183 VGND VGND VPWR VPWR sky130_fd_sc_hd__fill_2
X_4098_ clknet_leaf_15_clk _0205_ VGND VGND VPWR VPWR four_man\[57\] sky130_fd_sc_hd__dfxtp_1
X_3049_ net240 mantisaBshift\[20\] _0961_ net233 VGND VGND VPWR VPWR _0963_ sky130_fd_sc_hd__a31o_1
XFILLER_55_378 VPWR VGND VPWR VGND sky130_ef_sc_hd__decap_12
XFILLER_11_415 VPWR VGND VPWR VGND sky130_ef_sc_hd__decap_12
XFILLER_46_301 VGND VGND VPWR VPWR sky130_fd_sc_hd__decap_6
XFILLER_0_27 VGND VGND VPWR VPWR sky130_fd_sc_hd__fill_1
XFILLER_58_194 VGND VGND VPWR VPWR sky130_fd_sc_hd__fill_2
XFILLER_73_131 VGND VGND VPWR VPWR sky130_fd_sc_hd__fill_2
XTAP_TAPCELL_ROW_44_524 VGND VPWR sky130_fd_sc_hd__tapvpwrvgnd_1
XFILLER_61_337 VGND VGND VPWR VPWR sky130_fd_sc_hd__fill_1
XFILLER_64_85 VGND VGND VPWR VPWR sky130_fd_sc_hd__decap_3
XFILLER_14_242 VGND VGND VPWR VPWR sky130_fd_sc_hd__decap_8
XTAP_TAPCELL_ROW_52_590 VGND VPWR sky130_fd_sc_hd__tapvpwrvgnd_1
X_2420_ _0355_ _0362_ VGND VGND VPWR VPWR _0363_ sky130_fd_sc_hd__or2_1
X_2351_ mantisaresult\[29\] mantisaresult\[28\] mantisaresult\[27\] mantisaresult\[26\]
+ VGND VGND VPWR VPWR _0294_ sky130_fd_sc_hd__or4_2
X_2282_ net26 _1909_ net101 VGND VGND VPWR VPWR _1910_ sky130_fd_sc_hd__mux2_1
X_4021_ clknet_leaf_23_clk _0132_ VGND VGND VPWR VPWR mantisaresult\[24\] sky130_fd_sc_hd__dfxtp_1
XFILLER_64_120 VGND VGND VPWR VPWR sky130_fd_sc_hd__fill_1
XFILLER_64_175 VGND VGND VPWR VPWR sky130_fd_sc_hd__decap_6
XFILLER_64_197 VPWR VGND VPWR VGND sky130_ef_sc_hd__decap_12
XTAP_TAPCELL_ROW_15_292 VGND VPWR sky130_fd_sc_hd__tapvpwrvgnd_1
X_3805_ net190 _1542_ VGND VGND VPWR VPWR _0239_ sky130_fd_sc_hd__nor2_1
X_1997_ net21 net20 net23 net22 VGND VGND VPWR VPWR _1692_ sky130_fd_sc_hd__or4_1
X_3736_ _1556_ _1558_ net252 VGND VGND VPWR VPWR _1559_ sky130_fd_sc_hd__mux2_1
X_3667_ net256 _1496_ VGND VGND VPWR VPWR _1497_ sky130_fd_sc_hd__nand2_1
X_3598_ _1426_ _1428_ net270 VGND VGND VPWR VPWR _1429_ sky130_fd_sc_hd__mux2_1
X_2618_ _0391_ _0522_ _0557_ _0560_ VGND VGND VPWR VPWR _0561_ sky130_fd_sc_hd__and4_1
XTAP_TAPCELL_ROW_7_227 VGND VPWR sky130_fd_sc_hd__tapvpwrvgnd_1
X_2549_ _0370_ _0414_ net167 _0486_ VGND VGND VPWR VPWR _0492_ sky130_fd_sc_hd__or4_1
XFILLER_75_429 VPWR VGND VPWR VGND sky130_ef_sc_hd__decap_12
XFILLER_28_312 VGND VGND VPWR VPWR sky130_fd_sc_hd__fill_1
XTAP_TAPCELL_ROW_58_638 VGND VPWR sky130_fd_sc_hd__tapvpwrvgnd_1
XFILLER_55_153 VGND VGND VPWR VPWR sky130_fd_sc_hd__fill_2
XFILLER_34_77 VGND VGND VPWR VPWR sky130_fd_sc_hd__decap_4
XFILLER_59_30 VGND VGND VPWR VPWR sky130_fd_sc_hd__decap_8
XFILLER_78_234 VPWR VGND VPWR VGND sky130_ef_sc_hd__decap_12
XFILLER_78_289 VPWR VGND VPWR VGND sky130_ef_sc_hd__decap_12
XFILLER_75_73 VGND VGND VPWR VPWR sky130_fd_sc_hd__decap_4
XFILLER_46_197 VPWR VGND VPWR VGND sky130_ef_sc_hd__decap_12
X_3521_ _1335_ _1357_ net118 VGND VGND VPWR VPWR _1358_ sky130_fd_sc_hd__mux2_1
X_3452_ _0757_ _0851_ _0860_ net106 VGND VGND VPWR VPWR _1309_ sky130_fd_sc_hd__a2bb2o_1
X_2403_ _0306_ _0345_ VGND VGND VPWR VPWR _0346_ sky130_fd_sc_hd__nor2_1
X_3383_ mantisaresult\[59\] _1253_ net203 VGND VGND VPWR VPWR _0170_ sky130_fd_sc_hd__mux2_1
X_2334_ _1911_ net27 net100 VGND VGND VPWR VPWR _0284_ sky130_fd_sc_hd__mux2_1
XFILLER_69_278 VGND VGND VPWR VPWR sky130_fd_sc_hd__fill_2
X_2265_ _1898_ net290 net173 VGND VGND VPWR VPWR _0061_ sky130_fd_sc_hd__mux2_1
X_2196_ _1852_ _1793_ net98 VGND VGND VPWR VPWR _1853_ sky130_fd_sc_hd__mux2_1
X_4004_ clknet_leaf_24_clk _0115_ VGND VGND VPWR VPWR mantisaresult\[9\] sky130_fd_sc_hd__dfxtp_2
XFILLER_37_142 VGND VGND VPWR VPWR sky130_fd_sc_hd__fill_1
XFILLER_1_81 VPWR VGND VPWR VGND sky130_ef_sc_hd__decap_12
XTAP_TAPCELL_ROW_55_608 VGND VPWR sky130_fd_sc_hd__tapvpwrvgnd_1
XFILLER_37_197 VGND VGND VPWR VPWR sky130_fd_sc_hd__fill_2
XTAP_TAPCELL_ROW_63_674 VGND VPWR sky130_fd_sc_hd__tapvpwrvgnd_1
X_3719_ net260 _1543_ VGND VGND VPWR VPWR _1544_ sky130_fd_sc_hd__and2_1
XFILLER_0_447 VGND VGND VPWR VPWR sky130_fd_sc_hd__fill_1
Xhold11 mantisaA0\[7\] VGND VGND VPWR VPWR net285 sky130_fd_sc_hd__dlygate4sd3_1
Xhold22 mantisaA0\[17\] VGND VGND VPWR VPWR net296 sky130_fd_sc_hd__dlygate4sd3_1
Xhold44 inf2 VGND VGND VPWR VPWR net318 sky130_fd_sc_hd__dlygate4sd3_1
Xhold33 expmiddlea\[3\] VGND VGND VPWR VPWR net307 sky130_fd_sc_hd__dlygate4sd3_1
XFILLER_48_429 VGND VGND VPWR VPWR sky130_fd_sc_hd__fill_1
Xhold55 four_man\[44\] VGND VGND VPWR VPWR net329 sky130_fd_sc_hd__dlygate4sd3_1
XFILLER_75_248 VPWR VGND VPWR VGND sky130_ef_sc_hd__decap_12
Xhold77 expadd\[1\] VGND VGND VPWR VPWR net351 sky130_fd_sc_hd__dlygate4sd3_1
Xhold88 expmiddled\[4\] VGND VGND VPWR VPWR net362 sky130_fd_sc_hd__dlygate4sd3_1
Xhold99 mantisaB0\[22\] VGND VGND VPWR VPWR net373 sky130_fd_sc_hd__dlygate4sd3_1
Xhold66 four_man\[39\] VGND VGND VPWR VPWR net340 sky130_fd_sc_hd__dlygate4sd3_1
XFILLER_28_186 VGND VGND VPWR VPWR sky130_fd_sc_hd__fill_1
XFILLER_28_197 VGND VGND VPWR VPWR sky130_fd_sc_hd__decap_4
XFILLER_31_307 VGND VGND VPWR VPWR sky130_fd_sc_hd__fill_2
XTAP_TAPCELL_ROW_26_376 VGND VPWR sky130_fd_sc_hd__tapvpwrvgnd_1
XFILLER_6_26 VGND VGND VPWR VPWR sky130_fd_sc_hd__fill_2
XFILLER_66_204 VPWR VGND VPWR VGND sky130_ef_sc_hd__decap_12
X_2050_ _1737_ _1738_ VGND VGND VPWR VPWR _1739_ sky130_fd_sc_hd__nand2_1
XFILLER_66_237 VGND VGND VPWR VPWR sky130_fd_sc_hd__decap_3
XTAP_TAPCELL_ROW_77_788 VGND VPWR sky130_fd_sc_hd__tapvpwrvgnd_1
XFILLER_19_197 VGND VGND VPWR VPWR sky130_fd_sc_hd__decap_8
XTAP_TAPCELL_ROW_17_310 VGND VPWR sky130_fd_sc_hd__tapvpwrvgnd_1
XFILLER_22_307 VGND VGND VPWR VPWR sky130_fd_sc_hd__fill_1
X_2952_ _0878_ _0883_ net123 VGND VGND VPWR VPWR _0884_ sky130_fd_sc_hd__mux2_1
XTAP_TAPCELL_ROW_60_655 VGND VPWR sky130_fd_sc_hd__tapvpwrvgnd_1
X_2883_ _0822_ _0821_ net143 VGND VGND VPWR VPWR _0823_ sky130_fd_sc_hd__mux2_1
X_3504_ net127 _1342_ _1340_ net158 VGND VGND VPWR VPWR _1343_ sky130_fd_sc_hd__o211a_1
X_3435_ net159 _1297_ _1300_ VGND VGND VPWR VPWR _1301_ sky130_fd_sc_hd__and3_1
X_3366_ mantisaAshift\[58\] mantisaBshift\[58\] VGND VGND VPWR VPWR _1238_ sky130_fd_sc_hd__or2_1
X_2317_ _0275_ mantisaB0\[10\] net174 VGND VGND VPWR VPWR _0082_ sky130_fd_sc_hd__mux2_1
X_3297_ net219 _1175_ net203 VGND VGND VPWR VPWR _0162_ sky130_fd_sc_hd__mux2_1
XFILLER_38_440 VGND VGND VPWR VPWR sky130_fd_sc_hd__fill_2
X_2248_ net60 net169 VGND VGND VPWR VPWR _1887_ sky130_fd_sc_hd__and2_1
X_2179_ net272 _1839_ net177 VGND VGND VPWR VPWR _0034_ sky130_fd_sc_hd__mux2_1
XFILLER_53_432 VGND VGND VPWR VPWR sky130_fd_sc_hd__fill_2
XFILLER_65_281 VGND VGND VPWR VPWR sky130_fd_sc_hd__fill_2
XFILLER_15_68 VGND VGND VPWR VPWR sky130_fd_sc_hd__fill_1
XTAP_TAPCELL_ROW_23_357 VGND VPWR sky130_fd_sc_hd__tapvpwrvgnd_1
Xoutput67 net67 VGND VGND VPWR VPWR exp[1] sky130_fd_sc_hd__buf_2
Xoutput89 net89 VGND VGND VPWR VPWR mantisa[2] sky130_fd_sc_hd__buf_2
Xoutput78 net78 VGND VGND VPWR VPWR mantisa[13] sky130_fd_sc_hd__buf_2
XFILLER_0_277 VGND VGND VPWR VPWR sky130_fd_sc_hd__decap_3
XFILLER_48_248 VGND VGND VPWR VPWR sky130_fd_sc_hd__decap_4
XFILLER_44_421 VPWR VGND VPWR VGND sky130_ef_sc_hd__decap_12
XFILLER_56_270 VGND VGND VPWR VPWR sky130_fd_sc_hd__decap_4
XFILLER_63_229 VGND VGND VPWR VPWR sky130_fd_sc_hd__fill_1
XFILLER_72_63 VGND VGND VPWR VPWR sky130_fd_sc_hd__decap_4
XFILLER_72_85 VGND VGND VPWR VPWR sky130_fd_sc_hd__decap_6
XFILLER_12_362 VGND VGND VPWR VPWR sky130_fd_sc_hd__fill_2
X_3220_ mantisaAshift\[46\] mantisaBshift\[46\] VGND VGND VPWR VPWR _1105_ sky130_fd_sc_hd__or2_1
X_3151_ _1678_ _1679_ VGND VGND VPWR VPWR _1043_ sky130_fd_sc_hd__nor2_1
X_2102_ net16 net8 VGND VGND VPWR VPWR _1763_ sky130_fd_sc_hd__and2b_1
XFILLER_39_248 VGND VGND VPWR VPWR sky130_fd_sc_hd__decap_6
X_3082_ mantisaBshift\[23\] mantisaBshift\[24\] mantisaBshift\[25\] _0969_ VGND VGND
+ VPWR VPWR _0989_ sky130_fd_sc_hd__or4_2
X_2033_ _1723_ _1724_ VGND VGND VPWR VPWR _1725_ sky130_fd_sc_hd__nor2_1
XFILLER_47_281 VPWR VGND VPWR VGND sky130_ef_sc_hd__decap_12
XFILLER_54_229 VPWR VGND VPWR VGND sky130_ef_sc_hd__decap_12
XFILLER_62_240 VGND VGND VPWR VPWR sky130_fd_sc_hd__fill_1
XFILLER_62_251 VGND VGND VPWR VPWR sky130_fd_sc_hd__fill_1
XFILLER_50_402 VGND VGND VPWR VPWR sky130_fd_sc_hd__decap_3
X_3984_ clknet_leaf_25_clk net307 VGND VGND VPWR VPWR expmiddleb\[3\] sky130_fd_sc_hd__dfxtp_1
X_2935_ mantisaBshift\[0\] mantisaBshift\[1\] net239 VGND VGND VPWR VPWR _0869_ sky130_fd_sc_hd__o21ai_1
X_2866_ _0805_ VGND VGND VPWR VPWR _0806_ sky130_fd_sc_hd__inv_2
X_2797_ net146 _0738_ VGND VGND VPWR VPWR _0739_ sky130_fd_sc_hd__and2b_1
X_3418_ _1684_ mantisaBshift\[62\] _1284_ net244 VGND VGND VPWR VPWR _1285_ sky130_fd_sc_hd__o211a_1
X_3349_ _1198_ _1203_ _1212_ VGND VGND VPWR VPWR _1223_ sky130_fd_sc_hd__a21o_1
XFILLER_45_207 VPWR VGND VPWR VGND sky130_ef_sc_hd__decap_12
XTAP_TAPCELL_ROW_36_460 VGND VPWR sky130_fd_sc_hd__tapvpwrvgnd_1
XFILLER_41_402 VPWR VGND VPWR VGND sky130_ef_sc_hd__decap_12
XTAP_TAPCELL_ROW_71_739 VGND VPWR sky130_fd_sc_hd__tapvpwrvgnd_1
XTAP_TAPCELL_ROW_79_806 VGND VPWR sky130_fd_sc_hd__tapvpwrvgnd_1
XFILLER_3_27 VPWR VGND VPWR VGND sky130_ef_sc_hd__decap_12
XFILLER_76_321 VPWR VGND VPWR VGND sky130_ef_sc_hd__decap_12
XFILLER_76_365 VPWR VGND VPWR VGND sky130_ef_sc_hd__decap_12
XFILLER_44_251 VGND VGND VPWR VPWR sky130_fd_sc_hd__fill_1
X_2720_ _0659_ _0662_ net120 VGND VGND VPWR VPWR _0663_ sky130_fd_sc_hd__mux2_1
X_2651_ expmiddlec\[0\] _0569_ expmiddlec\[1\] VGND VGND VPWR VPWR _0594_ sky130_fd_sc_hd__a21o_1
XFILLER_8_141 VGND VGND VPWR VPWR sky130_fd_sc_hd__fill_1
X_2582_ mantisaresult\[17\] _0432_ _0447_ _0449_ VGND VGND VPWR VPWR _0525_ sky130_fd_sc_hd__or4_1
XFILLER_4_380 VPWR VGND VPWR VGND sky130_ef_sc_hd__decap_12
Xfanout109 net110 VGND VGND VPWR VPWR net109 sky130_fd_sc_hd__buf_2
X_3203_ _1065_ _1068_ _1066_ VGND VGND VPWR VPWR _1090_ sky130_fd_sc_hd__o21ai_1
X_3134_ _1005_ _1029_ VGND VGND VPWR VPWR _1030_ sky130_fd_sc_hd__or2_1
X_3065_ _0880_ _0974_ net119 VGND VGND VPWR VPWR _0975_ sky130_fd_sc_hd__mux2_1
X_2016_ net62 net61 net42 net41 VGND VGND VPWR VPWR _1711_ sky130_fd_sc_hd__or4_1
XFILLER_23_435 VGND VGND VPWR VPWR sky130_fd_sc_hd__fill_1
XFILLER_50_221 VPWR VGND VPWR VGND sky130_ef_sc_hd__decap_12
X_3967_ clknet_leaf_5_clk _0090_ VGND VGND VPWR VPWR mantisaB0\[18\] sky130_fd_sc_hd__dfxtp_1
XFILLER_50_265 VPWR VGND VPWR VGND sky130_ef_sc_hd__decap_12
XFILLER_50_298 VGND VGND VPWR VPWR sky130_fd_sc_hd__fill_2
X_2918_ net223 net110 _0855_ VGND VGND VPWR VPWR _0856_ sky130_fd_sc_hd__a21o_1
X_3898_ clknet_leaf_16_clk _0021_ VGND VGND VPWR VPWR net76 sky130_fd_sc_hd__dfxtp_1
X_2849_ _0789_ _0788_ net139 VGND VGND VPWR VPWR _0790_ sky130_fd_sc_hd__mux2_1
XFILLER_58_321 VGND VGND VPWR VPWR sky130_fd_sc_hd__fill_1
XFILLER_26_240 VGND VGND VPWR VPWR sky130_fd_sc_hd__fill_2
XFILLER_14_457 VPWR VGND VPWR VGND sky130_ef_sc_hd__decap_12
XFILLER_41_276 VGND VGND VPWR VPWR sky130_fd_sc_hd__decap_4
Xclkbuf_leaf_21_clk clknet_2_2__leaf_clk VGND VGND VPWR VPWR clknet_leaf_21_clk sky130_fd_sc_hd__clkbuf_8
XFILLER_5_111 VGND VGND VPWR VPWR sky130_fd_sc_hd__fill_1
XFILLER_49_387 VGND VGND VPWR VPWR sky130_fd_sc_hd__decap_4
XTAP_TAPCELL_ROW_47_544 VGND VPWR sky130_fd_sc_hd__tapvpwrvgnd_1
XFILLER_32_265 VPWR VGND VPWR VGND sky130_ef_sc_hd__decap_12
X_3821_ net259 _1527_ _1608_ net190 VGND VGND VPWR VPWR _1609_ sky130_fd_sc_hd__a211o_1
XTAP_TAPCELL_ROW_30_411 VGND VPWR sky130_fd_sc_hd__tapvpwrvgnd_1
XFILLER_9_461 VPWR VGND VPWR VGND sky130_ef_sc_hd__decap_12
X_3752_ net265 _1424_ VGND VGND VPWR VPWR _1573_ sky130_fd_sc_hd__and2_1
Xclkbuf_leaf_12_clk clknet_2_1__leaf_clk VGND VGND VPWR VPWR clknet_leaf_12_clk sky130_fd_sc_hd__clkbuf_8
X_3683_ _1455_ _1458_ net272 VGND VGND VPWR VPWR _1510_ sky130_fd_sc_hd__mux2_1
X_2703_ mantisaresult\[30\] net112 _0644_ _0611_ VGND VGND VPWR VPWR _0646_ sky130_fd_sc_hd__o2bb2a_1
X_2634_ _0543_ _0576_ VGND VGND VPWR VPWR _0577_ sky130_fd_sc_hd__nor2_1
X_2565_ _0371_ _0372_ _0447_ _0507_ VGND VGND VPWR VPWR _0508_ sky130_fd_sc_hd__or4_1
X_2496_ mantisaresult\[16\] _0435_ VGND VGND VPWR VPWR _0439_ sky130_fd_sc_hd__or2_1
X_3117_ _1015_ _0857_ net146 VGND VGND VPWR VPWR _1016_ sky130_fd_sc_hd__mux2_1
X_4097_ clknet_leaf_16_clk _0204_ VGND VGND VPWR VPWR four_man\[56\] sky130_fd_sc_hd__dfxtp_1
X_3048_ net240 _0961_ mantisaBshift\[20\] VGND VGND VPWR VPWR _0962_ sky130_fd_sc_hd__a21oi_1
XFILLER_23_243 VGND VGND VPWR VPWR sky130_fd_sc_hd__fill_1
XFILLER_11_427 VPWR VGND VPWR VGND sky130_ef_sc_hd__decap_12
XFILLER_11_449 VPWR VGND VPWR VGND sky130_ef_sc_hd__decap_12
XFILLER_23_57 VPWR VGND VPWR VGND sky130_ef_sc_hd__decap_12
XFILLER_58_151 VGND VGND VPWR VPWR sky130_fd_sc_hd__fill_2
XFILLER_58_162 VPWR VGND VPWR VGND sky130_ef_sc_hd__decap_12
XFILLER_73_143 VGND VGND VPWR VPWR sky130_fd_sc_hd__decap_6
XTAP_TAPCELL_ROW_1_180 VGND VPWR sky130_fd_sc_hd__tapvpwrvgnd_1
XTAP_TAPCELL_ROW_44_525 VGND VPWR sky130_fd_sc_hd__tapvpwrvgnd_1
XTAP_TAPCELL_ROW_52_591 VGND VPWR sky130_fd_sc_hd__tapvpwrvgnd_1
XFILLER_43_6 VGND VGND VPWR VPWR sky130_fd_sc_hd__decap_6
X_2350_ mantisaresult\[31\] mantisaresult\[30\] VGND VGND VPWR VPWR _0293_ sky130_fd_sc_hd__or2_2
X_2281_ net49 net170 VGND VGND VPWR VPWR _1909_ sky130_fd_sc_hd__and2_1
XFILLER_69_449 VPWR VGND VPWR VGND sky130_ef_sc_hd__decap_12
Xclkbuf_leaf_1_clk clknet_2_0__leaf_clk VGND VGND VPWR VPWR clknet_leaf_1_clk sky130_fd_sc_hd__clkbuf_8
X_4020_ clknet_leaf_16_clk _0131_ VGND VGND VPWR VPWR four_man\[47\] sky130_fd_sc_hd__dfxtp_1
XFILLER_49_151 VGND VGND VPWR VPWR sky130_fd_sc_hd__fill_1
XFILLER_45_390 VGND VGND VPWR VPWR sky130_fd_sc_hd__fill_2
XFILLER_52_349 VGND VGND VPWR VPWR sky130_fd_sc_hd__decap_6
XTAP_TAPCELL_ROW_15_293 VGND VPWR sky130_fd_sc_hd__tapvpwrvgnd_1
X_3804_ net190 _1531_ VGND VGND VPWR VPWR _0238_ sky130_fd_sc_hd__nor2_1
X_1996_ net39 net38 net19 net18 VGND VGND VPWR VPWR _1691_ sky130_fd_sc_hd__or4_1
XFILLER_20_279 VPWR VGND VPWR VGND sky130_ef_sc_hd__decap_12
X_3735_ net260 _1557_ VGND VGND VPWR VPWR _1558_ sky130_fd_sc_hd__or2_1
X_3666_ _1485_ _1495_ net263 VGND VGND VPWR VPWR _1496_ sky130_fd_sc_hd__mux2_1
X_3597_ mantisaB0\[4\] net193 _1427_ net273 VGND VGND VPWR VPWR _1428_ sky130_fd_sc_hd__a22o_1
X_2617_ mantisaresult\[59\] _0298_ _0559_ _0558_ mantisaresult\[63\] VGND VGND VPWR
+ VPWR _0560_ sky130_fd_sc_hd__o32a_1
XTAP_TAPCELL_ROW_7_228 VGND VPWR sky130_fd_sc_hd__tapvpwrvgnd_1
X_2548_ net226 _0311_ _0490_ VGND VGND VPWR VPWR _0491_ sky130_fd_sc_hd__and3_1
X_2479_ _0371_ _0372_ _0421_ VGND VGND VPWR VPWR _0422_ sky130_fd_sc_hd__or3_1
XFILLER_18_24 VGND VGND VPWR VPWR sky130_fd_sc_hd__decap_4
XFILLER_18_13 VGND VGND VPWR VPWR sky130_fd_sc_hd__fill_2
XTAP_TAPCELL_ROW_58_639 VGND VPWR sky130_fd_sc_hd__tapvpwrvgnd_1
X_4149_ clknet_leaf_2_clk _0256_ VGND VGND VPWR VPWR mantisaBshift\[27\] sky130_fd_sc_hd__dfxtp_1
XFILLER_11_279 VGND VGND VPWR VPWR sky130_fd_sc_hd__fill_1
Xclkload0 clknet_2_0__leaf_clk VGND VGND VPWR VPWR clkload0/Y sky130_fd_sc_hd__clkinvlp_4
XFILLER_59_20 VGND VGND VPWR VPWR sky130_fd_sc_hd__decap_4
XFILLER_78_246 VGND VGND VPWR VPWR sky130_fd_sc_hd__decap_6
XFILLER_66_419 VGND VGND VPWR VPWR sky130_fd_sc_hd__fill_1
XFILLER_19_302 VGND VGND VPWR VPWR sky130_fd_sc_hd__fill_1
Xfanout270 net272 VGND VGND VPWR VPWR net270 sky130_fd_sc_hd__clkbuf_4
XFILLER_75_63 VGND VGND VPWR VPWR sky130_fd_sc_hd__fill_1
XFILLER_61_113 VGND VGND VPWR VPWR sky130_fd_sc_hd__fill_2
X_3520_ mantisaresult\[55\] net113 net110 mantisaresult\[56\] VGND VGND VPWR VPWR
+ _1357_ sky130_fd_sc_hd__a22o_1
XFILLER_6_261 VGND VGND VPWR VPWR sky130_fd_sc_hd__fill_2
X_3451_ _0858_ _0921_ _0925_ _1307_ VGND VGND VPWR VPWR _1308_ sky130_fd_sc_hd__a22o_1
X_2402_ net221 _0333_ _0341_ VGND VGND VPWR VPWR _0345_ sky130_fd_sc_hd__or3_2
X_3382_ _1248_ _1252_ VGND VGND VPWR VPWR _1253_ sky130_fd_sc_hd__xnor2_1
X_2333_ _0283_ net367 net171 VGND VGND VPWR VPWR _0090_ sky130_fd_sc_hd__mux2_1
X_2264_ net20 _1897_ net105 VGND VGND VPWR VPWR _1898_ sky130_fd_sc_hd__mux2_1
X_4003_ clknet_leaf_24_clk _0114_ VGND VGND VPWR VPWR mantisaresult\[8\] sky130_fd_sc_hd__dfxtp_1
X_2195_ _1774_ _1791_ _1773_ VGND VGND VPWR VPWR _1852_ sky130_fd_sc_hd__o21bai_1
XFILLER_37_110 VGND VGND VPWR VPWR sky130_fd_sc_hd__fill_2
XFILLER_37_132 VGND VGND VPWR VPWR sky130_fd_sc_hd__fill_1
XFILLER_37_154 VGND VGND VPWR VPWR sky130_fd_sc_hd__decap_3
XFILLER_37_165 VGND VGND VPWR VPWR sky130_fd_sc_hd__decap_3
XTAP_TAPCELL_ROW_55_609 VGND VPWR sky130_fd_sc_hd__tapvpwrvgnd_1
XFILLER_1_93 VPWR VGND VPWR VGND sky130_ef_sc_hd__decap_12
XFILLER_52_135 VGND VGND VPWR VPWR sky130_fd_sc_hd__decap_4
XFILLER_33_360 VGND VGND VPWR VPWR sky130_fd_sc_hd__decap_3
XFILLER_40_319 VPWR VGND VPWR VGND sky130_ef_sc_hd__decap_12
XTAP_TAPCELL_ROW_63_675 VGND VPWR sky130_fd_sc_hd__tapvpwrvgnd_1
X_1979_ mantisaBshift\[4\] VGND VGND VPWR VPWR _1674_ sky130_fd_sc_hd__inv_2
XFILLER_20_25 VGND VGND VPWR VPWR sky130_fd_sc_hd__decap_3
XFILLER_4_209 VPWR VGND VPWR VGND sky130_ef_sc_hd__decap_12
X_3718_ _1423_ _1429_ net269 VGND VGND VPWR VPWR _1543_ sky130_fd_sc_hd__mux2_1
X_3649_ _1478_ VGND VGND VPWR VPWR _1479_ sky130_fd_sc_hd__inv_2
Xhold12 mantisaA0\[3\] VGND VGND VPWR VPWR net286 sky130_fd_sc_hd__dlygate4sd3_1
Xhold23 mantisaA0\[16\] VGND VGND VPWR VPWR net297 sky130_fd_sc_hd__dlygate4sd3_1
Xhold45 expmiddleb\[7\] VGND VGND VPWR VPWR net319 sky130_fd_sc_hd__dlygate4sd3_1
Xhold34 expmiddlea\[4\] VGND VGND VPWR VPWR net308 sky130_fd_sc_hd__dlygate4sd3_1
XFILLER_48_419 VGND VGND VPWR VPWR sky130_fd_sc_hd__fill_1
Xhold56 four_man\[58\] VGND VGND VPWR VPWR net330 sky130_fd_sc_hd__dlygate4sd3_1
XFILLER_75_238 VGND VGND VPWR VPWR sky130_fd_sc_hd__fill_1
Xhold67 expadd\[3\] VGND VGND VPWR VPWR net341 sky130_fd_sc_hd__dlygate4sd3_1
Xhold78 expadd\[5\] VGND VGND VPWR VPWR net352 sky130_fd_sc_hd__dlygate4sd3_1
XFILLER_28_110 VPWR VGND VPWR VGND sky130_ef_sc_hd__decap_12
XFILLER_29_89 VGND VGND VPWR VPWR sky130_fd_sc_hd__fill_2
Xhold89 mantisaB0\[17\] VGND VGND VPWR VPWR net363 sky130_fd_sc_hd__dlygate4sd3_1
XFILLER_43_102 VGND VGND VPWR VPWR sky130_fd_sc_hd__fill_1
XTAP_TAPCELL_ROW_26_377 VGND VPWR sky130_fd_sc_hd__tapvpwrvgnd_1
XFILLER_66_216 VGND VGND VPWR VPWR sky130_fd_sc_hd__decap_6
XFILLER_19_110 VGND VGND VPWR VPWR sky130_fd_sc_hd__fill_2
XTAP_TAPCELL_ROW_77_789 VGND VPWR sky130_fd_sc_hd__tapvpwrvgnd_1
XTAP_TAPCELL_ROW_17_311 VGND VPWR sky130_fd_sc_hd__tapvpwrvgnd_1
X_2951_ net144 _0784_ _0882_ VGND VGND VPWR VPWR _0883_ sky130_fd_sc_hd__a21oi_1
XFILLER_15_393 VPWR VGND VPWR VGND sky130_ef_sc_hd__decap_12
XFILLER_30_330 VGND VGND VPWR VPWR sky130_fd_sc_hd__decap_3
X_2882_ _0716_ _0724_ net117 VGND VGND VPWR VPWR _0822_ sky130_fd_sc_hd__mux2_1
XFILLER_30_374 VPWR VGND VPWR VGND sky130_ef_sc_hd__decap_12
X_3503_ _0923_ _0925_ _0932_ net106 _1341_ VGND VGND VPWR VPWR _1342_ sky130_fd_sc_hd__a221o_1
X_3434_ _0844_ _0921_ _1298_ _1299_ VGND VGND VPWR VPWR _1300_ sky130_fd_sc_hd__a211o_1
X_3365_ mantisaAshift\[58\] mantisaBshift\[58\] VGND VGND VPWR VPWR _1237_ sky130_fd_sc_hd__and2_1
X_3296_ _1163_ _1174_ VGND VGND VPWR VPWR _1175_ sky130_fd_sc_hd__xnor2_1
XFILLER_57_205 VGND VGND VPWR VPWR sky130_fd_sc_hd__decap_8
XTAP_TAPCELL_ROW_68_712 VGND VPWR sky130_fd_sc_hd__tapvpwrvgnd_1
X_2316_ _1893_ net18 net103 VGND VGND VPWR VPWR _0275_ sky130_fd_sc_hd__mux2_1
X_2247_ _1886_ net299 net172 VGND VGND VPWR VPWR _0055_ sky130_fd_sc_hd__mux2_1
XFILLER_72_219 VPWR VGND VPWR VGND sky130_ef_sc_hd__decap_12
X_2178_ _1837_ _1838_ VGND VGND VPWR VPWR _1839_ sky130_fd_sc_hd__xnor2_1
XFILLER_40_138 VGND VGND VPWR VPWR sky130_fd_sc_hd__fill_2
XTAP_TAPCELL_ROW_23_358 VGND VPWR sky130_fd_sc_hd__tapvpwrvgnd_1
Xoutput68 net68 VGND VGND VPWR VPWR exp[2] sky130_fd_sc_hd__buf_2
Xoutput79 net79 VGND VGND VPWR VPWR mantisa[14] sky130_fd_sc_hd__buf_2
XFILLER_0_289 VGND VGND VPWR VPWR sky130_fd_sc_hd__fill_1
XFILLER_29_463 VGND VGND VPWR VPWR sky130_fd_sc_hd__decap_8
XFILLER_16_157 VGND VGND VPWR VPWR sky130_fd_sc_hd__decap_6
XPHY_EDGE_ROW_19_Right_19 VGND VGND VPWR VPWR sky130_fd_sc_hd__decap_3
XTAP_TAPCELL_ROW_39_480 VGND VPWR sky130_fd_sc_hd__tapvpwrvgnd_1
XFILLER_44_433 VGND VGND VPWR VPWR sky130_fd_sc_hd__decap_8
XFILLER_71_241 VGND VGND VPWR VPWR sky130_fd_sc_hd__decap_8
XFILLER_8_301 VGND VGND VPWR VPWR sky130_fd_sc_hd__decap_6
XPHY_EDGE_ROW_28_Right_28 VGND VGND VPWR VPWR sky130_fd_sc_hd__decap_3
XFILLER_79_385 VGND VGND VPWR VPWR sky130_fd_sc_hd__decap_6
X_3150_ _1040_ _1041_ VGND VGND VPWR VPWR _1042_ sky130_fd_sc_hd__and2b_1
X_2101_ net274 _1757_ net177 VGND VGND VPWR VPWR _0033_ sky130_fd_sc_hd__mux2_1
X_3081_ _0987_ _0988_ mantisaresult\[25\] net233 VGND VGND VPWR VPWR _0133_ sky130_fd_sc_hd__a2bb2o_1
X_2032_ expmiddled\[1\] expadd\[1\] VGND VGND VPWR VPWR _1724_ sky130_fd_sc_hd__nor2_1
XPHY_EDGE_ROW_37_Right_37 VGND VGND VPWR VPWR sky130_fd_sc_hd__decap_3
XFILLER_47_293 VGND VGND VPWR VPWR sky130_fd_sc_hd__decap_6
X_3983_ clknet_leaf_26_clk net302 VGND VGND VPWR VPWR expmiddleb\[2\] sky130_fd_sc_hd__dfxtp_1
XFILLER_50_447 VGND VGND VPWR VPWR sky130_fd_sc_hd__fill_1
XFILLER_62_296 VGND VGND VPWR VPWR sky130_fd_sc_hd__fill_1
X_2934_ mantisaresult\[1\] _0868_ net201 VGND VGND VPWR VPWR _0106_ sky130_fd_sc_hd__mux2_1
XTAP_TAPCELL_ROW_20_328 VGND VPWR sky130_fd_sc_hd__tapvpwrvgnd_1
X_2865_ _0726_ _0728_ net117 VGND VGND VPWR VPWR _0805_ sky130_fd_sc_hd__mux2_1
XPHY_EDGE_ROW_46_Right_46 VGND VGND VPWR VPWR sky130_fd_sc_hd__decap_3
X_2796_ _0736_ _0737_ net120 VGND VGND VPWR VPWR _0738_ sky130_fd_sc_hd__mux2_1
XFILLER_7_92 VGND VGND VPWR VPWR sky130_fd_sc_hd__decap_4
X_3417_ _1278_ _1279_ _1277_ VGND VGND VPWR VPWR _1284_ sky130_fd_sc_hd__a21o_1
X_3348_ _1200_ _1220_ _1168_ _1170_ VGND VGND VPWR VPWR _1222_ sky130_fd_sc_hd__or4bb_1
XPHY_EDGE_ROW_55_Right_55 VGND VGND VPWR VPWR sky130_fd_sc_hd__decap_3
X_3279_ _1145_ _1150_ _1157_ net245 _1158_ VGND VGND VPWR VPWR _1159_ sky130_fd_sc_hd__o221a_1
XFILLER_38_271 VGND VGND VPWR VPWR sky130_fd_sc_hd__fill_1
XFILLER_45_219 VGND VGND VPWR VPWR sky130_fd_sc_hd__decap_4
XFILLER_13_105 VGND VGND VPWR VPWR sky130_fd_sc_hd__decap_6
XFILLER_26_79 VGND VGND VPWR VPWR sky130_fd_sc_hd__decap_4
XTAP_TAPCELL_ROW_36_461 VGND VPWR sky130_fd_sc_hd__tapvpwrvgnd_1
XFILLER_41_414 VGND VGND VPWR VPWR sky130_fd_sc_hd__fill_1
XPHY_EDGE_ROW_64_Right_64 VGND VGND VPWR VPWR sky130_fd_sc_hd__decap_3
XTAP_TAPCELL_ROW_79_807 VGND VPWR sky130_fd_sc_hd__tapvpwrvgnd_1
XFILLER_3_39 VPWR VGND VPWR VGND sky130_ef_sc_hd__decap_12
XFILLER_67_31 VGND VGND VPWR VPWR sky130_fd_sc_hd__decap_8
XFILLER_76_333 VPWR VGND VPWR VGND sky130_ef_sc_hd__decap_12
XPHY_EDGE_ROW_73_Right_73 VGND VGND VPWR VPWR sky130_fd_sc_hd__decap_3
XFILLER_76_377 VPWR VGND VPWR VGND sky130_ef_sc_hd__decap_12
XFILLER_67_86 VGND VGND VPWR VPWR sky130_fd_sc_hd__fill_1
X_2650_ _0592_ VGND VGND VPWR VPWR _0593_ sky130_fd_sc_hd__inv_2
XFILLER_73_6 VGND VGND VPWR VPWR sky130_fd_sc_hd__decap_6
XFILLER_8_197 VGND VGND VPWR VPWR sky130_fd_sc_hd__decap_6
XFILLER_8_175 VPWR VGND VPWR VGND sky130_ef_sc_hd__decap_12
X_2581_ _0401_ _0491_ _0523_ _0412_ VGND VGND VPWR VPWR _0524_ sky130_fd_sc_hd__or4b_2
XFILLER_4_392 VGND VGND VPWR VPWR sky130_fd_sc_hd__decap_8
X_3202_ mantisaAshift\[44\] mantisaBshift\[44\] VGND VGND VPWR VPWR _1089_ sky130_fd_sc_hd__xnor2_1
X_3133_ mantisaBshift\[32\] mantisaBshift\[33\] mantisaBshift\[34\] mantisaBshift\[35\]
+ VGND VGND VPWR VPWR _1029_ sky130_fd_sc_hd__or4_1
X_3064_ mantisaresult\[46\] net113 _0973_ net133 VGND VGND VPWR VPWR _0974_ sky130_fd_sc_hd__o2bb2a_1
X_2015_ _1708_ _1709_ VGND VGND VPWR VPWR _1710_ sky130_fd_sc_hd__nor2_1
XPHY_EDGE_ROW_19_Left_99 VGND VGND VPWR VPWR sky130_fd_sc_hd__decap_3
XFILLER_35_241 VGND VGND VPWR VPWR sky130_fd_sc_hd__decap_6
XFILLER_50_233 VPWR VGND VPWR VGND sky130_ef_sc_hd__decap_12
X_3966_ clknet_leaf_5_clk _0089_ VGND VGND VPWR VPWR mantisaB0\[17\] sky130_fd_sc_hd__dfxtp_1
XFILLER_50_277 VGND VGND VPWR VPWR sky130_fd_sc_hd__decap_8
X_2917_ net224 net155 net133 VGND VGND VPWR VPWR _0855_ sky130_fd_sc_hd__and3_1
X_3897_ clknet_leaf_16_clk _0020_ VGND VGND VPWR VPWR net75 sky130_fd_sc_hd__dfxtp_1
X_2848_ _0624_ _0668_ net115 VGND VGND VPWR VPWR _0789_ sky130_fd_sc_hd__mux2_1
X_2779_ _0720_ VGND VGND VPWR VPWR _0721_ sky130_fd_sc_hd__inv_2
XFILLER_37_12 VGND VGND VPWR VPWR sky130_fd_sc_hd__decap_4
XFILLER_26_230 VGND VGND VPWR VPWR sky130_fd_sc_hd__decap_4
XFILLER_26_274 VGND VGND VPWR VPWR sky130_fd_sc_hd__fill_2
XFILLER_14_469 VGND VGND VPWR VPWR sky130_fd_sc_hd__decap_4
XFILLER_5_167 VGND VGND VPWR VPWR sky130_fd_sc_hd__fill_1
XFILLER_49_322 VPWR VGND VPWR VGND sky130_ef_sc_hd__decap_12
XFILLER_76_141 VGND VGND VPWR VPWR sky130_fd_sc_hd__fill_1
XTAP_TAPCELL_ROW_47_545 VGND VPWR sky130_fd_sc_hd__tapvpwrvgnd_1
X_3820_ net259 _1537_ VGND VGND VPWR VPWR _1608_ sky130_fd_sc_hd__nor2_1
XTAP_TAPCELL_ROW_30_412 VGND VPWR sky130_fd_sc_hd__tapvpwrvgnd_1
X_3751_ _1570_ _1571_ net253 VGND VGND VPWR VPWR _1572_ sky130_fd_sc_hd__mux2_1
XFILLER_32_277 VGND VGND VPWR VPWR sky130_fd_sc_hd__decap_8
XFILLER_32_299 VGND VGND VPWR VPWR sky130_fd_sc_hd__decap_8
X_2702_ _0644_ VGND VGND VPWR VPWR _0645_ sky130_fd_sc_hd__inv_2
X_3682_ _1449_ _1453_ net270 VGND VGND VPWR VPWR _1509_ sky130_fd_sc_hd__mux2_1
X_2633_ _0445_ _0470_ _0567_ _0571_ VGND VGND VPWR VPWR _0576_ sky130_fd_sc_hd__or4b_1
X_2564_ _1632_ mantisaresult\[17\] _0432_ _0449_ VGND VGND VPWR VPWR _0507_ sky130_fd_sc_hd__or4_1
X_2495_ _1627_ _0431_ _0435_ _0437_ VGND VGND VPWR VPWR _0438_ sky130_fd_sc_hd__or4_1
X_4165_ clknet_leaf_11_clk _0272_ VGND VGND VPWR VPWR mantisaBshift\[58\] sky130_fd_sc_hd__dfxtp_1
X_3116_ _0928_ _1014_ net118 VGND VGND VPWR VPWR _1015_ sky130_fd_sc_hd__mux2_1
X_4096_ clknet_leaf_15_clk _0203_ VGND VGND VPWR VPWR four_man\[55\] sky130_fd_sc_hd__dfxtp_1
X_3047_ mantisaBshift\[18\] mantisaBshift\[19\] _0950_ _0955_ VGND VGND VPWR VPWR
+ _0961_ sky130_fd_sc_hd__or4_2
XFILLER_11_439 VGND VGND VPWR VPWR sky130_fd_sc_hd__decap_8
XFILLER_23_69 VGND VGND VPWR VPWR sky130_fd_sc_hd__fill_1
X_3949_ clknet_leaf_5_clk _0072_ VGND VGND VPWR VPWR mantisaB0\[0\] sky130_fd_sc_hd__dfxtp_1
XFILLER_58_174 VPWR VGND VPWR VGND sky130_ef_sc_hd__decap_12
XFILLER_0_29 VPWR VGND VPWR VGND sky130_ef_sc_hd__decap_12
XTAP_TAPCELL_ROW_1_181 VGND VPWR sky130_fd_sc_hd__tapvpwrvgnd_1
XTAP_TAPCELL_ROW_44_526 VGND VPWR sky130_fd_sc_hd__tapvpwrvgnd_1
XFILLER_73_199 VGND VGND VPWR VPWR sky130_fd_sc_hd__fill_2
XPHY_EDGE_ROW_23_Left_103 VGND VGND VPWR VPWR sky130_fd_sc_hd__decap_3
X_2280_ _1908_ net296 net174 VGND VGND VPWR VPWR _0066_ sky130_fd_sc_hd__mux2_1
XFILLER_1_181 VPWR VGND VPWR VGND sky130_ef_sc_hd__decap_12
XFILLER_77_461 VPWR VGND VPWR VGND sky130_ef_sc_hd__decap_12
XPHY_EDGE_ROW_32_Left_112 VGND VGND VPWR VPWR sky130_fd_sc_hd__decap_3
XFILLER_52_306 VGND VGND VPWR VPWR sky130_fd_sc_hd__fill_2
X_3803_ net191 _1513_ VGND VGND VPWR VPWR _0237_ sky130_fd_sc_hd__nor2_1
XTAP_TAPCELL_ROW_15_294 VGND VPWR sky130_fd_sc_hd__tapvpwrvgnd_1
X_1995_ net28 net17 net33 net32 VGND VGND VPWR VPWR _1690_ sky130_fd_sc_hd__or4_1
XFILLER_60_394 VGND VGND VPWR VPWR sky130_fd_sc_hd__decap_3
XFILLER_20_269 VGND VGND VPWR VPWR sky130_fd_sc_hd__fill_1
X_3734_ net268 _1510_ VGND VGND VPWR VPWR _1557_ sky130_fd_sc_hd__or2_1
XPHY_EDGE_ROW_41_Left_121 VGND VGND VPWR VPWR sky130_fd_sc_hd__decap_3
XFILLER_9_281 VPWR VGND VPWR VGND sky130_ef_sc_hd__decap_12
X_3665_ _1490_ _1494_ net266 VGND VGND VPWR VPWR _1495_ sky130_fd_sc_hd__mux2_1
X_2616_ _1640_ mantisaresult\[56\] mantisaresult\[58\] VGND VGND VPWR VPWR _0559_
+ sky130_fd_sc_hd__a21oi_1
X_3596_ net250 mantisaB0\[5\] VGND VGND VPWR VPWR _1427_ sky130_fd_sc_hd__and2b_1
XTAP_TAPCELL_ROW_7_229 VGND VPWR sky130_fd_sc_hd__tapvpwrvgnd_1
X_2547_ net224 _0325_ _1645_ _1644_ VGND VGND VPWR VPWR _0490_ sky130_fd_sc_hd__and4bb_1
X_2478_ _1637_ _0362_ _0374_ VGND VGND VPWR VPWR _0421_ sky130_fd_sc_hd__or3_1
XPHY_EDGE_ROW_50_Left_130 VGND VGND VPWR VPWR sky130_fd_sc_hd__decap_3
X_4148_ clknet_leaf_2_clk _0255_ VGND VGND VPWR VPWR mantisaBshift\[28\] sky130_fd_sc_hd__dfxtp_1
X_4079_ clknet_leaf_20_clk _0188_ VGND VGND VPWR VPWR expadd\[3\] sky130_fd_sc_hd__dfxtp_1
XFILLER_28_358 VGND VGND VPWR VPWR sky130_fd_sc_hd__decap_6
Xclkload1 clknet_2_2__leaf_clk VGND VGND VPWR VPWR clkload1/Y sky130_fd_sc_hd__inv_6
XFILLER_1_3 VPWR VGND VPWR VGND sky130_ef_sc_hd__decap_12
XFILLER_59_54 VGND VGND VPWR VPWR sky130_fd_sc_hd__fill_2
Xfanout260 net264 VGND VGND VPWR VPWR net260 sky130_fd_sc_hd__buf_2
Xfanout271 net272 VGND VGND VPWR VPWR net271 sky130_fd_sc_hd__buf_2
XFILLER_75_20 VGND VGND VPWR VPWR sky130_fd_sc_hd__fill_1
XFILLER_34_306 VGND VGND VPWR VPWR sky130_fd_sc_hd__fill_2
XFILLER_61_125 VGND VGND VPWR VPWR sky130_fd_sc_hd__fill_1
XFILLER_61_169 VGND VGND VPWR VPWR sky130_fd_sc_hd__decap_8
XTAP_TAPCELL_ROW_12_264 VGND VPWR sky130_fd_sc_hd__tapvpwrvgnd_1
XFILLER_6_251 VGND VGND VPWR VPWR sky130_fd_sc_hd__fill_1
X_3450_ _1306_ _1015_ net147 VGND VGND VPWR VPWR _1307_ sky130_fd_sc_hd__mux2_1
X_2401_ _0343_ VGND VGND VPWR VPWR _0344_ sky130_fd_sc_hd__inv_2
X_3381_ net247 _1239_ _1243_ _1251_ VGND VGND VPWR VPWR _1252_ sky130_fd_sc_hd__a31oi_1
X_2332_ _1909_ net26 net100 VGND VGND VPWR VPWR _0283_ sky130_fd_sc_hd__mux2_1
XFILLER_57_409 VGND VGND VPWR VPWR sky130_fd_sc_hd__fill_2
XFILLER_69_258 VGND VGND VPWR VPWR sky130_fd_sc_hd__decap_3
X_4002_ clknet_leaf_24_clk _0113_ VGND VGND VPWR VPWR mantisaresult\[7\] sky130_fd_sc_hd__dfxtp_1
X_2263_ net43 net170 VGND VGND VPWR VPWR _1897_ sky130_fd_sc_hd__and2_1
X_2194_ net254 _1851_ net177 VGND VGND VPWR VPWR _0037_ sky130_fd_sc_hd__mux2_1
XFILLER_40_309 VGND VGND VPWR VPWR sky130_fd_sc_hd__fill_2
XTAP_TAPCELL_ROW_63_676 VGND VPWR sky130_fd_sc_hd__tapvpwrvgnd_1
X_1978_ net382 VGND VGND VPWR VPWR _1673_ sky130_fd_sc_hd__inv_2
X_3717_ _1539_ _1541_ net252 VGND VGND VPWR VPWR _1542_ sky130_fd_sc_hd__mux2_1
X_3648_ _1476_ _1477_ net271 VGND VGND VPWR VPWR _1478_ sky130_fd_sc_hd__mux2_1
X_3579_ mantisaresult\[60\] net113 net109 mantisaresult\[61\] VGND VGND VPWR VPWR
+ _1411_ sky130_fd_sc_hd__a22o_1
XFILLER_0_427 VPWR VGND VPWR VGND sky130_ef_sc_hd__decap_12
XFILLER_0_449 VPWR VGND VPWR VGND sky130_ef_sc_hd__decap_12
Xhold13 mantisaA0\[5\] VGND VGND VPWR VPWR net287 sky130_fd_sc_hd__dlygate4sd3_1
Xhold46 expmiddleb\[5\] VGND VGND VPWR VPWR net320 sky130_fd_sc_hd__dlygate4sd3_1
Xhold24 expmiddlea\[5\] VGND VGND VPWR VPWR net298 sky130_fd_sc_hd__dlygate4sd3_1
Xhold35 mantisaA0\[21\] VGND VGND VPWR VPWR net309 sky130_fd_sc_hd__dlygate4sd3_1
Xhold79 expadd\[2\] VGND VGND VPWR VPWR net353 sky130_fd_sc_hd__dlygate4sd3_1
XFILLER_28_122 VGND VGND VPWR VPWR sky130_fd_sc_hd__fill_2
Xhold57 four_man\[51\] VGND VGND VPWR VPWR net331 sky130_fd_sc_hd__dlygate4sd3_1
Xhold68 four_man\[53\] VGND VGND VPWR VPWR net342 sky130_fd_sc_hd__dlygate4sd3_1
XTAP_TAPCELL_ROW_26_378 VGND VPWR sky130_fd_sc_hd__tapvpwrvgnd_1
XFILLER_61_55 VGND VGND VPWR VPWR sky130_fd_sc_hd__fill_1
XPHY_EDGE_ROW_7_Left_87 VGND VGND VPWR VPWR sky130_fd_sc_hd__decap_3
XFILLER_47_464 VGND VGND VPWR VPWR sky130_fd_sc_hd__decap_8
XFILLER_34_114 VPWR VGND VPWR VGND sky130_ef_sc_hd__decap_12
XFILLER_62_401 VGND VGND VPWR VPWR sky130_fd_sc_hd__decap_3
XFILLER_62_456 VGND VGND VPWR VPWR sky130_fd_sc_hd__fill_1
XFILLER_15_372 VGND VGND VPWR VPWR sky130_fd_sc_hd__decap_8
XFILLER_22_309 VPWR VGND VPWR VGND sky130_ef_sc_hd__decap_12
X_2950_ net144 _0881_ VGND VGND VPWR VPWR _0882_ sky130_fd_sc_hd__and2b_1
X_2881_ _0820_ VGND VGND VPWR VPWR _0821_ sky130_fd_sc_hd__inv_2
XFILLER_30_386 VPWR VGND VPWR VGND sky130_ef_sc_hd__decap_12
X_3502_ _0922_ _0935_ VGND VGND VPWR VPWR _1341_ sky130_fd_sc_hd__nor2_1
X_3433_ net106 _0829_ net125 VGND VGND VPWR VPWR _1299_ sky130_fd_sc_hd__a21o_1
X_3364_ mantisaresult\[57\] _1236_ net203 VGND VGND VPWR VPWR _0168_ sky130_fd_sc_hd__mux2_1
X_3295_ net246 _1173_ _1172_ VGND VGND VPWR VPWR _1174_ sky130_fd_sc_hd__o21a_1
X_2315_ _0274_ net366 net174 VGND VGND VPWR VPWR _0081_ sky130_fd_sc_hd__mux2_1
XTAP_TAPCELL_ROW_68_713 VGND VPWR sky130_fd_sc_hd__tapvpwrvgnd_1
X_2246_ net36 _1885_ net104 VGND VGND VPWR VPWR _1886_ sky130_fd_sc_hd__mux2_1
XFILLER_72_209 VGND VGND VPWR VPWR sky130_fd_sc_hd__fill_2
X_2177_ _1755_ _1778_ VGND VGND VPWR VPWR _1838_ sky130_fd_sc_hd__xnor2_1
XFILLER_25_169 VPWR VGND VPWR VGND sky130_ef_sc_hd__decap_12
XTAP_TAPCELL_ROW_23_359 VGND VPWR sky130_fd_sc_hd__tapvpwrvgnd_1
Xoutput69 net69 VGND VGND VPWR VPWR exp[3] sky130_fd_sc_hd__buf_2
XFILLER_29_442 VGND VGND VPWR VPWR sky130_fd_sc_hd__decap_6
XFILLER_56_55 VGND VGND VPWR VPWR sky130_fd_sc_hd__decap_6
XFILLER_44_401 VPWR VGND VPWR VGND sky130_ef_sc_hd__decap_12
XTAP_TAPCELL_ROW_39_481 VGND VPWR sky130_fd_sc_hd__tapvpwrvgnd_1
XFILLER_31_106 VGND VGND VPWR VPWR sky130_fd_sc_hd__fill_1
XFILLER_71_275 VGND VGND VPWR VPWR sky130_fd_sc_hd__decap_4
XFILLER_24_191 VGND VGND VPWR VPWR sky130_fd_sc_hd__decap_4
XFILLER_8_346 VGND VGND VPWR VPWR sky130_fd_sc_hd__fill_1
X_2100_ _1760_ _1761_ VGND VGND VPWR VPWR _1762_ sky130_fd_sc_hd__xor2_1
X_3080_ net241 mantisaBshift\[25\] _0986_ net233 VGND VGND VPWR VPWR _0988_ sky130_fd_sc_hd__a31o_1
X_2031_ expmiddled\[1\] expadd\[1\] VGND VGND VPWR VPWR _1723_ sky130_fd_sc_hd__and2_1
X_3982_ clknet_leaf_27_clk net305 VGND VGND VPWR VPWR expmiddleb\[1\] sky130_fd_sc_hd__dfxtp_1
XFILLER_62_253 VPWR VGND VPWR VGND sky130_ef_sc_hd__decap_12
X_2933_ mantisaBshift\[1\] _0867_ VGND VGND VPWR VPWR _0868_ sky130_fd_sc_hd__xnor2_1
XTAP_TAPCELL_ROW_20_329 VGND VPWR sky130_fd_sc_hd__tapvpwrvgnd_1
X_2864_ net127 _0803_ _0602_ VGND VGND VPWR VPWR _0804_ sky130_fd_sc_hd__a21oi_1
X_2795_ net227 net110 _0661_ net135 VGND VGND VPWR VPWR _0737_ sky130_fd_sc_hd__a22o_1
X_3416_ mantisaresult\[62\] _1283_ net204 VGND VGND VPWR VPWR _0173_ sky130_fd_sc_hd__mux2_1
X_3347_ mantisaBshift\[55\] mantisaAshift\[55\] VGND VGND VPWR VPWR _1221_ sky130_fd_sc_hd__and2b_1
X_3278_ mantisaBshift\[50\] mantisaAshift\[50\] net248 VGND VGND VPWR VPWR _1158_
+ sky130_fd_sc_hd__nand3b_1
X_2229_ _1874_ net281 net172 VGND VGND VPWR VPWR _0049_ sky130_fd_sc_hd__mux2_1
XFILLER_38_294 VPWR VGND VPWR VGND sky130_ef_sc_hd__decap_12
XTAP_TAPCELL_ROW_36_462 VGND VPWR sky130_fd_sc_hd__tapvpwrvgnd_1
XFILLER_53_242 VGND VGND VPWR VPWR sky130_fd_sc_hd__decap_4
XFILLER_53_264 VPWR VGND VPWR VGND sky130_ef_sc_hd__decap_12
XFILLER_42_24 VGND VGND VPWR VPWR sky130_fd_sc_hd__decap_4
XTAP_TAPCELL_ROW_79_808 VGND VPWR sky130_fd_sc_hd__tapvpwrvgnd_1
XPHY_EDGE_ROW_79_Left_159 VGND VGND VPWR VPWR sky130_fd_sc_hd__decap_3
XFILLER_76_301 VGND VGND VPWR VPWR sky130_fd_sc_hd__decap_6
XFILLER_76_345 VPWR VGND VPWR VGND sky130_ef_sc_hd__decap_12
XFILLER_76_389 VPWR VGND VPWR VGND sky130_ef_sc_hd__decap_12
XFILLER_29_250 VGND VGND VPWR VPWR sky130_fd_sc_hd__decap_3
XFILLER_17_423 VPWR VGND VPWR VGND sky130_ef_sc_hd__decap_12
XFILLER_44_286 VGND VGND VPWR VPWR sky130_fd_sc_hd__fill_1
XTAP_TAPCELL_ROW_70_730 VGND VPWR sky130_fd_sc_hd__tapvpwrvgnd_1
XFILLER_12_150 VGND VGND VPWR VPWR sky130_fd_sc_hd__decap_8
XFILLER_8_121 VGND VGND VPWR VPWR sky130_fd_sc_hd__fill_1
XFILLER_8_187 VGND VGND VPWR VPWR sky130_fd_sc_hd__decap_8
XFILLER_66_6 VGND VGND VPWR VPWR sky130_fd_sc_hd__fill_1
X_2580_ net225 _0335_ _0346_ VGND VGND VPWR VPWR _0523_ sky130_fd_sc_hd__and3_1
X_3201_ net328 net206 _1086_ _1088_ VGND VGND VPWR VPWR _0153_ sky130_fd_sc_hd__o22a_1
X_3132_ mantisaresult\[35\] net235 _1027_ _1028_ VGND VGND VPWR VPWR _0144_ sky130_fd_sc_hd__a22o_1
XFILLER_67_334 VGND VGND VPWR VPWR sky130_fd_sc_hd__fill_2
XFILLER_67_345 VGND VGND VPWR VPWR sky130_fd_sc_hd__decap_6
X_3063_ mantisaresult\[47\] net156 VGND VGND VPWR VPWR _0973_ sky130_fd_sc_hd__nand2_1
X_2014_ net51 net40 net56 net55 VGND VGND VPWR VPWR _1709_ sky130_fd_sc_hd__or4_1
XFILLER_35_253 VGND VGND VPWR VPWR sky130_fd_sc_hd__fill_1
XFILLER_35_275 VGND VGND VPWR VPWR sky130_fd_sc_hd__fill_2
XTAP_TAPCELL_ROW_33_432 VGND VPWR sky130_fd_sc_hd__tapvpwrvgnd_1
X_3965_ clknet_leaf_5_clk _0088_ VGND VGND VPWR VPWR mantisaB0\[16\] sky130_fd_sc_hd__dfxtp_1
XFILLER_50_245 VGND VGND VPWR VPWR sky130_fd_sc_hd__decap_6
XFILLER_31_470 VGND VGND VPWR VPWR sky130_fd_sc_hd__decap_3
X_2916_ _0735_ _0730_ net143 VGND VGND VPWR VPWR _0854_ sky130_fd_sc_hd__mux2_1
X_3896_ clknet_leaf_17_clk _0019_ VGND VGND VPWR VPWR net96 sky130_fd_sc_hd__dfxtp_1
X_2847_ _0616_ _0621_ net115 VGND VGND VPWR VPWR _0788_ sky130_fd_sc_hd__mux2_1
X_2778_ net141 _0718_ _0719_ VGND VGND VPWR VPWR _0720_ sky130_fd_sc_hd__o21ai_1
Xhold110 mantisaresult\[26\] VGND VGND VPWR VPWR net384 sky130_fd_sc_hd__dlygate4sd3_1
XFILLER_18_209 VGND VGND VPWR VPWR sky130_fd_sc_hd__fill_1
XFILLER_37_57 VGND VGND VPWR VPWR sky130_fd_sc_hd__decap_3
XFILLER_37_79 VGND VGND VPWR VPWR sky130_fd_sc_hd__decap_4
XFILLER_73_337 VPWR VGND VPWR VGND sky130_ef_sc_hd__decap_12
XFILLER_26_253 VGND VGND VPWR VPWR sky130_fd_sc_hd__fill_1
XFILLER_53_12 VGND VGND VPWR VPWR sky130_fd_sc_hd__fill_1
XFILLER_53_45 VGND VGND VPWR VPWR sky130_fd_sc_hd__fill_1
XFILLER_22_470 VGND VGND VPWR VPWR sky130_fd_sc_hd__decap_3
XFILLER_5_113 VPWR VGND VPWR VGND sky130_ef_sc_hd__decap_12
XFILLER_1_363 VGND VGND VPWR VPWR sky130_fd_sc_hd__decap_3
XFILLER_49_334 VGND VGND VPWR VPWR sky130_fd_sc_hd__fill_2
XTAP_TAPCELL_ROW_47_546 VGND VPWR sky130_fd_sc_hd__tapvpwrvgnd_1
XFILLER_64_359 VGND VGND VPWR VPWR sky130_fd_sc_hd__decap_4
XFILLER_20_407 VGND VGND VPWR VPWR sky130_fd_sc_hd__fill_1
XFILLER_20_429 VPWR VGND VPWR VGND sky130_ef_sc_hd__decap_12
X_3750_ net260 _1460_ VGND VGND VPWR VPWR _1571_ sky130_fd_sc_hd__or2_1
XTAP_TAPCELL_ROW_30_413 VGND VPWR sky130_fd_sc_hd__tapvpwrvgnd_1
X_2701_ mantisaresult\[31\] net154 VGND VGND VPWR VPWR _0644_ sky130_fd_sc_hd__nand2_1
X_3681_ _1506_ _1507_ net268 VGND VGND VPWR VPWR _1508_ sky130_fd_sc_hd__mux2_1
X_2632_ net166 _0571_ VGND VGND VPWR VPWR _0575_ sky130_fd_sc_hd__nand2_1
X_2563_ _0492_ _0502_ VGND VGND VPWR VPWR _0506_ sky130_fd_sc_hd__or2_1
X_2494_ mantisaresult\[7\] mantisaresult\[6\] mantisaresult\[5\] VGND VGND VPWR VPWR
+ _0437_ sky130_fd_sc_hd__or3_1
XFILLER_4_83 VGND VGND VPWR VPWR sky130_fd_sc_hd__fill_1
XFILLER_67_131 VGND VGND VPWR VPWR sky130_fd_sc_hd__decap_3
XFILLER_67_142 VGND VGND VPWR VPWR sky130_fd_sc_hd__fill_1
X_4164_ clknet_leaf_9_clk _0271_ VGND VGND VPWR VPWR mantisaBshift\[49\] sky130_fd_sc_hd__dfxtp_1
X_3115_ net220 net109 _1013_ VGND VGND VPWR VPWR _1014_ sky130_fd_sc_hd__a21o_1
XFILLER_67_164 VGND VGND VPWR VPWR sky130_fd_sc_hd__decap_4
X_4095_ clknet_leaf_16_clk _0202_ VGND VGND VPWR VPWR four_man\[54\] sky130_fd_sc_hd__dfxtp_1
X_3046_ _0959_ _0960_ mantisaresult\[19\] net234 VGND VGND VPWR VPWR _0126_ sky130_fd_sc_hd__a2bb2o_1
XFILLER_55_337 VPWR VGND VPWR VGND sky130_ef_sc_hd__decap_12
XFILLER_23_223 VGND VGND VPWR VPWR sky130_fd_sc_hd__fill_1
XFILLER_23_256 VPWR VGND VPWR VGND sky130_ef_sc_hd__decap_12
X_3948_ clknet_leaf_29_clk _0071_ VGND VGND VPWR VPWR mantisaA0\[22\] sky130_fd_sc_hd__dfxtp_1
X_3879_ clknet_leaf_20_clk _0002_ VGND VGND VPWR VPWR net66 sky130_fd_sc_hd__dfxtp_1
XFILLER_48_12 VGND VGND VPWR VPWR sky130_fd_sc_hd__fill_1
XFILLER_58_131 VGND VGND VPWR VPWR sky130_fd_sc_hd__fill_1
XFILLER_46_326 VGND VGND VPWR VPWR sky130_fd_sc_hd__fill_2
XFILLER_58_186 VGND VGND VPWR VPWR sky130_fd_sc_hd__decap_8
XFILLER_58_197 VPWR VGND VPWR VGND sky130_ef_sc_hd__decap_12
XFILLER_61_307 VPWR VGND VPWR VGND sky130_ef_sc_hd__decap_12
XFILLER_73_156 VPWR VGND VPWR VGND sky130_ef_sc_hd__decap_12
XFILLER_14_201 VGND VGND VPWR VPWR sky130_fd_sc_hd__fill_2
XTAP_TAPCELL_ROW_1_182 VGND VPWR sky130_fd_sc_hd__tapvpwrvgnd_1
XTAP_TAPCELL_ROW_44_527 VGND VPWR sky130_fd_sc_hd__tapvpwrvgnd_1
XFILLER_14_267 VPWR VGND VPWR VGND sky130_ef_sc_hd__decap_12
XFILLER_9_28 VGND VGND VPWR VPWR sky130_fd_sc_hd__decap_4
XFILLER_1_193 VPWR VGND VPWR VGND sky130_ef_sc_hd__decap_12
XFILLER_37_337 VPWR VGND VPWR VGND sky130_ef_sc_hd__decap_12
XFILLER_45_370 VPWR VGND VPWR VGND sky130_ef_sc_hd__decap_12
X_3802_ net192 _1504_ VGND VGND VPWR VPWR _0236_ sky130_fd_sc_hd__and2_1
XFILLER_20_237 VGND VGND VPWR VPWR sky130_fd_sc_hd__fill_1
XTAP_TAPCELL_ROW_15_295 VGND VPWR sky130_fd_sc_hd__tapvpwrvgnd_1
X_1994_ net35 net34 net37 net36 VGND VGND VPWR VPWR _1689_ sky130_fd_sc_hd__or4_1
XFILLER_9_260 VPWR VGND VPWR VGND sky130_ef_sc_hd__decap_12
X_3733_ _1554_ _1555_ net260 VGND VGND VPWR VPWR _1556_ sky130_fd_sc_hd__mux2_1
XFILLER_9_293 VGND VGND VPWR VPWR sky130_fd_sc_hd__decap_8
X_3664_ _1491_ _1493_ _1685_ VGND VGND VPWR VPWR _1494_ sky130_fd_sc_hd__mux2_1
X_2615_ _1639_ mantisaresult\[60\] mantisaresult\[62\] VGND VGND VPWR VPWR _0558_
+ sky130_fd_sc_hd__a21oi_1
X_3595_ mantisaB0\[2\] net193 _1425_ net273 VGND VGND VPWR VPWR _1426_ sky130_fd_sc_hd__a22o_1
X_2546_ _0353_ _0483_ _0488_ VGND VGND VPWR VPWR _0489_ sky130_fd_sc_hd__o21ai_1
X_2477_ _0414_ _0417_ _0419_ VGND VGND VPWR VPWR _0420_ sky130_fd_sc_hd__and3b_1
X_4147_ clknet_leaf_2_clk _0254_ VGND VGND VPWR VPWR mantisaBshift\[29\] sky130_fd_sc_hd__dfxtp_1
XFILLER_18_59 VGND VGND VPWR VPWR sky130_fd_sc_hd__decap_3
XFILLER_28_337 VGND VGND VPWR VPWR sky130_fd_sc_hd__decap_3
X_4078_ clknet_leaf_20_clk _0187_ VGND VGND VPWR VPWR expadd\[2\] sky130_fd_sc_hd__dfxtp_1
XFILLER_43_307 VGND VGND VPWR VPWR sky130_fd_sc_hd__fill_1
XFILLER_55_167 VGND VGND VPWR VPWR sky130_fd_sc_hd__fill_1
X_3029_ net237 _0947_ mantisaBshift\[15\] VGND VGND VPWR VPWR _0948_ sky130_fd_sc_hd__a21oi_1
XTAP_TAPCELL_ROW_66_696 VGND VPWR sky130_fd_sc_hd__tapvpwrvgnd_1
Xclkload2 clknet_2_3__leaf_clk VGND VGND VPWR VPWR clkload2/Y sky130_fd_sc_hd__clkinv_8
XFILLER_50_79 VGND VGND VPWR VPWR sky130_fd_sc_hd__decap_4
XFILLER_3_447 VGND VGND VPWR VPWR sky130_fd_sc_hd__fill_1
Xfanout250 net251 VGND VGND VPWR VPWR net250 sky130_fd_sc_hd__clkbuf_2
XFILLER_59_88 VGND VGND VPWR VPWR sky130_fd_sc_hd__fill_1
Xfanout272 expmiddle\[1\] VGND VGND VPWR VPWR net272 sky130_fd_sc_hd__buf_2
Xfanout261 net264 VGND VGND VPWR VPWR net261 sky130_fd_sc_hd__clkbuf_2
XFILLER_75_10 VGND VGND VPWR VPWR sky130_fd_sc_hd__fill_1
XFILLER_46_101 VGND VGND VPWR VPWR sky130_fd_sc_hd__fill_1
XFILLER_74_421 VPWR VGND VPWR VGND sky130_ef_sc_hd__decap_12
XTAP_TAPCELL_ROW_57_630 VGND VPWR sky130_fd_sc_hd__tapvpwrvgnd_1
XTAP_TAPCELL_ROW_12_265 VGND VPWR sky130_fd_sc_hd__tapvpwrvgnd_1
X_2400_ _0306_ _0342_ VGND VGND VPWR VPWR _0343_ sky130_fd_sc_hd__nor2_1
X_3380_ _1249_ _1250_ net247 VGND VGND VPWR VPWR _1251_ sky130_fd_sc_hd__mux2_1
X_2331_ _0282_ net363 net171 VGND VGND VPWR VPWR _0089_ sky130_fd_sc_hd__mux2_1
XFILLER_69_204 VPWR VGND VPWR VGND sky130_ef_sc_hd__decap_12
XFILLER_69_248 VGND VGND VPWR VPWR sky130_fd_sc_hd__fill_1
X_2262_ _1896_ net284 net173 VGND VGND VPWR VPWR _0060_ sky130_fd_sc_hd__mux2_1
X_4001_ clknet_leaf_24_clk _0112_ VGND VGND VPWR VPWR mantisaresult\[6\] sky130_fd_sc_hd__dfxtp_1
XFILLER_77_281 VPWR VGND VPWR VGND sky130_ef_sc_hd__decap_12
X_2193_ _1848_ _1850_ VGND VGND VPWR VPWR _1851_ sky130_fd_sc_hd__xnor2_1
XFILLER_1_51 VGND VGND VPWR VPWR sky130_fd_sc_hd__decap_4
XTAP_TAPCELL_ROW_63_677 VGND VPWR sky130_fd_sc_hd__tapvpwrvgnd_1
XFILLER_33_384 VGND VGND VPWR VPWR sky130_fd_sc_hd__fill_1
X_1977_ net11 VGND VGND VPWR VPWR _1672_ sky130_fd_sc_hd__inv_2
X_3716_ net260 _1540_ VGND VGND VPWR VPWR _1541_ sky130_fd_sc_hd__or2_1
X_3647_ _1686_ _1440_ _1457_ mantisaB0\[12\] VGND VGND VPWR VPWR _1477_ sky130_fd_sc_hd__a22oi_1
X_3578_ net128 _0888_ _1409_ net150 VGND VGND VPWR VPWR _1410_ sky130_fd_sc_hd__o211a_1
XFILLER_0_406 VPWR VGND VPWR VGND sky130_ef_sc_hd__decap_12
X_2529_ mantisaresult\[29\] _0349_ _0351_ VGND VGND VPWR VPWR _0472_ sky130_fd_sc_hd__and3_1
XFILLER_0_439 VGND VGND VPWR VPWR sky130_fd_sc_hd__decap_8
Xhold14 mantisaA0\[20\] VGND VGND VPWR VPWR net288 sky130_fd_sc_hd__dlygate4sd3_1
XFILLER_75_207 VGND VGND VPWR VPWR sky130_fd_sc_hd__decap_3
Xhold47 expmiddleb\[3\] VGND VGND VPWR VPWR net321 sky130_fd_sc_hd__dlygate4sd3_1
Xhold36 mantisaA0\[22\] VGND VGND VPWR VPWR net310 sky130_fd_sc_hd__dlygate4sd3_1
Xhold25 mantisaA0\[6\] VGND VGND VPWR VPWR net299 sky130_fd_sc_hd__dlygate4sd3_1
Xhold69 expadd\[6\] VGND VGND VPWR VPWR net343 sky130_fd_sc_hd__dlygate4sd3_1
Xhold58 four_man\[60\] VGND VGND VPWR VPWR net332 sky130_fd_sc_hd__dlygate4sd3_1
XFILLER_16_318 VGND VGND VPWR VPWR sky130_fd_sc_hd__decap_6
XFILLER_28_178 VGND VGND VPWR VPWR sky130_fd_sc_hd__fill_1
XTAP_TAPCELL_ROW_54_600 VGND VPWR sky130_fd_sc_hd__tapvpwrvgnd_1
XFILLER_45_57 VGND VGND VPWR VPWR sky130_fd_sc_hd__decap_4
XTAP_TAPCELL_ROW_26_379 VGND VPWR sky130_fd_sc_hd__tapvpwrvgnd_1
XFILLER_6_29 VPWR VGND VPWR VGND sky130_ef_sc_hd__decap_12
XFILLER_6_18 VGND VGND VPWR VPWR sky130_fd_sc_hd__decap_8
XFILLER_10_82 VGND VGND VPWR VPWR sky130_fd_sc_hd__fill_2
XFILLER_47_421 VGND VGND VPWR VPWR sky130_fd_sc_hd__decap_6
XFILLER_59_281 VGND VGND VPWR VPWR sky130_fd_sc_hd__decap_8
XFILLER_66_229 VGND VGND VPWR VPWR sky130_fd_sc_hd__decap_8
XFILLER_47_443 VGND VGND VPWR VPWR sky130_fd_sc_hd__decap_4
XFILLER_19_167 VGND VGND VPWR VPWR sky130_fd_sc_hd__fill_1
XFILLER_74_262 VGND VGND VPWR VPWR sky130_fd_sc_hd__fill_2
XFILLER_34_126 VPWR VGND VPWR VGND sky130_ef_sc_hd__decap_12
X_2880_ _0713_ _0715_ net116 VGND VGND VPWR VPWR _0820_ sky130_fd_sc_hd__mux2_1
XFILLER_35_90 VPWR VGND VPWR VGND sky130_ef_sc_hd__decap_12
XFILLER_42_181 VGND VGND VPWR VPWR sky130_fd_sc_hd__decap_6
XFILLER_30_398 VPWR VGND VPWR VGND sky130_ef_sc_hd__decap_12
X_3501_ _1333_ _1338_ _1339_ net129 VGND VGND VPWR VPWR _1340_ sky130_fd_sc_hd__a31o_1
X_3432_ _0834_ _0926_ VGND VGND VPWR VPWR _1298_ sky130_fd_sc_hd__nor2_1
X_3363_ _1232_ _1235_ VGND VGND VPWR VPWR _1236_ sky130_fd_sc_hd__xnor2_1
X_3294_ _1154_ _1157_ _1155_ VGND VGND VPWR VPWR _1173_ sky130_fd_sc_hd__o21a_1
X_2314_ _1891_ net39 net104 VGND VGND VPWR VPWR _0274_ sky130_fd_sc_hd__mux2_1
XTAP_TAPCELL_ROW_68_714 VGND VPWR sky130_fd_sc_hd__tapvpwrvgnd_1
X_2245_ net59 net169 VGND VGND VPWR VPWR _1885_ sky130_fd_sc_hd__and2_1
X_2176_ _1757_ _1836_ VGND VGND VPWR VPWR _1837_ sky130_fd_sc_hd__nand2_1
XTAP_TAPCELL_ROW_76_780 VGND VPWR sky130_fd_sc_hd__tapvpwrvgnd_1
XFILLER_31_15 VGND VGND VPWR VPWR sky130_fd_sc_hd__fill_1
XPHY_EDGE_ROW_1_Right_1 VGND VGND VPWR VPWR sky130_fd_sc_hd__decap_3
XFILLER_0_225 VPWR VGND VPWR VGND sky130_ef_sc_hd__decap_12
XFILLER_56_45 VGND VGND VPWR VPWR sky130_fd_sc_hd__fill_1
XFILLER_44_413 VGND VGND VPWR VPWR sky130_fd_sc_hd__decap_6
XFILLER_56_251 VGND VGND VPWR VPWR sky130_fd_sc_hd__fill_1
XTAP_TAPCELL_ROW_39_482 VGND VPWR sky130_fd_sc_hd__tapvpwrvgnd_1
XFILLER_56_295 VGND VGND VPWR VPWR sky130_fd_sc_hd__fill_2
XFILLER_44_468 VGND VGND VPWR VPWR sky130_fd_sc_hd__fill_1
XFILLER_12_376 VGND VGND VPWR VPWR sky130_fd_sc_hd__decap_4
XFILLER_12_398 VPWR VGND VPWR VGND sky130_ef_sc_hd__decap_12
XFILLER_8_369 VGND VGND VPWR VPWR sky130_fd_sc_hd__fill_1
XFILLER_79_343 VGND VGND VPWR VPWR sky130_fd_sc_hd__decap_3
XFILLER_79_321 VPWR VGND VPWR VGND sky130_ef_sc_hd__decap_12
XFILLER_79_365 VPWR VGND VPWR VGND sky130_ef_sc_hd__decap_12
X_2030_ _1721_ _1722_ net212 VGND VGND VPWR VPWR _0002_ sky130_fd_sc_hd__a21o_1
XFILLER_35_413 VGND VGND VPWR VPWR sky130_fd_sc_hd__fill_2
X_3981_ clknet_leaf_25_clk net311 VGND VGND VPWR VPWR expmiddleb\[0\] sky130_fd_sc_hd__dfxtp_1
XFILLER_62_265 VGND VGND VPWR VPWR sky130_fd_sc_hd__decap_4
X_2932_ mantisaBshift\[0\] net239 VGND VGND VPWR VPWR _0867_ sky130_fd_sc_hd__nand2_1
XFILLER_50_427 VGND VGND VPWR VPWR sky130_fd_sc_hd__decap_6
X_2863_ _0799_ _0802_ net124 VGND VGND VPWR VPWR _0803_ sky130_fd_sc_hd__mux2_1
X_2794_ mantisaresult\[38\] net110 _0658_ net135 VGND VGND VPWR VPWR _0736_ sky130_fd_sc_hd__a22o_1
X_3415_ _1277_ _1282_ VGND VGND VPWR VPWR _1283_ sky130_fd_sc_hd__xor2_1
X_3346_ _1198_ _1210_ VGND VGND VPWR VPWR _1220_ sky130_fd_sc_hd__nand2_1
X_3277_ _1142_ _1151_ _1144_ VGND VGND VPWR VPWR _1157_ sky130_fd_sc_hd__a21oi_1
XFILLER_26_413 VGND VGND VPWR VPWR sky130_fd_sc_hd__fill_2
X_2228_ net17 _1873_ net102 VGND VGND VPWR VPWR _1874_ sky130_fd_sc_hd__mux2_1
XFILLER_26_37 VGND VGND VPWR VPWR sky130_fd_sc_hd__decap_3
X_2159_ _1652_ net49 VGND VGND VPWR VPWR _1820_ sky130_fd_sc_hd__or2_1
XFILLER_38_284 VGND VGND VPWR VPWR sky130_fd_sc_hd__fill_2
XTAP_TAPCELL_ROW_36_463 VGND VPWR sky130_fd_sc_hd__tapvpwrvgnd_1
XFILLER_41_449 VPWR VGND VPWR VGND sky130_ef_sc_hd__decap_12
XFILLER_53_276 VGND VGND VPWR VPWR sky130_fd_sc_hd__decap_4
XFILLER_53_287 VPWR VGND VPWR VGND sky130_ef_sc_hd__decap_12
XTAP_TAPCELL_ROW_79_809 VGND VPWR sky130_fd_sc_hd__tapvpwrvgnd_1
XPHY_EDGE_ROW_10_Left_90 VGND VGND VPWR VPWR sky130_fd_sc_hd__decap_3
XFILLER_67_66 VGND VGND VPWR VPWR sky130_fd_sc_hd__decap_4
XFILLER_76_357 VGND VGND VPWR VPWR sky130_fd_sc_hd__decap_6
XFILLER_17_435 VPWR VGND VPWR VGND sky130_ef_sc_hd__decap_12
XFILLER_32_416 VGND VGND VPWR VPWR sky130_fd_sc_hd__fill_1
Xclkbuf_leaf_24_clk clknet_2_0__leaf_clk VGND VGND VPWR VPWR clknet_leaf_24_clk sky130_fd_sc_hd__clkbuf_8
XTAP_TAPCELL_ROW_70_731 VGND VPWR sky130_fd_sc_hd__tapvpwrvgnd_1
XFILLER_12_195 VGND VGND VPWR VPWR sky130_fd_sc_hd__fill_1
XFILLER_8_166 VGND VGND VPWR VPWR sky130_fd_sc_hd__fill_1
XFILLER_4_361 VGND VGND VPWR VPWR sky130_fd_sc_hd__decap_3
X_3200_ mantisaresult\[50\] net195 net164 _1087_ VGND VGND VPWR VPWR _1088_ sky130_fd_sc_hd__a31o_1
X_3131_ mantisaBshift\[35\] _1026_ net202 VGND VGND VPWR VPWR _1028_ sky130_fd_sc_hd__o21a_1
XFILLER_67_302 VPWR VGND VPWR VGND sky130_ef_sc_hd__decap_12
XFILLER_79_195 VGND VGND VPWR VPWR sky130_fd_sc_hd__fill_1
X_3062_ _0681_ _0744_ _0921_ _0664_ VGND VGND VPWR VPWR _0972_ sky130_fd_sc_hd__a2bb2o_1
XFILLER_67_368 VGND VGND VPWR VPWR sky130_fd_sc_hd__fill_2
X_2013_ net58 net57 net60 net59 VGND VGND VPWR VPWR _1708_ sky130_fd_sc_hd__or4_1
XTAP_TAPCELL_ROW_33_433 VGND VPWR sky130_fd_sc_hd__tapvpwrvgnd_1
Xclkbuf_leaf_15_clk clknet_2_3__leaf_clk VGND VGND VPWR VPWR clknet_leaf_15_clk sky130_fd_sc_hd__clkbuf_8
X_3964_ clknet_leaf_7_clk _0087_ VGND VGND VPWR VPWR mantisaB0\[15\] sky130_fd_sc_hd__dfxtp_1
X_2915_ net128 _0852_ net150 VGND VGND VPWR VPWR _0853_ sky130_fd_sc_hd__o21ai_1
X_3895_ clknet_leaf_16_clk _0018_ VGND VGND VPWR VPWR net95 sky130_fd_sc_hd__dfxtp_1
X_2846_ _0632_ _0786_ VGND VGND VPWR VPWR _0787_ sky130_fd_sc_hd__nand2_1
X_2777_ _0714_ net141 VGND VGND VPWR VPWR _0719_ sky130_fd_sc_hd__nand2b_1
Xhold100 mantisaB0\[16\] VGND VGND VPWR VPWR net374 sky130_fd_sc_hd__dlygate4sd3_1
Xhold111 mantisaB0\[8\] VGND VGND VPWR VPWR net385 sky130_fd_sc_hd__dlygate4sd3_1
X_3329_ _1176_ _1179_ _1177_ VGND VGND VPWR VPWR _1205_ sky130_fd_sc_hd__o21a_1
XFILLER_37_69 VGND VGND VPWR VPWR sky130_fd_sc_hd__fill_1
XFILLER_73_349 VPWR VGND VPWR VGND sky130_ef_sc_hd__decap_12
XFILLER_26_287 VGND VGND VPWR VPWR sky130_fd_sc_hd__fill_1
XFILLER_41_246 VPWR VGND VPWR VGND sky130_ef_sc_hd__decap_12
XFILLER_53_57 VGND VGND VPWR VPWR sky130_fd_sc_hd__fill_1
XFILLER_5_125 VPWR VGND VPWR VGND sky130_ef_sc_hd__decap_12
XFILLER_5_169 VPWR VGND VPWR VGND sky130_ef_sc_hd__decap_12
XFILLER_78_54 VPWR VGND VPWR VGND sky130_ef_sc_hd__decap_12
XFILLER_49_313 VGND VGND VPWR VPWR sky130_fd_sc_hd__decap_3
XFILLER_64_305 VGND VGND VPWR VPWR sky130_fd_sc_hd__decap_3
XFILLER_17_210 VGND VGND VPWR VPWR sky130_fd_sc_hd__decap_3
XTAP_TAPCELL_ROW_47_547 VGND VPWR sky130_fd_sc_hd__tapvpwrvgnd_1
XFILLER_17_265 VPWR VGND VPWR VGND sky130_ef_sc_hd__decap_12
XFILLER_32_213 VPWR VGND VPWR VGND sky130_ef_sc_hd__decap_12
XTAP_TAPCELL_ROW_30_414 VGND VPWR sky130_fd_sc_hd__tapvpwrvgnd_1
X_2700_ mantisaresult\[28\] net112 _0641_ net132 VGND VGND VPWR VPWR _0643_ sky130_fd_sc_hd__o2bb2a_1
X_3680_ _1443_ _1447_ net270 VGND VGND VPWR VPWR _1507_ sky130_fd_sc_hd__mux2_1
X_2631_ _0445_ _0506_ _0567_ VGND VGND VPWR VPWR _0574_ sky130_fd_sc_hd__or3_1
X_2562_ _0329_ _0361_ _0449_ _0499_ VGND VGND VPWR VPWR _0505_ sky130_fd_sc_hd__or4_1
X_2493_ _0435_ VGND VGND VPWR VPWR _0436_ sky130_fd_sc_hd__inv_2
Xclkbuf_leaf_4_clk clknet_2_1__leaf_clk VGND VGND VPWR VPWR clknet_leaf_4_clk sky130_fd_sc_hd__clkbuf_8
X_4163_ clknet_leaf_9_clk _0270_ VGND VGND VPWR VPWR mantisaBshift\[50\] sky130_fd_sc_hd__dfxtp_1
X_4094_ clknet_leaf_20_clk net214 VGND VGND VPWR VPWR inf3 sky130_fd_sc_hd__dfxtp_1
X_3114_ mantisaresult\[47\] net156 net133 VGND VGND VPWR VPWR _1013_ sky130_fd_sc_hd__and3_1
X_3045_ net237 mantisaBshift\[19\] _0958_ net234 VGND VGND VPWR VPWR _0960_ sky130_fd_sc_hd__a31o_1
XFILLER_55_349 VPWR VGND VPWR VGND sky130_ef_sc_hd__decap_12
XFILLER_23_268 VGND VGND VPWR VPWR sky130_fd_sc_hd__decap_8
X_3947_ clknet_leaf_0_clk _0070_ VGND VGND VPWR VPWR mantisaA0\[21\] sky130_fd_sc_hd__dfxtp_1
X_3878_ clknet_leaf_28_clk net279 VGND VGND VPWR VPWR net97 sky130_fd_sc_hd__dfxtp_1
X_2829_ _0769_ _0768_ net148 VGND VGND VPWR VPWR _0770_ sky130_fd_sc_hd__mux2_1
XFILLER_2_139 VGND VGND VPWR VPWR sky130_fd_sc_hd__fill_1
XFILLER_78_419 VGND VGND VPWR VPWR sky130_fd_sc_hd__fill_1
XFILLER_73_113 VGND VGND VPWR VPWR sky130_fd_sc_hd__fill_2
XTAP_TAPCELL_ROW_1_183 VGND VPWR sky130_fd_sc_hd__tapvpwrvgnd_1
XFILLER_61_319 VPWR VGND VPWR VGND sky130_ef_sc_hd__decap_12
XFILLER_54_393 VGND VGND VPWR VPWR sky130_fd_sc_hd__fill_2
XFILLER_14_279 VPWR VGND VPWR VGND sky130_ef_sc_hd__decap_12
XFILLER_13_82 VGND VGND VPWR VPWR sky130_fd_sc_hd__fill_1
XFILLER_1_161 VGND VGND VPWR VPWR sky130_fd_sc_hd__decap_6
XFILLER_77_441 VGND VGND VPWR VPWR sky130_fd_sc_hd__decap_6
XFILLER_49_165 VGND VGND VPWR VPWR sky130_fd_sc_hd__decap_3
XFILLER_37_316 VGND VGND VPWR VPWR sky130_fd_sc_hd__fill_2
XFILLER_37_327 VGND VGND VPWR VPWR sky130_fd_sc_hd__fill_2
XFILLER_37_349 VPWR VGND VPWR VGND sky130_ef_sc_hd__decap_12
XFILLER_52_319 VPWR VGND VPWR VGND sky130_ef_sc_hd__decap_12
XFILLER_45_382 VGND VGND VPWR VPWR sky130_fd_sc_hd__decap_8
X_3801_ _1462_ net191 VGND VGND VPWR VPWR _0235_ sky130_fd_sc_hd__nor2_1
XFILLER_60_374 VGND VGND VPWR VPWR sky130_fd_sc_hd__decap_4
X_1993_ net235 VGND VGND VPWR VPWR _1688_ sky130_fd_sc_hd__inv_2
X_3732_ _1507_ _1509_ net268 VGND VGND VPWR VPWR _1555_ sky130_fd_sc_hd__mux2_1
XFILLER_9_272 VGND VGND VPWR VPWR sky130_fd_sc_hd__decap_8
Xclkload20 clknet_leaf_19_clk VGND VGND VPWR VPWR clkload20/Y sky130_fd_sc_hd__clkinv_8
X_3663_ mantisaB0\[22\] net185 _1492_ VGND VGND VPWR VPWR _1493_ sky130_fd_sc_hd__a21boi_1
X_2614_ _0309_ mantisaresult\[51\] mantisaresult\[50\] VGND VGND VPWR VPWR _0557_
+ sky130_fd_sc_hd__or3b_1
X_3594_ net250 mantisaB0\[3\] VGND VGND VPWR VPWR _1425_ sky130_fd_sc_hd__and2b_1
X_2545_ _0331_ _0332_ _0350_ _0487_ VGND VGND VPWR VPWR _0488_ sky130_fd_sc_hd__or4_1
X_2476_ _0338_ _0348_ _0418_ VGND VGND VPWR VPWR _0419_ sky130_fd_sc_hd__or3_1
X_4146_ clknet_leaf_2_clk _0253_ VGND VGND VPWR VPWR mantisaBshift\[30\] sky130_fd_sc_hd__dfxtp_1
X_4077_ clknet_leaf_20_clk _0186_ VGND VGND VPWR VPWR expadd\[1\] sky130_fd_sc_hd__dfxtp_1
X_3028_ mantisaBshift\[13\] mantisaBshift\[14\] _0917_ VGND VGND VPWR VPWR _0947_
+ sky130_fd_sc_hd__or3_1
XTAP_TAPCELL_ROW_66_697 VGND VPWR sky130_fd_sc_hd__tapvpwrvgnd_1
XFILLER_36_382 VGND VGND VPWR VPWR sky130_fd_sc_hd__decap_3
XFILLER_70_149 VPWR VGND VPWR VGND sky130_ef_sc_hd__decap_12
XFILLER_11_205 VGND VGND VPWR VPWR sky130_fd_sc_hd__decap_3
XFILLER_11_238 VGND VGND VPWR VPWR sky130_fd_sc_hd__decap_6
XFILLER_51_385 VGND VGND VPWR VPWR sky130_fd_sc_hd__decap_6
Xclkload3 clknet_leaf_0_clk VGND VGND VPWR VPWR clkload3/Y sky130_fd_sc_hd__clkinv_16
Xfanout240 net243 VGND VGND VPWR VPWR net240 sky130_fd_sc_hd__dlymetal6s2s_1
XTAP_TAPCELL_ROW_6_220 VGND VPWR sky130_fd_sc_hd__tapvpwrvgnd_1
Xfanout251 expmiddle\[7\] VGND VGND VPWR VPWR net251 sky130_fd_sc_hd__buf_2
Xfanout273 net274 VGND VGND VPWR VPWR net273 sky130_fd_sc_hd__clkbuf_2
Xfanout262 net263 VGND VGND VPWR VPWR net262 sky130_fd_sc_hd__clkbuf_2
XFILLER_74_433 VPWR VGND VPWR VGND sky130_ef_sc_hd__decap_12
XFILLER_75_77 VGND VGND VPWR VPWR sky130_fd_sc_hd__fill_1
XFILLER_19_349 VGND VGND VPWR VPWR sky130_fd_sc_hd__fill_1
XTAP_TAPCELL_ROW_57_631 VGND VPWR sky130_fd_sc_hd__tapvpwrvgnd_1
XFILLER_42_363 VGND VGND VPWR VPWR sky130_fd_sc_hd__fill_1
XTAP_TAPCELL_ROW_12_266 VGND VPWR sky130_fd_sc_hd__tapvpwrvgnd_1
XFILLER_6_253 VGND VGND VPWR VPWR sky130_fd_sc_hd__decap_8
XFILLER_6_297 VGND VGND VPWR VPWR sky130_fd_sc_hd__fill_2
X_2330_ _1907_ net25 net100 VGND VGND VPWR VPWR _0282_ sky130_fd_sc_hd__mux2_1
XFILLER_69_216 VGND VGND VPWR VPWR sky130_fd_sc_hd__decap_3
X_2261_ net19 _1895_ net103 VGND VGND VPWR VPWR _1896_ sky130_fd_sc_hd__mux2_1
X_4000_ clknet_leaf_25_clk _0111_ VGND VGND VPWR VPWR mantisaresult\[5\] sky130_fd_sc_hd__dfxtp_1
X_2192_ _1792_ _1849_ VGND VGND VPWR VPWR _1850_ sky130_fd_sc_hd__nor2_1
XFILLER_37_113 VGND VGND VPWR VPWR sky130_fd_sc_hd__fill_1
XFILLER_65_411 VGND VGND VPWR VPWR sky130_fd_sc_hd__fill_2
XFILLER_77_293 VPWR VGND VPWR VGND sky130_ef_sc_hd__decap_12
XFILLER_37_146 VGND VGND VPWR VPWR sky130_fd_sc_hd__decap_8
XFILLER_18_360 VGND VGND VPWR VPWR sky130_fd_sc_hd__decap_4
XFILLER_25_319 VGND VGND VPWR VPWR sky130_fd_sc_hd__decap_6
XTAP_TAPCELL_ROW_63_678 VGND VPWR sky130_fd_sc_hd__tapvpwrvgnd_1
X_1976_ net45 VGND VGND VPWR VPWR _1671_ sky130_fd_sc_hd__inv_2
X_3715_ net269 _1459_ VGND VGND VPWR VPWR _1540_ sky130_fd_sc_hd__or2_1
X_3646_ _1686_ _1432_ _1457_ mantisaB0\[10\] VGND VGND VPWR VPWR _1476_ sky130_fd_sc_hd__a22oi_1
X_3577_ net126 _0875_ VGND VGND VPWR VPWR _1409_ sky130_fd_sc_hd__or2_1
X_2528_ _0470_ VGND VGND VPWR VPWR _0471_ sky130_fd_sc_hd__inv_2
XFILLER_0_418 VGND VGND VPWR VPWR sky130_fd_sc_hd__fill_2
Xhold26 expmiddlea\[6\] VGND VGND VPWR VPWR net300 sky130_fd_sc_hd__dlygate4sd3_1
Xhold37 expmiddlea\[0\] VGND VGND VPWR VPWR net311 sky130_fd_sc_hd__dlygate4sd3_1
X_2459_ net225 net226 mantisaresult\[36\] mantisaresult\[35\] VGND VGND VPWR VPWR
+ _0402_ sky130_fd_sc_hd__or4b_1
Xhold15 mantisaA0\[10\] VGND VGND VPWR VPWR net289 sky130_fd_sc_hd__dlygate4sd3_1
Xhold48 four_man\[46\] VGND VGND VPWR VPWR net322 sky130_fd_sc_hd__dlygate4sd3_1
Xhold59 four_man\[57\] VGND VGND VPWR VPWR net333 sky130_fd_sc_hd__dlygate4sd3_1
XFILLER_28_157 VGND VGND VPWR VPWR sky130_fd_sc_hd__fill_1
XFILLER_56_455 VGND VGND VPWR VPWR sky130_fd_sc_hd__fill_2
X_4129_ clknet_leaf_9_clk _0236_ VGND VGND VPWR VPWR mantisaBshift\[48\] sky130_fd_sc_hd__dfxtp_1
XTAP_TAPCELL_ROW_54_601 VGND VPWR sky130_fd_sc_hd__tapvpwrvgnd_1
XFILLER_71_447 VGND VGND VPWR VPWR sky130_fd_sc_hd__fill_1
XFILLER_61_57 VGND VGND VPWR VPWR sky130_fd_sc_hd__fill_2
XFILLER_3_223 VGND VGND VPWR VPWR sky130_fd_sc_hd__fill_1
XFILLER_19_102 VGND VGND VPWR VPWR sky130_fd_sc_hd__decap_8
XFILLER_47_400 VGND VGND VPWR VPWR sky130_fd_sc_hd__fill_1
XFILLER_34_138 VGND VGND VPWR VPWR sky130_fd_sc_hd__fill_2
XFILLER_15_352 VGND VGND VPWR VPWR sky130_fd_sc_hd__fill_2
XFILLER_30_322 VGND VGND VPWR VPWR sky130_fd_sc_hd__decap_8
XTAP_TAPCELL_ROW_60_648 VGND VPWR sky130_fd_sc_hd__tapvpwrvgnd_1
X_3500_ _0757_ _0920_ _0939_ _0744_ VGND VGND VPWR VPWR _1339_ sky130_fd_sc_hd__o22a_1
X_3431_ net106 _0842_ _1289_ _1296_ VGND VGND VPWR VPWR _1297_ sky130_fd_sc_hd__a211o_1
X_3362_ _1219_ _1226_ _1234_ net246 _1233_ VGND VGND VPWR VPWR _1235_ sky130_fd_sc_hd__o221a_1
X_2313_ _0273_ net385 net174 VGND VGND VPWR VPWR _0080_ sky130_fd_sc_hd__mux2_1
X_3293_ net246 _1171_ VGND VGND VPWR VPWR _1172_ sky130_fd_sc_hd__nand2_1
X_2244_ _1884_ net287 net175 VGND VGND VPWR VPWR _0054_ sky130_fd_sc_hd__mux2_1
XTAP_TAPCELL_ROW_68_715 VGND VPWR sky130_fd_sc_hd__tapvpwrvgnd_1
X_2175_ net98 VGND VGND VPWR VPWR _1836_ sky130_fd_sc_hd__inv_2
XTAP_TAPCELL_ROW_76_781 VGND VPWR sky130_fd_sc_hd__tapvpwrvgnd_1
XFILLER_33_193 VGND VGND VPWR VPWR sky130_fd_sc_hd__fill_2
XFILLER_21_366 VPWR VGND VPWR VGND sky130_ef_sc_hd__decap_12
X_1959_ net29 VGND VGND VPWR VPWR _1654_ sky130_fd_sc_hd__inv_2
X_3629_ _1456_ _1459_ net269 VGND VGND VPWR VPWR _1460_ sky130_fd_sc_hd__mux2_1
XFILLER_0_237 VPWR VGND VPWR VGND sky130_ef_sc_hd__decap_12
XTAP_TAPCELL_ROW_39_483 VGND VPWR sky130_fd_sc_hd__tapvpwrvgnd_1
XFILLER_72_67 VGND VGND VPWR VPWR sky130_fd_sc_hd__fill_1
XFILLER_12_333 VGND VGND VPWR VPWR sky130_fd_sc_hd__fill_2
XTAP_TAPCELL_ROW_22_350 VGND VPWR sky130_fd_sc_hd__tapvpwrvgnd_1
XFILLER_21_93 VGND VGND VPWR VPWR sky130_fd_sc_hd__decap_3
XFILLER_79_333 VGND VGND VPWR VPWR sky130_fd_sc_hd__decap_3
XFILLER_79_377 VGND VGND VPWR VPWR sky130_fd_sc_hd__decap_4
XFILLER_35_425 VPWR VGND VPWR VGND sky130_ef_sc_hd__decap_12
XFILLER_35_458 VPWR VGND VPWR VGND sky130_ef_sc_hd__decap_12
X_3980_ clknet_leaf_16_clk _0102_ VGND VGND VPWR VPWR four_man\[43\] sky130_fd_sc_hd__dfxtp_1
X_2931_ mantisaBshift\[0\] mantisaresult\[0\] net231 VGND VGND VPWR VPWR _0105_ sky130_fd_sc_hd__mux2_1
Xclkbuf_0_clk clk VGND VGND VPWR VPWR clknet_0_clk sky130_fd_sc_hd__clkbuf_16
X_2862_ _0801_ _0800_ net142 VGND VGND VPWR VPWR _0802_ sky130_fd_sc_hd__mux2_1
X_2793_ _0733_ _0734_ net120 VGND VGND VPWR VPWR _0735_ sky130_fd_sc_hd__mux2_1
X_3414_ net247 _1278_ _1279_ _1280_ _1281_ VGND VGND VPWR VPWR _1282_ sky130_fd_sc_hd__a32o_1
XPHY_EDGE_ROW_15_Right_15 VGND VGND VPWR VPWR sky130_fd_sc_hd__decap_3
X_3345_ _1218_ VGND VGND VPWR VPWR _1219_ sky130_fd_sc_hd__inv_2
X_3276_ _1154_ _1155_ VGND VGND VPWR VPWR _1156_ sky130_fd_sc_hd__and2b_1
X_2227_ net40 net168 VGND VGND VPWR VPWR _1873_ sky130_fd_sc_hd__and2_1
XFILLER_26_27 VGND VGND VPWR VPWR sky130_fd_sc_hd__fill_1
X_2158_ _1651_ net50 VGND VGND VPWR VPWR _1819_ sky130_fd_sc_hd__or2_1
XPHY_EDGE_ROW_24_Right_24 VGND VGND VPWR VPWR sky130_fd_sc_hd__decap_3
X_2089_ net209 net330 VGND VGND VPWR VPWR _0029_ sky130_fd_sc_hd__and2b_1
XFILLER_53_299 VGND VGND VPWR VPWR sky130_fd_sc_hd__decap_8
XFILLER_21_141 VGND VGND VPWR VPWR sky130_fd_sc_hd__decap_8
XFILLER_42_37 VPWR VGND VPWR VGND sky130_ef_sc_hd__decap_12
XFILLER_5_329 VGND VGND VPWR VPWR sky130_fd_sc_hd__decap_6
XPHY_EDGE_ROW_33_Right_33 VGND VGND VPWR VPWR sky130_fd_sc_hd__decap_3
XPHY_EDGE_ROW_42_Right_42 VGND VGND VPWR VPWR sky130_fd_sc_hd__decap_3
XFILLER_17_447 VGND VGND VPWR VPWR sky130_fd_sc_hd__fill_1
XFILLER_44_233 VGND VGND VPWR VPWR sky130_fd_sc_hd__fill_1
XFILLER_16_93 VGND VGND VPWR VPWR sky130_fd_sc_hd__fill_1
XTAP_TAPCELL_ROW_70_732 VGND VPWR sky130_fd_sc_hd__tapvpwrvgnd_1
XFILLER_40_461 VPWR VGND VPWR VGND sky130_ef_sc_hd__decap_12
XPHY_EDGE_ROW_51_Right_51 VGND VGND VPWR VPWR sky130_fd_sc_hd__decap_3
XFILLER_4_351 VGND VGND VPWR VPWR sky130_fd_sc_hd__fill_2
XFILLER_79_141 VPWR VGND VPWR VGND sky130_ef_sc_hd__decap_12
X_3130_ net370 _1026_ VGND VGND VPWR VPWR _1027_ sky130_fd_sc_hd__nand2_1
XFILLER_67_314 VPWR VGND VPWR VGND sky130_ef_sc_hd__decap_12
X_3061_ _0970_ _0971_ mantisaresult\[23\] net233 VGND VGND VPWR VPWR _0130_ sky130_fd_sc_hd__a2bb2o_1
XPHY_EDGE_ROW_60_Right_60 VGND VGND VPWR VPWR sky130_fd_sc_hd__decap_3
XFILLER_75_391 VGND VGND VPWR VPWR sky130_fd_sc_hd__fill_1
X_2012_ _1704_ _1705_ _1706_ VGND VGND VPWR VPWR _1707_ sky130_fd_sc_hd__and3_1
X_3963_ clknet_leaf_7_clk _0086_ VGND VGND VPWR VPWR mantisaB0\[14\] sky130_fd_sc_hd__dfxtp_1
XTAP_TAPCELL_ROW_33_434 VGND VPWR sky130_fd_sc_hd__tapvpwrvgnd_1
XFILLER_35_299 VGND VGND VPWR VPWR sky130_fd_sc_hd__decap_3
X_2914_ _0850_ _0851_ net122 VGND VGND VPWR VPWR _0852_ sky130_fd_sc_hd__mux2_1
X_3894_ clknet_leaf_17_clk _0017_ VGND VGND VPWR VPWR net94 sky130_fd_sc_hd__dfxtp_1
X_2845_ _0778_ _0785_ net123 VGND VGND VPWR VPWR _0786_ sky130_fd_sc_hd__mux2_1
Xhold101 expadd\[0\] VGND VGND VPWR VPWR net375 sky130_fd_sc_hd__dlygate4sd3_1
X_2776_ _0715_ _0717_ net117 VGND VGND VPWR VPWR _0718_ sky130_fd_sc_hd__mux2_1
Xhold112 expadd\[4\] VGND VGND VPWR VPWR net386 sky130_fd_sc_hd__dlygate4sd3_1
X_3328_ _1201_ _1203_ net248 VGND VGND VPWR VPWR _1204_ sky130_fd_sc_hd__o21ai_1
XFILLER_37_26 VGND VGND VPWR VPWR sky130_fd_sc_hd__decap_6
X_3259_ _1135_ _1139_ net235 VGND VGND VPWR VPWR _1141_ sky130_fd_sc_hd__a21oi_1
XFILLER_26_266 VGND VGND VPWR VPWR sky130_fd_sc_hd__decap_8
XFILLER_41_225 VPWR VGND VPWR VGND sky130_ef_sc_hd__decap_12
XFILLER_5_137 VPWR VGND VPWR VGND sky130_ef_sc_hd__decap_12
XFILLER_78_66 VPWR VGND VPWR VGND sky130_ef_sc_hd__decap_12
XFILLER_64_317 VGND VGND VPWR VPWR sky130_fd_sc_hd__decap_3
XFILLER_17_222 VGND VGND VPWR VPWR sky130_fd_sc_hd__fill_2
XTAP_TAPCELL_ROW_47_548 VGND VPWR sky130_fd_sc_hd__tapvpwrvgnd_1
XFILLER_17_277 VGND VGND VPWR VPWR sky130_fd_sc_hd__decap_3
XFILLER_32_225 VPWR VGND VPWR VGND sky130_ef_sc_hd__decap_12
XFILLER_13_461 VPWR VGND VPWR VGND sky130_ef_sc_hd__decap_12
XFILLER_9_421 VPWR VGND VPWR VGND sky130_ef_sc_hd__decap_12
XTAP_TAPCELL_ROW_30_415 VGND VPWR sky130_fd_sc_hd__tapvpwrvgnd_1
X_2630_ _0572_ VGND VGND VPWR VPWR _0573_ sky130_fd_sc_hd__inv_2
XFILLER_71_6 VGND VGND VPWR VPWR sky130_fd_sc_hd__fill_1
X_2561_ _0315_ _0431_ _0434_ _0497_ VGND VGND VPWR VPWR _0504_ sky130_fd_sc_hd__or4_1
X_2492_ mantisaresult\[8\] mantisaresult\[9\] _0433_ _0434_ VGND VGND VPWR VPWR _0435_
+ sky130_fd_sc_hd__or4_4
XFILLER_4_41 VPWR VGND VPWR VGND sky130_ef_sc_hd__decap_12
XFILLER_4_85 VPWR VGND VPWR VGND sky130_ef_sc_hd__decap_12
X_4162_ clknet_leaf_8_clk _0269_ VGND VGND VPWR VPWR mantisaBshift\[51\] sky130_fd_sc_hd__dfxtp_1
X_4093_ clknet_leaf_28_clk net278 VGND VGND VPWR VPWR signA3 sky130_fd_sc_hd__dfxtp_1
X_3113_ net122 net129 _0755_ _1011_ VGND VGND VPWR VPWR _1012_ sky130_fd_sc_hd__a31oi_1
X_3044_ net238 _0958_ mantisaBshift\[19\] VGND VGND VPWR VPWR _0959_ sky130_fd_sc_hd__a21oi_1
XFILLER_67_177 VGND VGND VPWR VPWR sky130_fd_sc_hd__fill_1
XFILLER_70_309 VPWR VGND VPWR VGND sky130_ef_sc_hd__decap_12
XFILLER_23_225 VPWR VGND VPWR VGND sky130_ef_sc_hd__decap_12
X_3946_ clknet_leaf_6_clk _0069_ VGND VGND VPWR VPWR mantisaA0\[20\] sky130_fd_sc_hd__dfxtp_1
X_3877_ clknet_leaf_6_clk net313 VGND VGND VPWR VPWR mantisaAshift\[62\] sky130_fd_sc_hd__dfxtp_1
X_2828_ _0636_ _0694_ net136 VGND VGND VPWR VPWR _0769_ sky130_fd_sc_hd__mux2_1
X_2759_ mantisaresult\[63\] net228 mantisaresult\[39\] _0701_ net217 VGND VGND VPWR
+ VPWR _0702_ sky130_fd_sc_hd__a221o_1
XFILLER_73_169 VGND VGND VPWR VPWR sky130_fd_sc_hd__decap_6
XTAP_TAPCELL_ROW_52_584 VGND VPWR sky130_fd_sc_hd__tapvpwrvgnd_1
XFILLER_22_291 VPWR VGND VPWR VGND sky130_ef_sc_hd__decap_12
XTAP_TAPCELL_ROW_9_240 VGND VPWR sky130_fd_sc_hd__tapvpwrvgnd_1
XFILLER_37_306 VGND VGND VPWR VPWR sky130_fd_sc_hd__fill_2
XFILLER_49_188 VGND VGND VPWR VPWR sky130_fd_sc_hd__decap_4
XFILLER_64_158 VGND VGND VPWR VPWR sky130_fd_sc_hd__fill_1
XFILLER_52_309 VGND VGND VPWR VPWR sky130_fd_sc_hd__fill_2
X_3800_ _1606_ VGND VGND VPWR VPWR _0234_ sky130_fd_sc_hd__inv_2
X_1992_ net214 VGND VGND VPWR VPWR _1687_ sky130_fd_sc_hd__inv_2
X_3731_ _1553_ VGND VGND VPWR VPWR _1554_ sky130_fd_sc_hd__inv_2
X_3662_ net274 net251 mantisaB0\[21\] VGND VGND VPWR VPWR _1492_ sky130_fd_sc_hd__or3b_1
Xclkload10 clknet_leaf_3_clk VGND VGND VPWR VPWR clkload10/Y sky130_fd_sc_hd__inv_16
Xclkload21 clknet_leaf_20_clk VGND VGND VPWR VPWR clkload21/X sky130_fd_sc_hd__clkbuf_4
X_2613_ _0373_ _0532_ _0508_ _0452_ _0376_ VGND VGND VPWR VPWR _0556_ sky130_fd_sc_hd__o2111a_1
X_3593_ net269 net272 _1422_ VGND VGND VPWR VPWR _1424_ sky130_fd_sc_hd__and3_1
X_2544_ mantisaresult\[30\] mantisaresult\[29\] _0485_ VGND VGND VPWR VPWR _0487_
+ sky130_fd_sc_hd__or3_1
X_2475_ mantisaresult\[25\] _0377_ mantisaresult\[24\] mantisaresult\[23\] VGND VGND
+ VPWR VPWR _0418_ sky130_fd_sc_hd__or4b_1
X_4145_ clknet_leaf_2_clk _0252_ VGND VGND VPWR VPWR mantisaBshift\[31\] sky130_fd_sc_hd__dfxtp_1
X_4076_ clknet_leaf_20_clk _0185_ VGND VGND VPWR VPWR expadd\[0\] sky130_fd_sc_hd__dfxtp_1
X_3027_ mantisaresult\[14\] _0946_ net201 VGND VGND VPWR VPWR _0121_ sky130_fd_sc_hd__mux2_1
XFILLER_55_169 VGND VGND VPWR VPWR sky130_fd_sc_hd__decap_6
XFILLER_51_331 VGND VGND VPWR VPWR sky130_fd_sc_hd__decap_4
XTAP_TAPCELL_ROW_66_698 VGND VPWR sky130_fd_sc_hd__tapvpwrvgnd_1
Xclkload4 clknet_leaf_1_clk VGND VGND VPWR VPWR clkload4/Y sky130_fd_sc_hd__inv_12
X_3929_ clknet_leaf_6_clk _0052_ VGND VGND VPWR VPWR mantisaA0\[3\] sky130_fd_sc_hd__dfxtp_1
XFILLER_3_405 VPWR VGND VPWR VGND sky130_ef_sc_hd__decap_12
XFILLER_3_449 VPWR VGND VPWR VGND sky130_ef_sc_hd__decap_12
XFILLER_59_24 VGND VGND VPWR VPWR sky130_fd_sc_hd__fill_1
XFILLER_59_57 VGND VGND VPWR VPWR sky130_fd_sc_hd__decap_3
Xfanout230 net232 VGND VGND VPWR VPWR net230 sky130_fd_sc_hd__buf_2
XTAP_TAPCELL_ROW_6_221 VGND VPWR sky130_fd_sc_hd__tapvpwrvgnd_1
Xfanout241 net243 VGND VGND VPWR VPWR net241 sky130_fd_sc_hd__buf_2
XFILLER_59_420 VPWR VGND VPWR VGND sky130_ef_sc_hd__decap_12
Xfanout274 expmiddle\[0\] VGND VGND VPWR VPWR net274 sky130_fd_sc_hd__buf_2
Xfanout252 net254 VGND VGND VPWR VPWR net252 sky130_fd_sc_hd__buf_2
Xfanout263 net264 VGND VGND VPWR VPWR net263 sky130_fd_sc_hd__buf_2
XFILLER_74_401 VPWR VGND VPWR VGND sky130_ef_sc_hd__decap_12
XFILLER_74_445 VPWR VGND VPWR VGND sky130_ef_sc_hd__decap_12
XFILLER_34_309 VGND VGND VPWR VPWR sky130_fd_sc_hd__fill_1
XFILLER_42_331 VGND VGND VPWR VPWR sky130_fd_sc_hd__decap_6
XTAP_TAPCELL_ROW_12_267 VGND VPWR sky130_fd_sc_hd__tapvpwrvgnd_1
XFILLER_6_221 VPWR VGND VPWR VGND sky130_ef_sc_hd__decap_12
XFILLER_69_228 VPWR VGND VPWR VGND sky130_ef_sc_hd__decap_12
X_2260_ net42 net169 VGND VGND VPWR VPWR _1895_ sky130_fd_sc_hd__and2_1
XFILLER_77_261 VPWR VGND VPWR VGND sky130_ef_sc_hd__decap_12
X_2191_ _1775_ _1788_ _1791_ VGND VGND VPWR VPWR _1849_ sky130_fd_sc_hd__and3_1
XFILLER_52_139 VGND VGND VPWR VPWR sky130_fd_sc_hd__fill_1
XTAP_TAPCELL_ROW_63_679 VGND VPWR sky130_fd_sc_hd__tapvpwrvgnd_1
X_1975_ net46 VGND VGND VPWR VPWR _1670_ sky130_fd_sc_hd__inv_2
X_3714_ _1435_ _1444_ _1450_ _1456_ net268 net260 VGND VGND VPWR VPWR _1539_ sky130_fd_sc_hd__mux4_1
X_3645_ net262 _1474_ _1464_ VGND VGND VPWR VPWR _1475_ sky130_fd_sc_hd__a21oi_1
X_3576_ net332 net207 _1408_ VGND VGND VPWR VPWR _0208_ sky130_fd_sc_hd__o21a_1
X_2527_ _0427_ _0460_ VGND VGND VPWR VPWR _0470_ sky130_fd_sc_hd__nand2_1
X_2458_ mantisaresult\[33\] _0320_ _0330_ VGND VGND VPWR VPWR _0401_ sky130_fd_sc_hd__and3_1
Xhold38 expmiddleb\[1\] VGND VGND VPWR VPWR net312 sky130_fd_sc_hd__dlygate4sd3_1
Xhold27 mantisaA0\[1\] VGND VGND VPWR VPWR net301 sky130_fd_sc_hd__dlygate4sd3_1
Xhold16 mantisaA0\[12\] VGND VGND VPWR VPWR net290 sky130_fd_sc_hd__dlygate4sd3_1
X_2389_ net229 mantisaresult\[33\] _0319_ VGND VGND VPWR VPWR _0332_ sky130_fd_sc_hd__or3_2
Xhold49 four_man\[61\] VGND VGND VPWR VPWR net323 sky130_fd_sc_hd__dlygate4sd3_1
X_4128_ clknet_leaf_3_clk _0235_ VGND VGND VPWR VPWR mantisaBshift\[33\] sky130_fd_sc_hd__dfxtp_1
XFILLER_45_15 VGND VGND VPWR VPWR sky130_fd_sc_hd__fill_2
XTAP_TAPCELL_ROW_54_602 VGND VPWR sky130_fd_sc_hd__tapvpwrvgnd_1
X_4059_ clknet_leaf_14_clk _0170_ VGND VGND VPWR VPWR mantisaresult\[59\] sky130_fd_sc_hd__dfxtp_1
XFILLER_61_47 VGND VGND VPWR VPWR sky130_fd_sc_hd__decap_8
XFILLER_10_51 VGND VGND VPWR VPWR sky130_fd_sc_hd__decap_3
XFILLER_19_169 VGND VGND VPWR VPWR sky130_fd_sc_hd__fill_1
XTAP_TAPCELL_ROW_17_304 VGND VPWR sky130_fd_sc_hd__tapvpwrvgnd_1
XFILLER_27_191 VGND VGND VPWR VPWR sky130_fd_sc_hd__decap_4
XTAP_TAPCELL_ROW_25_370 VGND VPWR sky130_fd_sc_hd__tapvpwrvgnd_1
XTAP_TAPCELL_ROW_60_649 VGND VPWR sky130_fd_sc_hd__tapvpwrvgnd_1
X_3430_ _1295_ _0926_ _0830_ _0756_ VGND VGND VPWR VPWR _1296_ sky130_fd_sc_hd__a2bb2o_1
X_3361_ _1216_ _1227_ _1217_ VGND VGND VPWR VPWR _1234_ sky130_fd_sc_hd__o21a_1
XFILLER_32_3 VGND VGND VPWR VPWR sky130_fd_sc_hd__fill_1
X_2312_ _1889_ net38 net104 VGND VGND VPWR VPWR _0273_ sky130_fd_sc_hd__mux2_1
X_3292_ _1168_ _1170_ VGND VGND VPWR VPWR _1171_ sky130_fd_sc_hd__and2_1
X_2243_ net35 _1883_ net102 VGND VGND VPWR VPWR _1884_ sky130_fd_sc_hd__mux2_1
XTAP_TAPCELL_ROW_68_716 VGND VPWR sky130_fd_sc_hd__tapvpwrvgnd_1
X_2174_ _1830_ _1834_ _1795_ VGND VGND VPWR VPWR _1835_ sky130_fd_sc_hd__o21ba_1
XTAP_TAPCELL_ROW_76_782 VGND VPWR sky130_fd_sc_hd__tapvpwrvgnd_1
XFILLER_65_286 VPWR VGND VPWR VGND sky130_ef_sc_hd__decap_12
XFILLER_33_161 VGND VGND VPWR VPWR sky130_fd_sc_hd__fill_1
XFILLER_40_109 VPWR VGND VPWR VGND sky130_ef_sc_hd__decap_12
XFILLER_21_378 VGND VGND VPWR VPWR sky130_fd_sc_hd__fill_2
X_1958_ net30 VGND VGND VPWR VPWR _1653_ sky130_fd_sc_hd__inv_2
X_3628_ net272 _1458_ VGND VGND VPWR VPWR _1459_ sky130_fd_sc_hd__or2_1
X_3559_ net149 _1295_ VGND VGND VPWR VPWR _1393_ sky130_fd_sc_hd__nand2_1
XFILLER_0_249 VGND VGND VPWR VPWR sky130_fd_sc_hd__decap_3
XFILLER_29_401 VPWR VGND VPWR VGND sky130_ef_sc_hd__decap_12
XFILLER_16_139 VGND VGND VPWR VPWR sky130_fd_sc_hd__fill_1
XTAP_TAPCELL_ROW_39_484 VGND VPWR sky130_fd_sc_hd__tapvpwrvgnd_1
XFILLER_12_323 VGND VGND VPWR VPWR sky130_fd_sc_hd__fill_2
XTAP_TAPCELL_ROW_22_351 VGND VPWR sky130_fd_sc_hd__tapvpwrvgnd_1
XFILLER_47_242 VGND VGND VPWR VPWR sky130_fd_sc_hd__decap_4
XFILLER_35_437 VGND VGND VPWR VPWR sky130_fd_sc_hd__decap_6
XFILLER_62_245 VGND VGND VPWR VPWR sky130_fd_sc_hd__decap_6
XTAP_TAPCELL_ROW_73_752 VGND VPWR sky130_fd_sc_hd__tapvpwrvgnd_1
X_2930_ net365 net63 net178 VGND VGND VPWR VPWR _0104_ sky130_fd_sc_hd__mux2_1
X_2861_ _0703_ _0750_ net136 VGND VGND VPWR VPWR _0801_ sky130_fd_sc_hd__mux2_1
X_2792_ mantisaresult\[36\] net110 _0654_ net135 VGND VGND VPWR VPWR _0734_ sky130_fd_sc_hd__a22o_1
X_3413_ mantisaAshift\[61\] mantisaBshift\[61\] net247 VGND VGND VPWR VPWR _1281_
+ sky130_fd_sc_hd__o21ba_1
X_3344_ _1216_ _1217_ VGND VGND VPWR VPWR _1218_ sky130_fd_sc_hd__nand2b_1
X_3275_ mantisaAshift\[51\] mantisaBshift\[51\] VGND VGND VPWR VPWR _1155_ sky130_fd_sc_hd__or2_1
X_2226_ _1695_ _1698_ _1870_ _1871_ VGND VGND VPWR VPWR _1872_ sky130_fd_sc_hd__or4_1
XFILLER_38_242 VGND VGND VPWR VPWR sky130_fd_sc_hd__decap_4
XFILLER_38_253 VGND VGND VPWR VPWR sky130_fd_sc_hd__decap_3
X_2157_ _1651_ net50 net49 _1652_ VGND VGND VPWR VPWR _1818_ sky130_fd_sc_hd__a22o_1
XFILLER_26_448 VGND VGND VPWR VPWR sky130_fd_sc_hd__fill_2
X_2088_ net210 net333 VGND VGND VPWR VPWR _0028_ sky130_fd_sc_hd__and2b_1
XFILLER_42_49 VGND VGND VPWR VPWR sky130_fd_sc_hd__decap_8
XPHY_EDGE_ROW_39_Left_119 VGND VGND VPWR VPWR sky130_fd_sc_hd__decap_3
XFILLER_29_242 VGND VGND VPWR VPWR sky130_fd_sc_hd__fill_2
XPHY_EDGE_ROW_48_Left_128 VGND VGND VPWR VPWR sky130_fd_sc_hd__decap_3
XFILLER_16_61 VGND VGND VPWR VPWR sky130_fd_sc_hd__decap_4
XFILLER_32_407 VGND VGND VPWR VPWR sky130_fd_sc_hd__decap_6
XFILLER_32_429 VPWR VGND VPWR VGND sky130_ef_sc_hd__decap_12
XFILLER_16_83 VGND VGND VPWR VPWR sky130_fd_sc_hd__fill_1
XTAP_TAPCELL_ROW_70_733 VGND VPWR sky130_fd_sc_hd__tapvpwrvgnd_1
XFILLER_12_197 VPWR VGND VPWR VGND sky130_ef_sc_hd__decap_12
XFILLER_32_71 VGND VGND VPWR VPWR sky130_fd_sc_hd__fill_1
XPHY_EDGE_ROW_57_Left_137 VGND VGND VPWR VPWR sky130_fd_sc_hd__decap_3
XFILLER_79_175 VGND VGND VPWR VPWR sky130_fd_sc_hd__fill_1
XFILLER_79_153 VPWR VGND VPWR VGND sky130_ef_sc_hd__decap_12
XFILLER_79_197 VPWR VGND VPWR VGND sky130_ef_sc_hd__decap_12
X_3060_ net241 mantisaBshift\[23\] _0969_ net233 VGND VGND VPWR VPWR _0971_ sky130_fd_sc_hd__a31o_1
XPHY_EDGE_ROW_66_Left_146 VGND VGND VPWR VPWR sky130_fd_sc_hd__decap_3
XFILLER_67_326 VGND VGND VPWR VPWR sky130_fd_sc_hd__fill_2
X_2011_ net11 net10 net13 net12 VGND VGND VPWR VPWR _1706_ sky130_fd_sc_hd__and4_1
XFILLER_23_407 VGND VGND VPWR VPWR sky130_fd_sc_hd__fill_2
XFILLER_35_267 VGND VGND VPWR VPWR sky130_fd_sc_hd__decap_8
XTAP_TAPCELL_ROW_33_435 VGND VPWR sky130_fd_sc_hd__tapvpwrvgnd_1
X_3962_ clknet_leaf_7_clk _0085_ VGND VGND VPWR VPWR mantisaB0\[13\] sky130_fd_sc_hd__dfxtp_1
X_2913_ _0706_ _0752_ net141 VGND VGND VPWR VPWR _0851_ sky130_fd_sc_hd__mux2_1
XFILLER_31_462 VGND VGND VPWR VPWR sky130_fd_sc_hd__decap_8
X_3893_ clknet_leaf_17_clk _0016_ VGND VGND VPWR VPWR net93 sky130_fd_sc_hd__dfxtp_1
XPHY_EDGE_ROW_75_Left_155 VGND VGND VPWR VPWR sky130_fd_sc_hd__decap_3
X_2844_ net144 _0784_ _0780_ VGND VGND VPWR VPWR _0785_ sky130_fd_sc_hd__o21a_1
X_2775_ _0716_ VGND VGND VPWR VPWR _0717_ sky130_fd_sc_hd__inv_2
Xhold113 mantisaresult\[22\] VGND VGND VPWR VPWR net387 sky130_fd_sc_hd__dlygate4sd3_1
Xhold102 mantisaB0\[4\] VGND VGND VPWR VPWR net376 sky130_fd_sc_hd__dlygate4sd3_1
X_3327_ mantisaAshift\[52\] _1682_ _1178_ _1202_ VGND VGND VPWR VPWR _1203_ sky130_fd_sc_hd__a31o_1
XFILLER_37_16 VGND VGND VPWR VPWR sky130_fd_sc_hd__fill_1
X_3258_ _1135_ _1139_ VGND VGND VPWR VPWR _1140_ sky130_fd_sc_hd__or2_1
X_2209_ net1 net9 net98 VGND VGND VPWR VPWR _1863_ sky130_fd_sc_hd__mux2_1
X_3189_ _0974_ _1076_ net118 VGND VGND VPWR VPWR _1077_ sky130_fd_sc_hd__mux2_1
XFILLER_26_234 VGND VGND VPWR VPWR sky130_fd_sc_hd__fill_1
XFILLER_14_418 VGND VGND VPWR VPWR sky130_fd_sc_hd__fill_2
XFILLER_5_105 VGND VGND VPWR VPWR sky130_fd_sc_hd__decap_6
XFILLER_5_149 VPWR VGND VPWR VGND sky130_ef_sc_hd__decap_12
XFILLER_78_78 VGND VGND VPWR VPWR sky130_fd_sc_hd__decap_6
XFILLER_1_355 VGND VGND VPWR VPWR sky130_fd_sc_hd__decap_8
XFILLER_76_123 VPWR VGND VPWR VGND sky130_ef_sc_hd__decap_12
XFILLER_49_337 VGND VGND VPWR VPWR sky130_fd_sc_hd__decap_4
XFILLER_76_145 VGND VGND VPWR VPWR sky130_fd_sc_hd__decap_4
XTAP_TAPCELL_ROW_47_549 VGND VPWR sky130_fd_sc_hd__tapvpwrvgnd_1
XFILLER_17_256 VGND VGND VPWR VPWR sky130_fd_sc_hd__fill_1
Xclkbuf_2_0__f_clk clknet_0_clk VGND VGND VPWR VPWR clknet_2_0__leaf_clk sky130_fd_sc_hd__clkbuf_16
XFILLER_32_204 VGND VGND VPWR VPWR sky130_fd_sc_hd__decap_4
XFILLER_32_237 VPWR VGND VPWR VGND sky130_ef_sc_hd__decap_12
XFILLER_9_433 VPWR VGND VPWR VGND sky130_ef_sc_hd__decap_12
XFILLER_64_6 VGND VGND VPWR VPWR sky130_fd_sc_hd__fill_1
X_2560_ _0366_ _0495_ _0494_ VGND VGND VPWR VPWR _0503_ sky130_fd_sc_hd__a21oi_1
X_2491_ mantisaresult\[15\] mantisaresult\[14\] VGND VGND VPWR VPWR _0434_ sky130_fd_sc_hd__or2_1
X_4161_ clknet_leaf_10_clk _0268_ VGND VGND VPWR VPWR mantisaBshift\[52\] sky130_fd_sc_hd__dfxtp_1
XFILLER_4_53 VPWR VGND VPWR VGND sky130_ef_sc_hd__decap_12
XFILLER_4_97 VPWR VGND VPWR VGND sky130_ef_sc_hd__decap_12
X_4092_ clknet_leaf_26_clk _0201_ VGND VGND VPWR VPWR expmiddlec\[7\] sky130_fd_sc_hd__dfxtp_1
X_3112_ net125 _1010_ net151 VGND VGND VPWR VPWR _1011_ sky130_fd_sc_hd__a21o_1
X_3043_ mantisaBshift\[18\] _0950_ _0955_ VGND VGND VPWR VPWR _0958_ sky130_fd_sc_hd__or3_1
XFILLER_55_318 VGND VGND VPWR VPWR sky130_fd_sc_hd__decap_8
XFILLER_23_237 VGND VGND VPWR VPWR sky130_fd_sc_hd__decap_6
X_3945_ clknet_leaf_6_clk _0068_ VGND VGND VPWR VPWR mantisaA0\[19\] sky130_fd_sc_hd__dfxtp_1
XFILLER_31_281 VGND VGND VPWR VPWR sky130_fd_sc_hd__decap_8
X_3876_ clknet_leaf_6_clk net310 VGND VGND VPWR VPWR mantisaAshift\[61\] sky130_fd_sc_hd__dfxtp_1
X_2827_ _0688_ _0691_ net116 VGND VGND VPWR VPWR _0768_ sky130_fd_sc_hd__mux2_1
X_2758_ net199 net160 VGND VGND VPWR VPWR _0701_ sky130_fd_sc_hd__and2_1
X_2689_ net150 net128 VGND VGND VPWR VPWR _0632_ sky130_fd_sc_hd__nor2_2
XFILLER_46_307 VGND VGND VPWR VPWR sky130_fd_sc_hd__fill_1
XFILLER_58_145 VGND VGND VPWR VPWR sky130_fd_sc_hd__fill_1
XFILLER_54_351 VGND VGND VPWR VPWR sky130_fd_sc_hd__decap_8
XFILLER_22_270 VGND VGND VPWR VPWR sky130_fd_sc_hd__fill_1
XTAP_TAPCELL_ROW_52_585 VGND VPWR sky130_fd_sc_hd__tapvpwrvgnd_1
XFILLER_13_51 VGND VGND VPWR VPWR sky130_fd_sc_hd__decap_4
XFILLER_10_421 VPWR VGND VPWR VGND sky130_ef_sc_hd__decap_12
XTAP_TAPCELL_ROW_9_241 VGND VPWR sky130_fd_sc_hd__tapvpwrvgnd_1
XFILLER_29_9 VGND VGND VPWR VPWR sky130_fd_sc_hd__decap_6
XFILLER_64_104 VPWR VGND VPWR VGND sky130_ef_sc_hd__decap_12
X_3730_ net268 _1506_ _1552_ VGND VGND VPWR VPWR _1553_ sky130_fd_sc_hd__a21oi_1
X_1991_ net274 VGND VGND VPWR VPWR _1686_ sky130_fd_sc_hd__inv_2
XFILLER_13_281 VGND VGND VPWR VPWR sky130_fd_sc_hd__decap_6
X_3661_ mantisaA0\[23\] net193 VGND VGND VPWR VPWR _1491_ sky130_fd_sc_hd__nand2_1
X_2612_ _0544_ _0554_ VGND VGND VPWR VPWR _0555_ sky130_fd_sc_hd__or2_1
Xclkload22 clknet_leaf_21_clk VGND VGND VPWR VPWR clkload22/X sky130_fd_sc_hd__clkbuf_8
X_3592_ net272 _1422_ VGND VGND VPWR VPWR _1423_ sky130_fd_sc_hd__and2_1
Xclkload11 clknet_leaf_4_clk VGND VGND VPWR VPWR clkload11/Y sky130_fd_sc_hd__inv_16
X_2543_ _0479_ _0482_ _0484_ VGND VGND VPWR VPWR _0486_ sky130_fd_sc_hd__or3_1
X_2474_ _0371_ _0372_ _0416_ VGND VGND VPWR VPWR _0417_ sky130_fd_sc_hd__or3_1
X_4144_ clknet_leaf_3_clk _0251_ VGND VGND VPWR VPWR mantisaBshift\[32\] sky130_fd_sc_hd__dfxtp_1
XFILLER_18_29 VGND VGND VPWR VPWR sky130_fd_sc_hd__decap_4
XFILLER_28_307 VGND VGND VPWR VPWR sky130_fd_sc_hd__fill_1
X_4075_ clknet_leaf_16_clk _0184_ VGND VGND VPWR VPWR four_man\[52\] sky130_fd_sc_hd__dfxtp_1
X_3026_ mantisaBshift\[14\] _0945_ VGND VGND VPWR VPWR _0946_ sky130_fd_sc_hd__xnor2_1
XTAP_TAPCELL_ROW_66_699 VGND VPWR sky130_fd_sc_hd__tapvpwrvgnd_1
XFILLER_51_354 VGND VGND VPWR VPWR sky130_fd_sc_hd__decap_6
XFILLER_63_192 VGND VGND VPWR VPWR sky130_fd_sc_hd__decap_3
Xclkload5 clknet_leaf_24_clk VGND VGND VPWR VPWR clkload5/Y sky130_fd_sc_hd__inv_6
X_3928_ clknet_leaf_6_clk _0051_ VGND VGND VPWR VPWR mantisaA0\[2\] sky130_fd_sc_hd__dfxtp_1
XFILLER_50_27 VGND VGND VPWR VPWR sky130_fd_sc_hd__fill_1
XFILLER_50_38 VGND VGND VPWR VPWR sky130_fd_sc_hd__decap_4
X_3859_ clknet_leaf_6_clk net287 VGND VGND VPWR VPWR mantisaAshift\[44\] sky130_fd_sc_hd__dfxtp_1
XFILLER_3_417 VPWR VGND VPWR VGND sky130_ef_sc_hd__decap_12
XTAP_TAPCELL_ROW_6_222 VGND VPWR sky130_fd_sc_hd__tapvpwrvgnd_1
Xfanout231 net232 VGND VGND VPWR VPWR net231 sky130_fd_sc_hd__buf_2
Xfanout220 mantisaresult\[48\] VGND VGND VPWR VPWR net220 sky130_fd_sc_hd__clkbuf_4
Xfanout264 net265 VGND VGND VPWR VPWR net264 sky130_fd_sc_hd__dlymetal6s2s_1
Xfanout253 net254 VGND VGND VPWR VPWR net253 sky130_fd_sc_hd__dlymetal6s2s_1
Xfanout242 net243 VGND VGND VPWR VPWR net242 sky130_fd_sc_hd__buf_2
XFILLER_74_413 VGND VGND VPWR VPWR sky130_fd_sc_hd__decap_6
XFILLER_75_57 VGND VGND VPWR VPWR sky130_fd_sc_hd__decap_6
XFILLER_46_137 VGND VGND VPWR VPWR sky130_fd_sc_hd__decap_3
XFILLER_74_457 VPWR VGND VPWR VGND sky130_ef_sc_hd__decap_12
XFILLER_27_351 VGND VGND VPWR VPWR sky130_fd_sc_hd__fill_1
XFILLER_42_321 VGND VGND VPWR VPWR sky130_fd_sc_hd__fill_1
XFILLER_61_118 VGND VGND VPWR VPWR sky130_fd_sc_hd__fill_1
XFILLER_54_192 VGND VGND VPWR VPWR sky130_fd_sc_hd__decap_4
XFILLER_24_50 VGND VGND VPWR VPWR sky130_fd_sc_hd__fill_1
XFILLER_42_365 VPWR VGND VPWR VGND sky130_ef_sc_hd__decap_12
XTAP_TAPCELL_ROW_12_268 VGND VPWR sky130_fd_sc_hd__tapvpwrvgnd_1
XFILLER_6_233 VPWR VGND VPWR VGND sky130_ef_sc_hd__decap_12
XFILLER_40_93 VGND VGND VPWR VPWR sky130_fd_sc_hd__decap_3
X_2190_ _1788_ _1795_ VGND VGND VPWR VPWR _1848_ sky130_fd_sc_hd__nand2_1
XFILLER_27_6 VPWR VGND VPWR VGND sky130_ef_sc_hd__decap_12
XFILLER_77_273 VGND VGND VPWR VPWR sky130_fd_sc_hd__decap_6
XFILLER_65_446 VGND VGND VPWR VPWR sky130_fd_sc_hd__fill_2
XFILLER_18_351 VGND VGND VPWR VPWR sky130_fd_sc_hd__fill_1
X_1974_ net43 VGND VGND VPWR VPWR _1669_ sky130_fd_sc_hd__inv_2
X_3713_ _1450_ _1456_ net269 VGND VGND VPWR VPWR _1538_ sky130_fd_sc_hd__mux2_1
X_3644_ _1473_ VGND VGND VPWR VPWR _1474_ sky130_fd_sc_hd__inv_2
X_3575_ mantisaresult\[63\] mantisaresult\[61\] net158 _1406_ _1407_ VGND VGND VPWR
+ VPWR _1408_ sky130_fd_sc_hd__a221o_1
X_2526_ _0457_ _0468_ _0466_ _0462_ VGND VGND VPWR VPWR _0469_ sky130_fd_sc_hd__or4b_1
X_2457_ net229 _0339_ _0347_ _0399_ VGND VGND VPWR VPWR _0400_ sky130_fd_sc_hd__a31o_1
Xhold28 expmiddlea\[2\] VGND VGND VPWR VPWR net302 sky130_fd_sc_hd__dlygate4sd3_1
Xhold17 mantisaA0\[4\] VGND VGND VPWR VPWR net291 sky130_fd_sc_hd__dlygate4sd3_1
Xhold39 mantisaA0\[23\] VGND VGND VPWR VPWR net313 sky130_fd_sc_hd__dlygate4sd3_1
X_2388_ net188 _0310_ _0327_ _0329_ VGND VGND VPWR VPWR _0331_ sky130_fd_sc_hd__or4_2
XFILLER_68_273 VGND VGND VPWR VPWR sky130_fd_sc_hd__fill_1
X_4127_ clknet_leaf_1_clk _0234_ VGND VGND VPWR VPWR mantisaBshift\[18\] sky130_fd_sc_hd__dfxtp_1
XTAP_TAPCELL_ROW_54_603 VGND VPWR sky130_fd_sc_hd__tapvpwrvgnd_1
X_4058_ clknet_leaf_14_clk _0169_ VGND VGND VPWR VPWR mantisaresult\[58\] sky130_fd_sc_hd__dfxtp_2
XFILLER_71_405 VPWR VGND VPWR VGND sky130_ef_sc_hd__decap_12
X_3009_ _0812_ net146 VGND VGND VPWR VPWR _0930_ sky130_fd_sc_hd__nand2b_1
XFILLER_71_449 VPWR VGND VPWR VGND sky130_ef_sc_hd__decap_12
XFILLER_24_365 VGND VGND VPWR VPWR sky130_fd_sc_hd__decap_3
XFILLER_51_162 VGND VGND VPWR VPWR sky130_fd_sc_hd__fill_1
XFILLER_3_225 VPWR VGND VPWR VGND sky130_ef_sc_hd__decap_12
XFILLER_10_85 VPWR VGND VPWR VGND sky130_ef_sc_hd__decap_12
XFILLER_59_295 VPWR VGND VPWR VGND sky130_ef_sc_hd__decap_12
XFILLER_74_221 VPWR VGND VPWR VGND sky130_ef_sc_hd__decap_12
XFILLER_19_159 VGND VGND VPWR VPWR sky130_fd_sc_hd__decap_8
XTAP_TAPCELL_ROW_17_305 VGND VPWR sky130_fd_sc_hd__tapvpwrvgnd_1
XTAP_TAPCELL_ROW_25_371 VGND VPWR sky130_fd_sc_hd__tapvpwrvgnd_1
XFILLER_30_346 VPWR VGND VPWR VGND sky130_ef_sc_hd__decap_12
XFILLER_51_70 VPWR VGND VPWR VGND sky130_ef_sc_hd__decap_12
X_3360_ net248 mantisaAshift\[56\] _1683_ VGND VGND VPWR VPWR _1233_ sky130_fd_sc_hd__nand3_1
X_2311_ _1926_ net360 net172 VGND VGND VPWR VPWR _0079_ sky130_fd_sc_hd__mux2_1
X_3291_ _1127_ _1146_ _1169_ VGND VGND VPWR VPWR _1170_ sky130_fd_sc_hd__a21o_1
X_2242_ net58 net169 VGND VGND VPWR VPWR _1883_ sky130_fd_sc_hd__and2_1
XTAP_TAPCELL_ROW_68_717 VGND VPWR sky130_fd_sc_hd__tapvpwrvgnd_1
X_2173_ _1770_ _1788_ _1833_ _1832_ VGND VGND VPWR VPWR _1834_ sky130_fd_sc_hd__or4b_1
XTAP_TAPCELL_ROW_76_783 VGND VPWR sky130_fd_sc_hd__tapvpwrvgnd_1
XFILLER_65_298 VGND VGND VPWR VPWR sky130_fd_sc_hd__decap_3
X_1957_ net26 VGND VGND VPWR VPWR _1652_ sky130_fd_sc_hd__inv_2
X_3627_ mantisaB0\[22\] net193 net185 mantisaA0\[23\] VGND VGND VPWR VPWR _1458_ sky130_fd_sc_hd__a22oi_1
X_3558_ _1391_ _1350_ net145 VGND VGND VPWR VPWR _1392_ sky130_fd_sc_hd__mux2_1
X_2509_ _0371_ _0372_ _0448_ _0451_ VGND VGND VPWR VPWR _0452_ sky130_fd_sc_hd__or4_1
X_3489_ net321 expmiddlec\[3\] net231 VGND VGND VPWR VPWR _0197_ sky130_fd_sc_hd__mux2_1
XFILLER_29_435 VGND VGND VPWR VPWR sky130_fd_sc_hd__fill_2
XFILLER_16_129 VGND VGND VPWR VPWR sky130_fd_sc_hd__fill_2
XTAP_TAPCELL_ROW_39_485 VGND VPWR sky130_fd_sc_hd__tapvpwrvgnd_1
XFILLER_71_279 VGND VGND VPWR VPWR sky130_fd_sc_hd__fill_1
XFILLER_24_195 VGND VGND VPWR VPWR sky130_fd_sc_hd__fill_1
XFILLER_35_405 VGND VGND VPWR VPWR sky130_fd_sc_hd__decap_8
Xclkbuf_leaf_27_clk clknet_2_0__leaf_clk VGND VGND VPWR VPWR clknet_leaf_27_clk sky130_fd_sc_hd__clkbuf_8
XTAP_TAPCELL_ROW_73_753 VGND VPWR sky130_fd_sc_hd__tapvpwrvgnd_1
X_2860_ _0747_ _0749_ net115 VGND VGND VPWR VPWR _0800_ sky130_fd_sc_hd__mux2_1
XFILLER_62_80 VGND VGND VPWR VPWR sky130_fd_sc_hd__decap_4
X_2791_ net229 net108 _0651_ net135 VGND VGND VPWR VPWR _0733_ sky130_fd_sc_hd__a22o_1
XFILLER_7_31 VPWR VGND VPWR VGND sky130_ef_sc_hd__decap_12
XFILLER_7_75 VGND VGND VPWR VPWR sky130_fd_sc_hd__fill_1
X_3412_ mantisaAshift\[61\] mantisaBshift\[61\] _1269_ VGND VGND VPWR VPWR _1280_
+ sky130_fd_sc_hd__a21bo_1
X_3343_ mantisaAshift\[56\] mantisaBshift\[56\] VGND VGND VPWR VPWR _1217_ sky130_fd_sc_hd__or2_1
X_3274_ mantisaAshift\[51\] mantisaBshift\[51\] VGND VGND VPWR VPWR _1154_ sky130_fd_sc_hd__and2_1
X_2225_ net4 net7 net6 net8 VGND VGND VPWR VPWR _1871_ sky130_fd_sc_hd__or4_1
XFILLER_26_29 VGND VGND VPWR VPWR sky130_fd_sc_hd__decap_8
XFILLER_26_405 VGND VGND VPWR VPWR sky130_fd_sc_hd__decap_8
X_2156_ _1813_ _1815_ _1816_ _1808_ VGND VGND VPWR VPWR _1817_ sky130_fd_sc_hd__o22a_1
XPHY_EDGE_ROW_5_Right_5 VGND VGND VPWR VPWR sky130_fd_sc_hd__decap_3
XFILLER_53_246 VGND VGND VPWR VPWR sky130_fd_sc_hd__fill_1
X_2087_ net209 net336 VGND VGND VPWR VPWR _0027_ sky130_fd_sc_hd__and2b_1
XFILLER_21_121 VGND VGND VPWR VPWR sky130_fd_sc_hd__fill_1
XFILLER_34_471 VGND VGND VPWR VPWR sky130_fd_sc_hd__fill_2
X_2989_ mantisaBshift\[11\] _0912_ VGND VGND VPWR VPWR _0913_ sky130_fd_sc_hd__xnor2_1
XFILLER_17_449 VPWR VGND VPWR VGND sky130_ef_sc_hd__decap_12
XTAP_TAPCELL_ROW_70_734 VGND VPWR sky130_fd_sc_hd__tapvpwrvgnd_1
XFILLER_79_165 VGND VGND VPWR VPWR sky130_fd_sc_hd__decap_3
X_2010_ net15 net14 net16 VGND VGND VPWR VPWR _1705_ sky130_fd_sc_hd__and3_1
XFILLER_75_393 VPWR VGND VPWR VGND sky130_ef_sc_hd__decap_12
X_3961_ clknet_leaf_7_clk _0084_ VGND VGND VPWR VPWR mantisaB0\[12\] sky130_fd_sc_hd__dfxtp_1
X_2912_ net141 _0748_ _0849_ VGND VGND VPWR VPWR _0850_ sky130_fd_sc_hd__o21ai_1
XTAP_TAPCELL_ROW_33_436 VGND VPWR sky130_fd_sc_hd__tapvpwrvgnd_1
X_3892_ clknet_leaf_17_clk _0015_ VGND VGND VPWR VPWR net92 sky130_fd_sc_hd__dfxtp_1
X_2843_ net137 _0662_ _0783_ VGND VGND VPWR VPWR _0784_ sky130_fd_sc_hd__a21oi_1
X_2774_ mantisaresult\[23\] net112 _0634_ net132 VGND VGND VPWR VPWR _0716_ sky130_fd_sc_hd__o2bb2a_1
Xhold114 expadd\[7\] VGND VGND VPWR VPWR net388 sky130_fd_sc_hd__dlygate4sd3_1
Xhold103 mantisaB0\[6\] VGND VGND VPWR VPWR net377 sky130_fd_sc_hd__dlygate4sd3_1
Xclkbuf_leaf_7_clk clknet_2_1__leaf_clk VGND VGND VPWR VPWR clknet_leaf_7_clk sky130_fd_sc_hd__clkbuf_8
X_3326_ mantisaBshift\[53\] mantisaAshift\[53\] VGND VGND VPWR VPWR _1202_ sky130_fd_sc_hd__and2b_1
X_3257_ _1125_ _1128_ _1137_ net245 _1138_ VGND VGND VPWR VPWR _1139_ sky130_fd_sc_hd__o221a_1
X_2208_ net251 _1759_ _1860_ _1862_ VGND VGND VPWR VPWR _0040_ sky130_fd_sc_hd__a22o_1
X_3188_ _1642_ _0610_ net133 _1075_ VGND VGND VPWR VPWR _1076_ sky130_fd_sc_hd__o31a_1
X_2139_ net34 _1661_ _1796_ _1799_ VGND VGND VPWR VPWR _1800_ sky130_fd_sc_hd__a22o_1
XPHY_EDGE_ROW_14_Left_94 VGND VGND VPWR VPWR sky130_fd_sc_hd__decap_3
XFILLER_22_430 VGND VGND VPWR VPWR sky130_fd_sc_hd__decap_8
XFILLER_78_13 VPWR VGND VPWR VGND sky130_ef_sc_hd__decap_12
XFILLER_1_334 VGND VGND VPWR VPWR sky130_fd_sc_hd__fill_2
XFILLER_49_305 VGND VGND VPWR VPWR sky130_fd_sc_hd__decap_8
XFILLER_76_135 VGND VGND VPWR VPWR sky130_fd_sc_hd__fill_2
XFILLER_17_202 VGND VGND VPWR VPWR sky130_fd_sc_hd__decap_8
XFILLER_57_360 VGND VGND VPWR VPWR sky130_fd_sc_hd__decap_4
XFILLER_57_393 VGND VGND VPWR VPWR sky130_fd_sc_hd__decap_3
XFILLER_72_363 VGND VGND VPWR VPWR sky130_fd_sc_hd__fill_1
XFILLER_13_441 VGND VGND VPWR VPWR sky130_fd_sc_hd__decap_6
XFILLER_32_249 VGND VGND VPWR VPWR sky130_fd_sc_hd__decap_3
XFILLER_9_445 VGND VGND VPWR VPWR sky130_fd_sc_hd__decap_3
X_2490_ mantisaresult\[13\] mantisaresult\[12\] mantisaresult\[11\] mantisaresult\[10\]
+ VGND VGND VPWR VPWR _0433_ sky130_fd_sc_hd__or4_1
X_4160_ clknet_leaf_10_clk _0267_ VGND VGND VPWR VPWR mantisaBshift\[53\] sky130_fd_sc_hd__dfxtp_1
XFILLER_4_65 VPWR VGND VPWR VGND sky130_ef_sc_hd__decap_12
X_3111_ _0711_ _0753_ net149 VGND VGND VPWR VPWR _1010_ sky130_fd_sc_hd__mux2_1
XFILLER_67_113 VGND VGND VPWR VPWR sky130_fd_sc_hd__fill_2
X_4091_ clknet_leaf_26_clk _0200_ VGND VGND VPWR VPWR expmiddlec\[6\] sky130_fd_sc_hd__dfxtp_1
X_3042_ mantisaresult\[18\] _0957_ net201 VGND VGND VPWR VPWR _0125_ sky130_fd_sc_hd__mux2_1
XFILLER_23_249 VGND VGND VPWR VPWR sky130_fd_sc_hd__fill_1
X_3944_ clknet_leaf_9_clk _0067_ VGND VGND VPWR VPWR mantisaA0\[18\] sky130_fd_sc_hd__dfxtp_1
X_3875_ clknet_leaf_6_clk net309 VGND VGND VPWR VPWR mantisaAshift\[60\] sky130_fd_sc_hd__dfxtp_1
X_2826_ net138 _0764_ _0766_ VGND VGND VPWR VPWR _0767_ sky130_fd_sc_hd__a21oi_1
X_2757_ _0699_ _0631_ net157 VGND VGND VPWR VPWR _0700_ sky130_fd_sc_hd__and3b_1
XFILLER_2_109 VPWR VGND VPWR VGND sky130_ef_sc_hd__decap_12
X_2688_ net123 _0627_ net126 net151 VGND VGND VPWR VPWR _0631_ sky130_fd_sc_hd__a31o_1
XFILLER_48_49 VGND VGND VPWR VPWR sky130_fd_sc_hd__fill_1
X_3309_ _1185_ _0929_ net146 VGND VGND VPWR VPWR _1186_ sky130_fd_sc_hd__mux2_1
XTAP_TAPCELL_ROW_52_586 VGND VPWR sky130_fd_sc_hd__tapvpwrvgnd_1
XFILLER_10_433 VPWR VGND VPWR VGND sky130_ef_sc_hd__decap_12
XFILLER_6_426 VPWR VGND VPWR VGND sky130_ef_sc_hd__decap_12
XTAP_TAPCELL_ROW_9_242 VGND VPWR sky130_fd_sc_hd__tapvpwrvgnd_1
XFILLER_49_157 VGND VGND VPWR VPWR sky130_fd_sc_hd__decap_8
XFILLER_64_116 VGND VGND VPWR VPWR sky130_fd_sc_hd__decap_4
XFILLER_60_322 VPWR VGND VPWR VGND sky130_ef_sc_hd__decap_12
X_1990_ net270 VGND VGND VPWR VPWR _1685_ sky130_fd_sc_hd__inv_2
XTAP_TAPCELL_ROW_15_288 VGND VPWR sky130_fd_sc_hd__tapvpwrvgnd_1
XFILLER_9_220 VGND VGND VPWR VPWR sky130_fd_sc_hd__decap_4
X_3660_ _1487_ _1489_ net270 VGND VGND VPWR VPWR _1490_ sky130_fd_sc_hd__mux2_1
Xclkload23 clknet_leaf_23_clk VGND VGND VPWR VPWR clkload23/Y sky130_fd_sc_hd__clkinvlp_4
X_2611_ _0370_ _0380_ _0484_ _0553_ VGND VGND VPWR VPWR _0554_ sky130_fd_sc_hd__or4_2
X_3591_ mantisaB0\[0\] net193 _1421_ net274 VGND VGND VPWR VPWR _1422_ sky130_fd_sc_hd__a22o_1
Xclkload12 clknet_leaf_5_clk VGND VGND VPWR VPWR clkload12/Y sky130_fd_sc_hd__inv_16
X_2542_ mantisaresult\[28\] mantisaresult\[27\] mantisaresult\[26\] mantisaresult\[25\]
+ VGND VGND VPWR VPWR _0485_ sky130_fd_sc_hd__or4b_1
X_2473_ _0293_ _0294_ _0314_ _0415_ VGND VGND VPWR VPWR _0416_ sky130_fd_sc_hd__or4_1
XFILLER_68_411 VGND VGND VPWR VPWR sky130_fd_sc_hd__decap_3
X_4143_ clknet_leaf_3_clk _0250_ VGND VGND VPWR VPWR mantisaBshift\[34\] sky130_fd_sc_hd__dfxtp_1
X_4074_ clknet_leaf_21_clk _0183_ VGND VGND VPWR VPWR expmiddled\[7\] sky130_fd_sc_hd__dfxtp_1
X_3025_ mantisaBshift\[13\] _0917_ net237 VGND VGND VPWR VPWR _0945_ sky130_fd_sc_hd__o21ai_1
XFILLER_51_322 VGND VGND VPWR VPWR sky130_fd_sc_hd__fill_1
XFILLER_34_29 VPWR VGND VPWR VGND sky130_ef_sc_hd__decap_12
X_3927_ clknet_leaf_4_clk _0050_ VGND VGND VPWR VPWR mantisaA0\[1\] sky130_fd_sc_hd__dfxtp_1
Xclkload6 clknet_leaf_25_clk VGND VGND VPWR VPWR clkload6/Y sky130_fd_sc_hd__inv_12
X_3858_ clknet_leaf_6_clk net291 VGND VGND VPWR VPWR mantisaAshift\[43\] sky130_fd_sc_hd__dfxtp_1
X_2809_ _0749_ _0750_ net115 VGND VGND VPWR VPWR _0751_ sky130_fd_sc_hd__mux2_1
X_3789_ net255 _1578_ VGND VGND VPWR VPWR _1601_ sky130_fd_sc_hd__nor2_1
XFILLER_3_429 VPWR VGND VPWR VGND sky130_ef_sc_hd__decap_12
XTAP_TAPCELL_ROW_6_223 VGND VPWR sky130_fd_sc_hd__tapvpwrvgnd_1
Xfanout232 net236 VGND VGND VPWR VPWR net232 sky130_fd_sc_hd__buf_1
Xfanout221 mantisaresult\[46\] VGND VGND VPWR VPWR net221 sky130_fd_sc_hd__buf_2
Xfanout210 net211 VGND VGND VPWR VPWR net210 sky130_fd_sc_hd__buf_1
Xfanout243 sub VGND VGND VPWR VPWR net243 sky130_fd_sc_hd__dlymetal6s2s_1
Xfanout265 expmiddle\[3\] VGND VGND VPWR VPWR net265 sky130_fd_sc_hd__clkbuf_2
Xfanout254 expmiddle\[4\] VGND VGND VPWR VPWR net254 sky130_fd_sc_hd__clkbuf_2
XFILLER_59_455 VGND VGND VPWR VPWR sky130_fd_sc_hd__fill_2
XFILLER_74_469 VGND VGND VPWR VPWR sky130_fd_sc_hd__decap_4
XFILLER_42_377 VGND VGND VPWR VPWR sky130_fd_sc_hd__decap_4
XFILLER_42_388 VGND VGND VPWR VPWR sky130_fd_sc_hd__fill_2
XTAP_TAPCELL_ROW_12_269 VGND VPWR sky130_fd_sc_hd__tapvpwrvgnd_1
XFILLER_10_296 VPWR VGND VPWR VGND sky130_ef_sc_hd__decap_12
XFILLER_6_245 VGND VGND VPWR VPWR sky130_fd_sc_hd__decap_6
XFILLER_40_83 VGND VGND VPWR VPWR sky130_fd_sc_hd__fill_1
XFILLER_1_55 VGND VGND VPWR VPWR sky130_fd_sc_hd__fill_1
XFILLER_45_193 VGND VGND VPWR VPWR sky130_fd_sc_hd__decap_8
XFILLER_60_141 VPWR VGND VPWR VGND sky130_ef_sc_hd__decap_12
XFILLER_60_185 VGND VGND VPWR VPWR sky130_fd_sc_hd__decap_4
X_1973_ net44 VGND VGND VPWR VPWR _1668_ sky130_fd_sc_hd__inv_2
X_3712_ net187 _1531_ _1537_ _1501_ VGND VGND VPWR VPWR _0215_ sky130_fd_sc_hd__a2bb2o_1
X_3643_ _1467_ _1471_ net266 VGND VGND VPWR VPWR _1473_ sky130_fd_sc_hd__mux2_1
X_3574_ mantisaresult\[60\] net199 net160 net217 VGND VGND VPWR VPWR _1407_ sky130_fd_sc_hd__a31o_1
X_2525_ _0372_ _0448_ _0467_ VGND VGND VPWR VPWR _0468_ sky130_fd_sc_hd__nor3_1
X_2456_ net188 _0312_ _0322_ _0398_ VGND VGND VPWR VPWR _0399_ sky130_fd_sc_hd__nor4_1
Xhold18 mantisaA0\[15\] VGND VGND VPWR VPWR net292 sky130_fd_sc_hd__dlygate4sd3_1
Xhold29 expmiddlea\[7\] VGND VGND VPWR VPWR net303 sky130_fd_sc_hd__dlygate4sd3_1
X_4126_ clknet_leaf_1_clk _0233_ VGND VGND VPWR VPWR mantisaBshift\[19\] sky130_fd_sc_hd__dfxtp_1
X_2387_ net188 _0310_ _0326_ _0328_ VGND VGND VPWR VPWR _0330_ sky130_fd_sc_hd__and4bb_1
X_4057_ clknet_leaf_14_clk _0168_ VGND VGND VPWR VPWR mantisaresult\[57\] sky130_fd_sc_hd__dfxtp_2
X_3008_ _0856_ _0928_ net118 VGND VGND VPWR VPWR _0929_ sky130_fd_sc_hd__mux2_1
XTAP_TAPCELL_ROW_54_604 VGND VPWR sky130_fd_sc_hd__tapvpwrvgnd_1
XFILLER_71_417 VPWR VGND VPWR VGND sky130_ef_sc_hd__decap_12
XFILLER_51_185 VGND VGND VPWR VPWR sky130_fd_sc_hd__fill_1
XTAP_TAPCELL_ROW_62_670 VGND VPWR sky130_fd_sc_hd__tapvpwrvgnd_1
XFILLER_10_42 VGND VGND VPWR VPWR sky130_fd_sc_hd__fill_2
XFILLER_3_237 VPWR VGND VPWR VGND sky130_ef_sc_hd__decap_12
XFILLER_59_241 VGND VGND VPWR VPWR sky130_fd_sc_hd__decap_3
XFILLER_59_252 VPWR VGND VPWR VGND sky130_ef_sc_hd__decap_12
XFILLER_19_73 VGND VGND VPWR VPWR sky130_fd_sc_hd__fill_1
XFILLER_47_447 VGND VGND VPWR VPWR sky130_fd_sc_hd__fill_1
XFILLER_19_84 VGND VGND VPWR VPWR sky130_fd_sc_hd__fill_2
XFILLER_74_233 VGND VGND VPWR VPWR sky130_fd_sc_hd__fill_2
XTAP_TAPCELL_ROW_17_306 VGND VPWR sky130_fd_sc_hd__tapvpwrvgnd_1
XFILLER_42_141 VGND VGND VPWR VPWR sky130_fd_sc_hd__decap_4
XTAP_TAPCELL_ROW_25_372 VGND VPWR sky130_fd_sc_hd__tapvpwrvgnd_1
XFILLER_30_358 VGND VGND VPWR VPWR sky130_fd_sc_hd__fill_1
XFILLER_51_82 VGND VGND VPWR VPWR sky130_fd_sc_hd__decap_6
XPHY_EDGE_ROW_2_Left_82 VGND VGND VPWR VPWR sky130_fd_sc_hd__decap_3
X_2310_ _1887_ net37 net104 VGND VGND VPWR VPWR _1926_ sky130_fd_sc_hd__mux2_1
X_3290_ mantisaAshift\[49\] _1680_ _1147_ mantisaAshift\[48\] _1167_ VGND VGND VPWR
+ VPWR _1169_ sky130_fd_sc_hd__a221o_1
XFILLER_2_281 VGND VGND VPWR VPWR sky130_fd_sc_hd__fill_1
X_2241_ _1882_ net291 net172 VGND VGND VPWR VPWR _0053_ sky130_fd_sc_hd__mux2_1
XTAP_TAPCELL_ROW_68_718 VGND VPWR sky130_fd_sc_hd__tapvpwrvgnd_1
XFILLER_18_3 VGND VGND VPWR VPWR sky130_fd_sc_hd__decap_4
X_2172_ _1655_ net54 VGND VGND VPWR VPWR _1833_ sky130_fd_sc_hd__and2_1
XFILLER_65_200 VGND VGND VPWR VPWR sky130_fd_sc_hd__decap_8
XFILLER_65_277 VGND VGND VPWR VPWR sky130_fd_sc_hd__decap_3
XFILLER_33_185 VGND VGND VPWR VPWR sky130_fd_sc_hd__decap_8
X_1956_ net27 VGND VGND VPWR VPWR _1651_ sky130_fd_sc_hd__inv_2
X_3626_ _1686_ net251 VGND VGND VPWR VPWR _1457_ sky130_fd_sc_hd__nor2_1
X_3557_ _1367_ _1390_ net119 VGND VGND VPWR VPWR _1391_ sky130_fd_sc_hd__mux2_1
X_2508_ mantisaresult\[3\] _1647_ _0442_ _0450_ VGND VGND VPWR VPWR _0451_ sky130_fd_sc_hd__or4_1
X_3488_ net317 expmiddlec\[2\] net230 VGND VGND VPWR VPWR _0196_ sky130_fd_sc_hd__mux2_1
X_2439_ net219 _0307_ _0311_ net220 VGND VGND VPWR VPWR _0382_ sky130_fd_sc_hd__a22o_1
X_4109_ clknet_leaf_1_clk _0216_ VGND VGND VPWR VPWR mantisaBshift\[13\] sky130_fd_sc_hd__dfxtp_1
XTAP_TAPCELL_ROW_39_486 VGND VPWR sky130_fd_sc_hd__tapvpwrvgnd_1
XFILLER_71_214 VGND VGND VPWR VPWR sky130_fd_sc_hd__fill_1
XFILLER_24_141 VGND VGND VPWR VPWR sky130_fd_sc_hd__fill_1
XFILLER_8_318 VGND VGND VPWR VPWR sky130_fd_sc_hd__fill_2
XFILLER_8_307 VGND VGND VPWR VPWR sky130_fd_sc_hd__fill_1
XFILLER_79_358 VGND VGND VPWR VPWR sky130_fd_sc_hd__fill_2
XFILLER_47_222 VGND VGND VPWR VPWR sky130_fd_sc_hd__fill_2
XFILLER_47_277 VGND VGND VPWR VPWR sky130_fd_sc_hd__decap_3
XFILLER_46_82 VGND VGND VPWR VPWR sky130_fd_sc_hd__fill_2
XFILLER_62_225 VGND VGND VPWR VPWR sky130_fd_sc_hd__decap_6
XTAP_TAPCELL_ROW_73_754 VGND VPWR sky130_fd_sc_hd__tapvpwrvgnd_1
XFILLER_62_269 VGND VGND VPWR VPWR sky130_fd_sc_hd__fill_1
XFILLER_15_185 VGND VGND VPWR VPWR sky130_fd_sc_hd__fill_2
XFILLER_30_133 VGND VGND VPWR VPWR sky130_fd_sc_hd__decap_6
XFILLER_30_144 VGND VGND VPWR VPWR sky130_fd_sc_hd__decap_3
X_2790_ net143 _0727_ _0731_ VGND VGND VPWR VPWR _0732_ sky130_fd_sc_hd__a21oi_1
XFILLER_11_391 VGND VGND VPWR VPWR sky130_fd_sc_hd__fill_1
XFILLER_7_43 VPWR VGND VPWR VGND sky130_ef_sc_hd__decap_12
X_3411_ _1271_ _1272_ _1268_ VGND VGND VPWR VPWR _1279_ sky130_fd_sc_hd__a21o_1
X_3342_ mantisaAshift\[56\] mantisaBshift\[56\] VGND VGND VPWR VPWR _1216_ sky130_fd_sc_hd__and2_1
X_3273_ mantisaresult\[50\] _1153_ net203 VGND VGND VPWR VPWR _0160_ sky130_fd_sc_hd__mux2_1
X_2224_ net1 net3 net2 net5 VGND VGND VPWR VPWR _1870_ sky130_fd_sc_hd__or4_1
X_2155_ _1809_ _1811_ _1812_ _1810_ VGND VGND VPWR VPWR _1816_ sky130_fd_sc_hd__o31a_1
X_2086_ net210 net354 VGND VGND VPWR VPWR _0026_ sky130_fd_sc_hd__and2b_1
XTAP_TAPCELL_ROW_36_456 VGND VPWR sky130_fd_sc_hd__tapvpwrvgnd_1
XFILLER_21_111 VGND VGND VPWR VPWR sky130_fd_sc_hd__fill_1
XFILLER_61_291 VGND VGND VPWR VPWR sky130_fd_sc_hd__decap_4
X_2988_ mantisaBshift\[10\] _0909_ net238 VGND VGND VPWR VPWR _0912_ sky130_fd_sc_hd__o21ai_1
X_1939_ mantisaresult\[32\] VGND VGND VPWR VPWR _1634_ sky130_fd_sc_hd__inv_2
X_3609_ net250 mantisaB0\[11\] VGND VGND VPWR VPWR _1440_ sky130_fd_sc_hd__and2b_1
XFILLER_44_203 VGND VGND VPWR VPWR sky130_fd_sc_hd__fill_2
XFILLER_44_258 VGND VGND VPWR VPWR sky130_fd_sc_hd__decap_4
XFILLER_16_85 VGND VGND VPWR VPWR sky130_fd_sc_hd__decap_8
XPHY_EDGE_ROW_11_Right_11 VGND VGND VPWR VPWR sky130_fd_sc_hd__decap_3
XTAP_TAPCELL_ROW_70_735 VGND VPWR sky130_fd_sc_hd__tapvpwrvgnd_1
XFILLER_4_365 VGND VGND VPWR VPWR sky130_fd_sc_hd__decap_4
XPHY_EDGE_ROW_20_Right_20 VGND VGND VPWR VPWR sky130_fd_sc_hd__decap_3
XFILLER_75_361 VPWR VGND VPWR VGND sky130_ef_sc_hd__decap_12
XFILLER_35_247 VGND VGND VPWR VPWR sky130_fd_sc_hd__fill_1
X_3960_ clknet_leaf_8_clk _0083_ VGND VGND VPWR VPWR mantisaB0\[11\] sky130_fd_sc_hd__dfxtp_1
X_2911_ net136 _0754_ net141 VGND VGND VPWR VPWR _0849_ sky130_fd_sc_hd__o21ai_1
XTAP_TAPCELL_ROW_33_437 VGND VPWR sky130_fd_sc_hd__tapvpwrvgnd_1
XFILLER_43_291 VGND VGND VPWR VPWR sky130_fd_sc_hd__decap_3
X_3891_ clknet_leaf_16_clk _0014_ VGND VGND VPWR VPWR net91 sky130_fd_sc_hd__dfxtp_1
X_2842_ net137 _0782_ VGND VGND VPWR VPWR _0783_ sky130_fd_sc_hd__nor2_1
X_2773_ net132 _0692_ net112 mantisaresult\[21\] VGND VGND VPWR VPWR _0715_ sky130_fd_sc_hd__a2bb2o_1
XFILLER_7_181 VPWR VGND VPWR VGND sky130_ef_sc_hd__decap_12
Xhold115 _1753_ VGND VGND VPWR VPWR net389 sky130_fd_sc_hd__dlygate4sd3_1
Xhold104 mantisaB0\[15\] VGND VGND VPWR VPWR net378 sky130_fd_sc_hd__dlygate4sd3_1
X_3325_ _1163_ _1171_ _1178_ VGND VGND VPWR VPWR _1201_ sky130_fd_sc_hd__and3_1
XFILLER_58_328 VPWR VGND VPWR VGND sky130_ef_sc_hd__decap_12
X_3256_ mantisaBshift\[48\] mantisaAshift\[48\] net245 VGND VGND VPWR VPWR _1138_
+ sky130_fd_sc_hd__nand3b_1
X_2207_ _1768_ net99 _1861_ _1765_ net177 VGND VGND VPWR VPWR _1862_ sky130_fd_sc_hd__o311a_1
X_3187_ net220 net113 VGND VGND VPWR VPWR _1075_ sky130_fd_sc_hd__nand2_1
XFILLER_73_309 VPWR VGND VPWR VGND sky130_ef_sc_hd__decap_12
X_2138_ net33 _1658_ _1659_ net32 _1798_ VGND VGND VPWR VPWR _1799_ sky130_fd_sc_hd__a221o_1
X_2069_ _1752_ net389 _1754_ VGND VGND VPWR VPWR _0009_ sky130_fd_sc_hd__o21ai_1
XFILLER_41_206 VPWR VGND VPWR VGND sky130_ef_sc_hd__decap_12
XFILLER_78_25 VGND VGND VPWR VPWR sky130_fd_sc_hd__decap_3
XFILLER_1_313 VGND VGND VPWR VPWR sky130_fd_sc_hd__decap_4
XFILLER_64_309 VGND VGND VPWR VPWR sky130_fd_sc_hd__decap_8
XFILLER_17_225 VPWR VGND VPWR VGND sky130_ef_sc_hd__decap_12
XFILLER_27_84 VGND VGND VPWR VPWR sky130_fd_sc_hd__decap_6
XFILLER_4_77 VGND VGND VPWR VPWR sky130_fd_sc_hd__decap_6
XFILLER_4_195 VGND VGND VPWR VPWR sky130_fd_sc_hd__fill_1
X_3110_ mantisaresult\[33\] _1009_ net205 VGND VGND VPWR VPWR _0141_ sky130_fd_sc_hd__mux2_1
XFILLER_67_103 VGND VGND VPWR VPWR sky130_fd_sc_hd__fill_1
X_4090_ clknet_leaf_26_clk _0199_ VGND VGND VPWR VPWR expmiddlec\[5\] sky130_fd_sc_hd__dfxtp_2
X_3041_ mantisaBshift\[18\] _0956_ VGND VGND VPWR VPWR _0957_ sky130_fd_sc_hd__xor2_1
XFILLER_67_169 VGND VGND VPWR VPWR sky130_fd_sc_hd__decap_8
XFILLER_48_383 VGND VGND VPWR VPWR sky130_fd_sc_hd__decap_3
XTAP_TAPCELL_ROW_46_540 VGND VPWR sky130_fd_sc_hd__tapvpwrvgnd_1
X_3943_ clknet_leaf_8_clk _0066_ VGND VGND VPWR VPWR mantisaA0\[17\] sky130_fd_sc_hd__dfxtp_1
XFILLER_31_261 VGND VGND VPWR VPWR sky130_fd_sc_hd__decap_8
X_3874_ clknet_leaf_6_clk net288 VGND VGND VPWR VPWR mantisaAshift\[59\] sky130_fd_sc_hd__dfxtp_1
X_2825_ net138 _0765_ VGND VGND VPWR VPWR _0766_ sky130_fd_sc_hd__and2b_1
X_2756_ _0633_ _0665_ _0698_ net128 VGND VGND VPWR VPWR _0699_ sky130_fd_sc_hd__a2bb2o_1
X_2687_ _1625_ _0579_ _0601_ VGND VGND VPWR VPWR _0630_ sky130_fd_sc_hd__mux2_2
XFILLER_58_114 VGND VGND VPWR VPWR sky130_fd_sc_hd__decap_3
X_3308_ _1014_ _1184_ net118 VGND VGND VPWR VPWR _1185_ sky130_fd_sc_hd__mux2_1
XFILLER_58_125 VGND VGND VPWR VPWR sky130_fd_sc_hd__decap_6
XFILLER_39_361 VGND VGND VPWR VPWR sky130_fd_sc_hd__decap_3
XFILLER_46_309 VPWR VGND VPWR VGND sky130_ef_sc_hd__decap_12
X_3239_ mantisaAshift\[48\] mantisaBshift\[48\] VGND VGND VPWR VPWR _1122_ sky130_fd_sc_hd__nand2_1
XTAP_TAPCELL_ROW_1_176 VGND VPWR sky130_fd_sc_hd__tapvpwrvgnd_1
XTAP_TAPCELL_ROW_52_587 VGND VPWR sky130_fd_sc_hd__tapvpwrvgnd_1
Xfanout98 net101 VGND VGND VPWR VPWR net98 sky130_fd_sc_hd__clkbuf_4
XFILLER_10_445 VPWR VGND VPWR VGND sky130_ef_sc_hd__decap_12
XFILLER_6_438 VPWR VGND VPWR VGND sky130_ef_sc_hd__decap_12
XTAP_TAPCELL_ROW_9_243 VGND VPWR sky130_fd_sc_hd__tapvpwrvgnd_1
XFILLER_49_147 VGND VGND VPWR VPWR sky130_fd_sc_hd__decap_4
XFILLER_49_169 VGND VGND VPWR VPWR sky130_fd_sc_hd__decap_3
XFILLER_38_83 VGND VGND VPWR VPWR sky130_fd_sc_hd__fill_1
XFILLER_72_161 VGND VGND VPWR VPWR sky130_fd_sc_hd__decap_6
XFILLER_60_334 VGND VGND VPWR VPWR sky130_fd_sc_hd__decap_6
XFILLER_72_183 VGND VGND VPWR VPWR sky130_fd_sc_hd__decap_4
XFILLER_13_261 VPWR VGND VPWR VGND sky130_ef_sc_hd__decap_12
XFILLER_60_378 VGND VGND VPWR VPWR sky130_fd_sc_hd__fill_1
XTAP_TAPCELL_ROW_15_289 VGND VPWR sky130_fd_sc_hd__tapvpwrvgnd_1
X_2610_ _0478_ _0552_ _0513_ _0420_ VGND VGND VPWR VPWR _0553_ sky130_fd_sc_hd__or4bb_1
X_3590_ net251 mantisaB0\[1\] VGND VGND VPWR VPWR _1421_ sky130_fd_sc_hd__and2b_1
Xclkload13 clknet_leaf_7_clk VGND VGND VPWR VPWR clkload13/Y sky130_fd_sc_hd__inv_16
Xclkload24 clknet_leaf_14_clk VGND VGND VPWR VPWR clkload24/Y sky130_fd_sc_hd__bufinv_16
X_2541_ mantisaresult\[25\] mantisaresult\[24\] _0352_ VGND VGND VPWR VPWR _0484_
+ sky130_fd_sc_hd__o21a_1
X_2472_ _0354_ mantisaresult\[23\] mantisaresult\[22\] VGND VGND VPWR VPWR _0415_
+ sky130_fd_sc_hd__or3b_1
X_4142_ clknet_leaf_2_clk _0249_ VGND VGND VPWR VPWR mantisaBshift\[35\] sky130_fd_sc_hd__dfxtp_1
X_4073_ clknet_leaf_21_clk _0182_ VGND VGND VPWR VPWR expmiddled\[6\] sky130_fd_sc_hd__dfxtp_1
X_3024_ net322 net206 _0942_ _0944_ VGND VGND VPWR VPWR _0120_ sky130_fd_sc_hd__o22a_1
XFILLER_70_109 VGND VGND VPWR VPWR sky130_fd_sc_hd__fill_2
X_3926_ clknet_leaf_4_clk _0049_ VGND VGND VPWR VPWR mantisaA0\[0\] sky130_fd_sc_hd__dfxtp_1
Xclkload7 clknet_leaf_27_clk VGND VGND VPWR VPWR clkload7/Y sky130_fd_sc_hd__clkinv_16
X_3857_ clknet_leaf_6_clk net286 VGND VGND VPWR VPWR mantisaAshift\[42\] sky130_fd_sc_hd__dfxtp_1
X_2808_ net130 _0666_ net111 mantisaresult\[7\] VGND VGND VPWR VPWR _0750_ sky130_fd_sc_hd__a2bb2o_1
X_3788_ net255 net187 _1575_ _1600_ VGND VGND VPWR VPWR _0228_ sky130_fd_sc_hd__o31ai_1
X_2739_ net122 _0681_ VGND VGND VPWR VPWR _0682_ sky130_fd_sc_hd__nor2_1
Xfanout211 net212 VGND VGND VPWR VPWR net211 sky130_fd_sc_hd__clkbuf_2
Xfanout222 mantisaresult\[45\] VGND VGND VPWR VPWR net222 sky130_fd_sc_hd__buf_2
XFILLER_59_401 VGND VGND VPWR VPWR sky130_fd_sc_hd__decap_4
Xfanout200 _0296_ VGND VGND VPWR VPWR net200 sky130_fd_sc_hd__clkbuf_2
Xfanout233 net234 VGND VGND VPWR VPWR net233 sky130_fd_sc_hd__clkbuf_2
Xfanout255 net257 VGND VGND VPWR VPWR net255 sky130_fd_sc_hd__buf_2
Xfanout244 net249 VGND VGND VPWR VPWR net244 sky130_fd_sc_hd__buf_2
Xfanout266 net267 VGND VGND VPWR VPWR net266 sky130_fd_sc_hd__buf_2
XFILLER_46_106 VPWR VGND VPWR VGND sky130_ef_sc_hd__decap_12
XTAP_TAPCELL_ROW_57_624 VGND VPWR sky130_fd_sc_hd__tapvpwrvgnd_1
XTAP_TAPCELL_ROW_65_690 VGND VPWR sky130_fd_sc_hd__tapvpwrvgnd_1
XFILLER_10_253 VPWR VGND VPWR VGND sky130_ef_sc_hd__decap_12
XFILLER_10_286 VGND VGND VPWR VPWR sky130_fd_sc_hd__decap_4
XFILLER_6_279 VGND VGND VPWR VPWR sky130_fd_sc_hd__fill_2
XFILLER_65_437 VGND VGND VPWR VPWR sky130_fd_sc_hd__fill_2
XTAP_TAPCELL_ROW_28_392 VGND VPWR sky130_fd_sc_hd__tapvpwrvgnd_1
XFILLER_60_197 VGND VGND VPWR VPWR sky130_fd_sc_hd__fill_1
X_1972_ net41 VGND VGND VPWR VPWR _1667_ sky130_fd_sc_hd__inv_2
X_3711_ net263 _1536_ VGND VGND VPWR VPWR _1537_ sky130_fd_sc_hd__and2_1
X_3642_ _1471_ VGND VGND VPWR VPWR _1472_ sky130_fd_sc_hd__inv_2
X_3573_ net150 _1399_ _1400_ _1405_ VGND VGND VPWR VPWR _1406_ sky130_fd_sc_hd__a31o_1
XPHY_EDGE_ROW_49_Right_49 VGND VGND VPWR VPWR sky130_fd_sc_hd__decap_3
X_2524_ mantisaresult\[7\] _1628_ _0371_ _0450_ VGND VGND VPWR VPWR _0467_ sky130_fd_sc_hd__or4_1
X_2455_ _1634_ mantisaresult\[33\] VGND VGND VPWR VPWR _0398_ sky130_fd_sc_hd__or2_1
X_2386_ net227 _0316_ VGND VGND VPWR VPWR _0329_ sky130_fd_sc_hd__or2_1
Xhold19 mantisaA0\[19\] VGND VGND VPWR VPWR net293 sky130_fd_sc_hd__dlygate4sd3_1
X_4125_ clknet_leaf_1_clk _0232_ VGND VGND VPWR VPWR mantisaBshift\[20\] sky130_fd_sc_hd__dfxtp_1
XFILLER_56_437 VGND VGND VPWR VPWR sky130_fd_sc_hd__fill_2
XFILLER_68_297 VGND VGND VPWR VPWR sky130_fd_sc_hd__decap_8
XPHY_EDGE_ROW_58_Right_58 VGND VGND VPWR VPWR sky130_fd_sc_hd__decap_3
X_4056_ clknet_leaf_14_clk _0167_ VGND VGND VPWR VPWR mantisaresult\[56\] sky130_fd_sc_hd__dfxtp_2
X_3007_ mantisaresult\[46\] net109 _0927_ VGND VGND VPWR VPWR _0928_ sky130_fd_sc_hd__a21o_1
XTAP_TAPCELL_ROW_54_605 VGND VPWR sky130_fd_sc_hd__tapvpwrvgnd_1
XFILLER_71_429 VPWR VGND VPWR VGND sky130_ef_sc_hd__decap_12
XFILLER_24_323 VGND VGND VPWR VPWR sky130_fd_sc_hd__fill_1
XFILLER_36_194 VGND VGND VPWR VPWR sky130_fd_sc_hd__fill_2
XFILLER_61_39 VGND VGND VPWR VPWR sky130_fd_sc_hd__fill_2
XTAP_TAPCELL_ROW_62_671 VGND VPWR sky130_fd_sc_hd__tapvpwrvgnd_1
X_3909_ clknet_leaf_15_clk _0032_ VGND VGND VPWR VPWR net88 sky130_fd_sc_hd__dfxtp_1
XPHY_EDGE_ROW_67_Right_67 VGND VGND VPWR VPWR sky130_fd_sc_hd__decap_3
XFILLER_3_205 VPWR VGND VPWR VGND sky130_ef_sc_hd__decap_12
XFILLER_3_249 VPWR VGND VPWR VGND sky130_ef_sc_hd__decap_12
XFILLER_59_220 VGND VGND VPWR VPWR sky130_fd_sc_hd__decap_4
XFILLER_59_264 VPWR VGND VPWR VGND sky130_ef_sc_hd__decap_12
XPHY_EDGE_ROW_76_Right_76 VGND VGND VPWR VPWR sky130_fd_sc_hd__decap_3
XTAP_TAPCELL_ROW_17_307 VGND VPWR sky130_fd_sc_hd__tapvpwrvgnd_1
XFILLER_35_51 VGND VGND VPWR VPWR sky130_fd_sc_hd__decap_4
XTAP_TAPCELL_ROW_25_373 VGND VPWR sky130_fd_sc_hd__tapvpwrvgnd_1
X_2240_ net34 _1881_ net102 VGND VGND VPWR VPWR _1882_ sky130_fd_sc_hd__mux2_1
XTAP_TAPCELL_ROW_68_719 VGND VPWR sky130_fd_sc_hd__tapvpwrvgnd_1
X_2171_ _1775_ _1831_ VGND VGND VPWR VPWR _1832_ sky130_fd_sc_hd__nor2_1
XFILLER_65_223 VGND VGND VPWR VPWR sky130_fd_sc_hd__fill_1
XFILLER_65_234 VPWR VGND VPWR VGND sky130_ef_sc_hd__decap_12
XFILLER_18_194 VGND VGND VPWR VPWR sky130_fd_sc_hd__fill_2
XFILLER_33_153 VGND VGND VPWR VPWR sky130_fd_sc_hd__decap_8
XFILLER_21_315 VPWR VGND VPWR VGND sky130_ef_sc_hd__decap_12
XFILLER_21_337 VGND VGND VPWR VPWR sky130_fd_sc_hd__fill_2
X_1955_ net24 VGND VGND VPWR VPWR _1650_ sky130_fd_sc_hd__inv_2
X_3625_ _1453_ _1455_ net272 VGND VGND VPWR VPWR _1456_ sky130_fd_sc_hd__mux2_1
X_3556_ mantisaresult\[58\] net113 net109 mantisaresult\[59\] VGND VGND VPWR VPWR
+ _1390_ sky130_fd_sc_hd__a22o_1
X_2507_ mantisaresult\[17\] _0433_ _0449_ VGND VGND VPWR VPWR _0450_ sky130_fd_sc_hd__or3_1
X_3487_ net342 net207 _1330_ _1332_ VGND VGND VPWR VPWR _0195_ sky130_fd_sc_hd__o22a_1
X_2438_ net219 _0307_ _0311_ net220 VGND VGND VPWR VPWR _0381_ sky130_fd_sc_hd__a22oi_2
X_2369_ net220 _0310_ VGND VGND VPWR VPWR _0312_ sky130_fd_sc_hd__or2_1
XFILLER_56_17 VGND VGND VPWR VPWR sky130_fd_sc_hd__fill_2
X_4108_ clknet_leaf_1_clk _0215_ VGND VGND VPWR VPWR mantisaBshift\[14\] sky130_fd_sc_hd__dfxtp_1
X_4039_ clknet_leaf_12_clk _0150_ VGND VGND VPWR VPWR mantisaresult\[41\] sky130_fd_sc_hd__dfxtp_1
XTAP_TAPCELL_ROW_39_487 VGND VPWR sky130_fd_sc_hd__tapvpwrvgnd_1
XFILLER_72_27 VGND VGND VPWR VPWR sky130_fd_sc_hd__fill_1
XFILLER_12_315 VGND VGND VPWR VPWR sky130_fd_sc_hd__decap_8
XFILLER_12_348 VGND VGND VPWR VPWR sky130_fd_sc_hd__fill_2
XFILLER_24_197 VGND VGND VPWR VPWR sky130_fd_sc_hd__decap_8
XFILLER_21_75 VPWR VGND VPWR VGND sky130_ef_sc_hd__decap_12
XFILLER_79_337 VGND VGND VPWR VPWR sky130_fd_sc_hd__fill_2
XFILLER_47_201 VGND VGND VPWR VPWR sky130_fd_sc_hd__decap_3
XTAP_TAPCELL_ROW_73_755 VGND VPWR sky130_fd_sc_hd__tapvpwrvgnd_1
XFILLER_7_55 VGND VGND VPWR VPWR sky130_fd_sc_hd__fill_1
X_3410_ mantisaBshift\[61\] mantisaAshift\[61\] VGND VGND VPWR VPWR _1278_ sky130_fd_sc_hd__nand2b_1
X_3341_ mantisaresult\[55\] _1215_ net203 VGND VGND VPWR VPWR _0166_ sky130_fd_sc_hd__mux2_1
XFILLER_30_3 VGND VGND VPWR VPWR sky130_fd_sc_hd__fill_2
X_3272_ _1145_ _1152_ VGND VGND VPWR VPWR _1153_ sky130_fd_sc_hd__xnor2_1
X_2223_ net8 net16 net303 net178 VGND VGND VPWR VPWR _0048_ sky130_fd_sc_hd__o22a_1
X_2154_ _1814_ _1807_ _1809_ VGND VGND VPWR VPWR _1815_ sky130_fd_sc_hd__or3b_1
X_2085_ net210 net325 VGND VGND VPWR VPWR _0025_ sky130_fd_sc_hd__and2b_1
XTAP_TAPCELL_ROW_36_457 VGND VPWR sky130_fd_sc_hd__tapvpwrvgnd_1
XFILLER_61_270 VGND VGND VPWR VPWR sky130_fd_sc_hd__decap_3
X_2987_ _0910_ _0911_ mantisaresult\[10\] net230 VGND VGND VPWR VPWR _0116_ sky130_fd_sc_hd__a2bb2o_1
X_1938_ mantisaresult\[9\] VGND VGND VPWR VPWR _1633_ sky130_fd_sc_hd__inv_2
X_3608_ net254 _1438_ VGND VGND VPWR VPWR _1439_ sky130_fd_sc_hd__nor2_1
X_3539_ mantisaresult\[57\] net195 net161 net216 VGND VGND VPWR VPWR _1375_ sky130_fd_sc_hd__a31o_1
XFILLER_76_307 VGND VGND VPWR VPWR sky130_fd_sc_hd__fill_1
XFILLER_29_223 VGND VGND VPWR VPWR sky130_fd_sc_hd__fill_1
XFILLER_29_234 VGND VGND VPWR VPWR sky130_fd_sc_hd__decap_8
XFILLER_29_267 VGND VGND VPWR VPWR sky130_fd_sc_hd__fill_1
XFILLER_29_278 VGND VGND VPWR VPWR sky130_fd_sc_hd__fill_2
XFILLER_29_289 VGND VGND VPWR VPWR sky130_fd_sc_hd__decap_4
XFILLER_40_410 VGND VGND VPWR VPWR sky130_fd_sc_hd__decap_8
XFILLER_40_421 VPWR VGND VPWR VGND sky130_ef_sc_hd__decap_12
XFILLER_8_138 VGND VGND VPWR VPWR sky130_fd_sc_hd__fill_2
XFILLER_32_85 VGND VGND VPWR VPWR sky130_fd_sc_hd__fill_1
XPHY_EDGE_ROW_26_Left_106 VGND VGND VPWR VPWR sky130_fd_sc_hd__decap_3
XFILLER_75_373 VPWR VGND VPWR VGND sky130_ef_sc_hd__decap_12
XPHY_EDGE_ROW_35_Left_115 VGND VGND VPWR VPWR sky130_fd_sc_hd__decap_3
X_2910_ net345 net207 _0846_ _0848_ VGND VGND VPWR VPWR _0102_ sky130_fd_sc_hd__o22a_1
XTAP_TAPCELL_ROW_33_438 VGND VPWR sky130_fd_sc_hd__tapvpwrvgnd_1
XFILLER_43_281 VGND VGND VPWR VPWR sky130_fd_sc_hd__decap_6
X_3890_ clknet_leaf_17_clk _0013_ VGND VGND VPWR VPWR net90 sky130_fd_sc_hd__dfxtp_1
X_2841_ net227 net114 _0781_ net134 VGND VGND VPWR VPWR _0782_ sky130_fd_sc_hd__o2bb2a_1
X_2772_ _0712_ _0713_ net116 VGND VGND VPWR VPWR _0714_ sky130_fd_sc_hd__mux2_1
XFILLER_7_193 VGND VGND VPWR VPWR sky130_fd_sc_hd__fill_2
Xhold116 mantisaA0\[23\] VGND VGND VPWR VPWR net390 sky130_fd_sc_hd__dlygate4sd3_1
Xhold105 mantisaB0\[0\] VGND VGND VPWR VPWR net379 sky130_fd_sc_hd__dlygate4sd3_1
XPHY_EDGE_ROW_44_Left_124 VGND VGND VPWR VPWR sky130_fd_sc_hd__decap_3
X_3324_ _1163_ _1178_ VGND VGND VPWR VPWR _1200_ sky130_fd_sc_hd__nand2_1
XFILLER_58_307 VGND VGND VPWR VPWR sky130_fd_sc_hd__fill_1
X_3255_ _1136_ VGND VGND VPWR VPWR _1137_ sky130_fd_sc_hd__inv_2
X_2206_ _1766_ _1856_ VGND VGND VPWR VPWR _1861_ sky130_fd_sc_hd__nor2_1
X_3186_ _0790_ _0756_ _0744_ _0767_ VGND VGND VPWR VPWR _1074_ sky130_fd_sc_hd__o2bb2a_1
XTAP_TAPCELL_ROW_49_560 VGND VPWR sky130_fd_sc_hd__tapvpwrvgnd_1
XPHY_EDGE_ROW_53_Left_133 VGND VGND VPWR VPWR sky130_fd_sc_hd__decap_3
X_2137_ net28 _1656_ _1659_ net32 _1797_ VGND VGND VPWR VPWR _1798_ sky130_fd_sc_hd__o221a_1
X_2068_ _1752_ _1753_ net212 VGND VGND VPWR VPWR _1754_ sky130_fd_sc_hd__a21oi_1
XFILLER_53_18 VGND VGND VPWR VPWR sky130_fd_sc_hd__decap_3
XFILLER_41_218 VGND VGND VPWR VPWR sky130_fd_sc_hd__decap_6
XPHY_EDGE_ROW_62_Left_142 VGND VGND VPWR VPWR sky130_fd_sc_hd__decap_3
XPHY_EDGE_ROW_71_Left_151 VGND VGND VPWR VPWR sky130_fd_sc_hd__decap_3
XFILLER_17_237 VGND VGND VPWR VPWR sky130_fd_sc_hd__decap_8
XFILLER_72_321 VPWR VGND VPWR VGND sky130_ef_sc_hd__decap_12
XFILLER_27_74 VGND VGND VPWR VPWR sky130_fd_sc_hd__fill_1
XFILLER_72_365 VPWR VGND VPWR VGND sky130_ef_sc_hd__decap_12
XTAP_TAPCELL_ROW_30_408 VGND VPWR sky130_fd_sc_hd__tapvpwrvgnd_1
XFILLER_40_251 VGND VGND VPWR VPWR sky130_fd_sc_hd__fill_1
XFILLER_4_141 VPWR VGND VPWR VGND sky130_ef_sc_hd__decap_12
XFILLER_0_391 VGND VGND VPWR VPWR sky130_fd_sc_hd__fill_1
XFILLER_67_137 VGND VGND VPWR VPWR sky130_fd_sc_hd__fill_2
X_3040_ _0950_ _0955_ net237 VGND VGND VPWR VPWR _0956_ sky130_fd_sc_hd__o21a_1
XFILLER_48_373 VGND VGND VPWR VPWR sky130_fd_sc_hd__fill_1
XTAP_TAPCELL_ROW_46_541 VGND VPWR sky130_fd_sc_hd__tapvpwrvgnd_1
XFILLER_23_207 VPWR VGND VPWR VGND sky130_ef_sc_hd__decap_12
X_3942_ clknet_leaf_8_clk _0065_ VGND VGND VPWR VPWR mantisaA0\[16\] sky130_fd_sc_hd__dfxtp_1
X_3873_ clknet_leaf_6_clk net293 VGND VGND VPWR VPWR mantisaAshift\[58\] sky130_fd_sc_hd__dfxtp_1
X_2824_ _0678_ _0685_ net116 VGND VGND VPWR VPWR _0765_ sky130_fd_sc_hd__mux2_1
XFILLER_31_295 VPWR VGND VPWR VGND sky130_ef_sc_hd__decap_12
X_2755_ net122 _0697_ _0682_ VGND VGND VPWR VPWR _0698_ sky130_fd_sc_hd__a21oi_1
X_2686_ expmiddlec\[4\] _0580_ _0601_ VGND VGND VPWR VPWR _0629_ sky130_fd_sc_hd__mux2_1
XFILLER_48_18 VGND VGND VPWR VPWR sky130_fd_sc_hd__fill_1
XFILLER_48_29 VPWR VGND VPWR VGND sky130_ef_sc_hd__decap_12
X_3307_ mantisaresult\[50\] net109 _1183_ VGND VGND VPWR VPWR _1184_ sky130_fd_sc_hd__a21o_1
XFILLER_39_340 VGND VGND VPWR VPWR sky130_fd_sc_hd__fill_1
X_3238_ mantisaresult\[47\] _1121_ net204 VGND VGND VPWR VPWR _0157_ sky130_fd_sc_hd__mux2_1
X_3169_ _1048_ _1051_ _1049_ VGND VGND VPWR VPWR _1059_ sky130_fd_sc_hd__o21a_1
XFILLER_54_321 VGND VGND VPWR VPWR sky130_fd_sc_hd__decap_8
XTAP_TAPCELL_ROW_1_177 VGND VPWR sky130_fd_sc_hd__tapvpwrvgnd_1
XFILLER_54_365 VGND VGND VPWR VPWR sky130_fd_sc_hd__fill_1
XFILLER_22_251 VGND VGND VPWR VPWR sky130_fd_sc_hd__fill_1
Xfanout99 net101 VGND VGND VPWR VPWR net99 sky130_fd_sc_hd__dlymetal6s2s_1
XFILLER_13_21 VGND VGND VPWR VPWR sky130_fd_sc_hd__fill_2
XFILLER_22_262 VGND VGND VPWR VPWR sky130_fd_sc_hd__decap_8
XTAP_TAPCELL_ROW_52_588 VGND VPWR sky130_fd_sc_hd__tapvpwrvgnd_1
XFILLER_10_457 VPWR VGND VPWR VGND sky130_ef_sc_hd__decap_12
XTAP_TAPCELL_ROW_9_244 VGND VPWR sky130_fd_sc_hd__tapvpwrvgnd_1
XFILLER_1_111 VGND VGND VPWR VPWR sky130_fd_sc_hd__fill_1
XFILLER_49_126 VGND VGND VPWR VPWR sky130_fd_sc_hd__decap_3
XFILLER_57_181 VGND VGND VPWR VPWR sky130_fd_sc_hd__fill_1
XFILLER_60_313 VGND VGND VPWR VPWR sky130_fd_sc_hd__fill_1
XFILLER_54_61 VGND VGND VPWR VPWR sky130_fd_sc_hd__decap_6
XFILLER_13_273 VGND VGND VPWR VPWR sky130_fd_sc_hd__decap_6
XFILLER_13_295 VGND VGND VPWR VPWR sky130_fd_sc_hd__decap_4
XFILLER_62_6 VGND VGND VPWR VPWR sky130_fd_sc_hd__decap_8
Xclkload25 clknet_leaf_15_clk VGND VGND VPWR VPWR clkload25/Y sky130_fd_sc_hd__clkinvlp_4
Xclkload14 clknet_leaf_8_clk VGND VGND VPWR VPWR clkload14/Y sky130_fd_sc_hd__clkinv_8
X_2540_ mantisaresult\[25\] mantisaresult\[24\] VGND VGND VPWR VPWR _0483_ sky130_fd_sc_hd__nand2b_1
XFILLER_5_461 VPWR VGND VPWR VGND sky130_ef_sc_hd__decap_12
X_2471_ mantisaresult\[21\] mantisaresult\[20\] _0352_ _0356_ VGND VGND VPWR VPWR
+ _0414_ sky130_fd_sc_hd__o211a_1
X_4141_ clknet_leaf_2_clk _0248_ VGND VGND VPWR VPWR mantisaBshift\[36\] sky130_fd_sc_hd__dfxtp_1
XFILLER_68_435 VPWR VGND VPWR VGND sky130_ef_sc_hd__decap_12
X_4072_ clknet_leaf_21_clk _0181_ VGND VGND VPWR VPWR expmiddled\[5\] sky130_fd_sc_hd__dfxtp_1
XFILLER_48_170 VGND VGND VPWR VPWR sky130_fd_sc_hd__fill_2
XFILLER_55_129 VPWR VGND VPWR VGND sky130_ef_sc_hd__decap_12
X_3023_ mantisaresult\[47\] net194 net165 _0943_ VGND VGND VPWR VPWR _0944_ sky130_fd_sc_hd__a31o_1
XFILLER_63_151 VGND VGND VPWR VPWR sky130_fd_sc_hd__fill_1
XFILLER_36_398 VPWR VGND VPWR VGND sky130_ef_sc_hd__decap_12
XFILLER_51_335 VGND VGND VPWR VPWR sky130_fd_sc_hd__fill_1
X_3925_ clknet_leaf_28_clk _0048_ VGND VGND VPWR VPWR expmiddlea\[7\] sky130_fd_sc_hd__dfxtp_1
Xclkload8 clknet_leaf_28_clk VGND VGND VPWR VPWR clkload8/Y sky130_fd_sc_hd__inv_16
X_3856_ clknet_leaf_4_clk net304 VGND VGND VPWR VPWR mantisaAshift\[41\] sky130_fd_sc_hd__dfxtp_1
X_2807_ net130 _0622_ net111 mantisaresult\[5\] VGND VGND VPWR VPWR _0749_ sky130_fd_sc_hd__a2bb2o_1
X_3787_ net255 _1574_ _1599_ net189 VGND VGND VPWR VPWR _1600_ sky130_fd_sc_hd__a211o_1
X_2738_ net138 _0672_ _0680_ VGND VGND VPWR VPWR _0681_ sky130_fd_sc_hd__a21oi_1
X_2669_ net152 net130 VGND VGND VPWR VPWR _0612_ sky130_fd_sc_hd__and2_1
Xfanout212 inf3 VGND VGND VPWR VPWR net212 sky130_fd_sc_hd__clkbuf_4
Xfanout201 _1688_ VGND VGND VPWR VPWR net201 sky130_fd_sc_hd__clkbuf_4
Xfanout223 mantisaresult\[44\] VGND VGND VPWR VPWR net223 sky130_fd_sc_hd__buf_2
Xfanout234 net236 VGND VGND VPWR VPWR net234 sky130_fd_sc_hd__clkbuf_2
Xfanout256 net257 VGND VGND VPWR VPWR net256 sky130_fd_sc_hd__clkbuf_2
Xfanout245 net248 VGND VGND VPWR VPWR net245 sky130_fd_sc_hd__buf_2
Xfanout267 expmiddle\[2\] VGND VGND VPWR VPWR net267 sky130_fd_sc_hd__buf_2
XFILLER_75_16 VGND VGND VPWR VPWR sky130_fd_sc_hd__decap_4
XFILLER_27_310 VPWR VGND VPWR VGND sky130_ef_sc_hd__decap_12
XFILLER_46_118 VGND VGND VPWR VPWR sky130_fd_sc_hd__decap_8
XFILLER_46_129 VGND VGND VPWR VPWR sky130_fd_sc_hd__decap_8
XTAP_TAPCELL_ROW_57_625 VGND VPWR sky130_fd_sc_hd__tapvpwrvgnd_1
XFILLER_27_365 VPWR VGND VPWR VGND sky130_ef_sc_hd__decap_12
XTAP_TAPCELL_ROW_65_691 VGND VPWR sky130_fd_sc_hd__tapvpwrvgnd_1
XFILLER_10_265 VPWR VGND VPWR VGND sky130_ef_sc_hd__decap_12
XFILLER_40_63 VGND VGND VPWR VPWR sky130_fd_sc_hd__decap_3
XFILLER_40_85 VGND VGND VPWR VPWR sky130_fd_sc_hd__decap_8
XFILLER_77_221 VGND VGND VPWR VPWR sky130_fd_sc_hd__decap_3
XFILLER_18_321 VPWR VGND VPWR VGND sky130_ef_sc_hd__decap_12
XFILLER_1_57 VPWR VGND VPWR VGND sky130_ef_sc_hd__decap_12
XTAP_TAPCELL_ROW_28_393 VGND VPWR sky130_fd_sc_hd__tapvpwrvgnd_1
X_3710_ _1533_ _1534_ net267 VGND VGND VPWR VPWR _1536_ sky130_fd_sc_hd__mux2_1
X_1971_ net42 VGND VGND VPWR VPWR _1666_ sky130_fd_sc_hd__inv_2
X_3641_ _1468_ _1470_ net271 VGND VGND VPWR VPWR _1471_ sky130_fd_sc_hd__mux2_1
XTAP_TAPCELL_ROW_11_260 VGND VPWR sky130_fd_sc_hd__tapvpwrvgnd_1
X_3572_ _0859_ _0936_ _1404_ _0632_ VGND VGND VPWR VPWR _1405_ sky130_fd_sc_hd__a22o_1
X_2523_ _0431_ _0463_ _0464_ _0465_ VGND VGND VPWR VPWR _0466_ sky130_fd_sc_hd__o211ai_1
X_2454_ _0324_ _0344_ _0395_ _0394_ VGND VGND VPWR VPWR _0397_ sky130_fd_sc_hd__o31ai_1
X_2385_ net227 _0316_ VGND VGND VPWR VPWR _0328_ sky130_fd_sc_hd__nor2_1
X_4124_ clknet_leaf_1_clk _0231_ VGND VGND VPWR VPWR mantisaBshift\[21\] sky130_fd_sc_hd__dfxtp_1
Xinput1 expa[0] VGND VGND VPWR VPWR net1 sky130_fd_sc_hd__buf_1
X_4055_ clknet_leaf_14_clk _0166_ VGND VGND VPWR VPWR mantisaresult\[55\] sky130_fd_sc_hd__dfxtp_2
X_3006_ net222 net156 net133 VGND VGND VPWR VPWR _0927_ sky130_fd_sc_hd__and3_1
XTAP_TAPCELL_ROW_54_606 VGND VPWR sky130_fd_sc_hd__tapvpwrvgnd_1
XFILLER_51_154 VGND VGND VPWR VPWR sky130_fd_sc_hd__decap_8
X_3908_ clknet_leaf_15_clk _0031_ VGND VGND VPWR VPWR net87 sky130_fd_sc_hd__dfxtp_1
X_3839_ net253 net187 _1571_ _1621_ VGND VGND VPWR VPWR _0258_ sky130_fd_sc_hd__o31ai_1
XFILLER_3_217 VGND VGND VPWR VPWR sky130_fd_sc_hd__decap_6
XFILLER_19_31 VGND VGND VPWR VPWR sky130_fd_sc_hd__fill_2
XFILLER_47_427 VGND VGND VPWR VPWR sky130_fd_sc_hd__fill_1
XFILLER_59_276 VGND VGND VPWR VPWR sky130_fd_sc_hd__decap_4
XTAP_TAPCELL_ROW_17_308 VGND VPWR sky130_fd_sc_hd__tapvpwrvgnd_1
XFILLER_27_162 VGND VGND VPWR VPWR sky130_fd_sc_hd__decap_6
XFILLER_15_335 VGND VGND VPWR VPWR sky130_fd_sc_hd__fill_1
XTAP_TAPCELL_ROW_25_374 VGND VPWR sky130_fd_sc_hd__tapvpwrvgnd_1
XFILLER_42_187 VGND VGND VPWR VPWR sky130_fd_sc_hd__fill_1
XFILLER_25_6 VGND VGND VPWR VPWR sky130_fd_sc_hd__decap_4
X_2170_ _1771_ _1772_ VGND VGND VPWR VPWR _1831_ sky130_fd_sc_hd__nand2_1
XFILLER_65_246 VGND VGND VPWR VPWR sky130_fd_sc_hd__fill_2
XFILLER_18_184 VGND VGND VPWR VPWR sky130_fd_sc_hd__fill_2
XFILLER_21_327 VGND VGND VPWR VPWR sky130_fd_sc_hd__decap_6
XFILLER_33_165 VGND VGND VPWR VPWR sky130_fd_sc_hd__decap_3
X_1954_ net25 VGND VGND VPWR VPWR _1649_ sky130_fd_sc_hd__inv_2
X_3624_ mantisaB0\[20\] net193 _1454_ VGND VGND VPWR VPWR _1455_ sky130_fd_sc_hd__a21oi_1
X_3555_ _0840_ _0936_ VGND VGND VPWR VPWR _1389_ sky130_fd_sc_hd__and2b_1
XFILLER_0_209 VPWR VGND VPWR VGND sky130_ef_sc_hd__decap_12
X_2506_ mantisaresult\[16\] mantisaresult\[15\] mantisaresult\[14\] VGND VGND VPWR
+ VPWR _0449_ sky130_fd_sc_hd__or3_2
X_3486_ mantisaresult\[54\] net197 net165 _1331_ VGND VGND VPWR VPWR _1332_ sky130_fd_sc_hd__a31o_1
X_2437_ _0376_ _0379_ VGND VGND VPWR VPWR _0380_ sky130_fd_sc_hd__nand2_1
XFILLER_29_427 VGND VGND VPWR VPWR sky130_fd_sc_hd__decap_8
X_2368_ net188 _0310_ VGND VGND VPWR VPWR _0311_ sky130_fd_sc_hd__nor2_2
X_4107_ clknet_leaf_1_clk _0214_ VGND VGND VPWR VPWR mantisaBshift\[15\] sky130_fd_sc_hd__dfxtp_1
X_2299_ _1920_ net346 net176 VGND VGND VPWR VPWR _0073_ sky130_fd_sc_hd__mux2_1
XFILLER_44_419 VGND VGND VPWR VPWR sky130_fd_sc_hd__fill_1
X_4038_ clknet_leaf_12_clk _0149_ VGND VGND VPWR VPWR mantisaresult\[40\] sky130_fd_sc_hd__dfxtp_1
XFILLER_37_471 VGND VGND VPWR VPWR sky130_fd_sc_hd__fill_2
XFILLER_12_305 VGND VGND VPWR VPWR sky130_fd_sc_hd__decap_3
XTAP_TAPCELL_ROW_22_344 VGND VPWR sky130_fd_sc_hd__tapvpwrvgnd_1
XFILLER_21_87 VGND VGND VPWR VPWR sky130_fd_sc_hd__fill_2
XFILLER_79_305 VGND VGND VPWR VPWR sky130_fd_sc_hd__decap_3
XFILLER_47_246 VGND VGND VPWR VPWR sky130_fd_sc_hd__fill_1
XTAP_TAPCELL_ROW_73_756 VGND VPWR sky130_fd_sc_hd__tapvpwrvgnd_1
XFILLER_30_179 VGND VGND VPWR VPWR sky130_fd_sc_hd__decap_6
XFILLER_11_393 VGND VGND VPWR VPWR sky130_fd_sc_hd__decap_6
XFILLER_11_360 VGND VGND VPWR VPWR sky130_fd_sc_hd__fill_1
X_3340_ _1210_ _1214_ VGND VGND VPWR VPWR _1215_ sky130_fd_sc_hd__xnor2_1
X_3271_ _1151_ _1149_ net245 VGND VGND VPWR VPWR _1152_ sky130_fd_sc_hd__mux2_1
X_2222_ net300 net178 _1869_ VGND VGND VPWR VPWR _0047_ sky130_fd_sc_hd__o21a_1
XFILLER_23_3 VGND VGND VPWR VPWR sky130_fd_sc_hd__decap_8
XFILLER_38_224 VGND VGND VPWR VPWR sky130_fd_sc_hd__fill_2
XFILLER_38_246 VGND VGND VPWR VPWR sky130_fd_sc_hd__fill_1
X_2153_ net19 _1666_ _1669_ net20 _1812_ VGND VGND VPWR VPWR _1814_ sky130_fd_sc_hd__a221o_1
X_2084_ net210 net342 VGND VGND VPWR VPWR _0024_ sky130_fd_sc_hd__and2b_1
XFILLER_34_441 VGND VGND VPWR VPWR sky130_fd_sc_hd__decap_6
XTAP_TAPCELL_ROW_36_458 VGND VPWR sky130_fd_sc_hd__tapvpwrvgnd_1
XFILLER_21_113 VGND VGND VPWR VPWR sky130_fd_sc_hd__decap_8
X_2986_ net238 mantisaBshift\[10\] _0909_ net232 VGND VGND VPWR VPWR _0911_ sky130_fd_sc_hd__a31o_1
X_1937_ mantisaresult\[10\] VGND VGND VPWR VPWR _1632_ sky130_fd_sc_hd__inv_2
X_3607_ _1424_ _1436_ net265 VGND VGND VPWR VPWR _1438_ sky130_fd_sc_hd__mux2_1
X_3538_ net157 _1372_ _1373_ VGND VGND VPWR VPWR _1374_ sky130_fd_sc_hd__and3_1
X_3469_ _0534_ _0554_ _0544_ VGND VGND VPWR VPWR _1320_ sky130_fd_sc_hd__o21ai_1
XFILLER_67_39 VGND VGND VPWR VPWR sky130_fd_sc_hd__fill_1
XFILLER_69_393 VGND VGND VPWR VPWR sky130_fd_sc_hd__fill_2
XFILLER_16_21 VGND VGND VPWR VPWR sky130_fd_sc_hd__decap_6
XFILLER_16_65 VGND VGND VPWR VPWR sky130_fd_sc_hd__fill_1
XFILLER_40_433 VGND VGND VPWR VPWR sky130_fd_sc_hd__fill_1
XFILLER_8_117 VGND VGND VPWR VPWR sky130_fd_sc_hd__decap_4
XFILLER_79_113 VPWR VGND VPWR VGND sky130_ef_sc_hd__decap_12
XFILLER_79_179 VPWR VGND VPWR VGND sky130_ef_sc_hd__decap_12
XFILLER_75_385 VGND VGND VPWR VPWR sky130_fd_sc_hd__decap_6
XFILLER_28_290 VGND VGND VPWR VPWR sky130_fd_sc_hd__fill_2
XFILLER_31_422 VPWR VGND VPWR VGND sky130_ef_sc_hd__decap_12
XTAP_TAPCELL_ROW_33_439 VGND VPWR sky130_fd_sc_hd__tapvpwrvgnd_1
X_2840_ net226 net155 VGND VGND VPWR VPWR _0781_ sky130_fd_sc_hd__nand2_1
X_2771_ mantisaresult\[20\] net107 _0687_ net131 VGND VGND VPWR VPWR _0713_ sky130_fd_sc_hd__a22o_1
Xhold106 mantisaB0\[13\] VGND VGND VPWR VPWR net380 sky130_fd_sc_hd__dlygate4sd3_1
XFILLER_7_161 VGND VGND VPWR VPWR sky130_fd_sc_hd__decap_6
XPHY_EDGE_ROW_9_Right_9 VGND VGND VPWR VPWR sky130_fd_sc_hd__decap_3
X_3323_ _1198_ VGND VGND VPWR VPWR _1199_ sky130_fd_sc_hd__inv_2
X_3254_ _1122_ _1129_ _1124_ VGND VGND VPWR VPWR _1136_ sky130_fd_sc_hd__a21o_1
X_2205_ net99 _1859_ VGND VGND VPWR VPWR _1860_ sky130_fd_sc_hd__nand2_1
X_3185_ net224 net236 _1072_ _1073_ VGND VGND VPWR VPWR _0152_ sky130_fd_sc_hd__a22o_1
XFILLER_66_363 VGND VGND VPWR VPWR sky130_fd_sc_hd__fill_1
XFILLER_26_205 VGND VGND VPWR VPWR sky130_fd_sc_hd__decap_3
XTAP_TAPCELL_ROW_49_561 VGND VPWR sky130_fd_sc_hd__tapvpwrvgnd_1
X_2136_ net28 _1656_ _1657_ net17 VGND VGND VPWR VPWR _1797_ sky130_fd_sc_hd__a22o_1
X_2067_ expmiddled\[7\] net388 VGND VGND VPWR VPWR _1753_ sky130_fd_sc_hd__xnor2_1
X_2969_ mantisaBshift\[4\] mantisaBshift\[5\] _0893_ net239 VGND VGND VPWR VPWR _0898_
+ sky130_fd_sc_hd__o31a_1
XFILLER_1_337 VGND VGND VPWR VPWR sky130_fd_sc_hd__fill_2
XFILLER_57_374 VGND VGND VPWR VPWR sky130_fd_sc_hd__fill_2
XFILLER_72_300 VGND VGND VPWR VPWR sky130_fd_sc_hd__decap_8
XFILLER_72_333 VPWR VGND VPWR VGND sky130_ef_sc_hd__decap_12
XFILLER_32_208 VGND VGND VPWR VPWR sky130_fd_sc_hd__fill_1
XFILLER_72_377 VPWR VGND VPWR VGND sky130_ef_sc_hd__decap_12
XTAP_TAPCELL_ROW_30_409 VGND VPWR sky130_fd_sc_hd__tapvpwrvgnd_1
XFILLER_40_274 VPWR VGND VPWR VGND sky130_ef_sc_hd__decap_12
XFILLER_4_153 VPWR VGND VPWR VGND sky130_ef_sc_hd__decap_12
XFILLER_4_197 VPWR VGND VPWR VGND sky130_ef_sc_hd__decap_12
XFILLER_48_341 VGND VGND VPWR VPWR sky130_fd_sc_hd__decap_8
XFILLER_48_363 VGND VGND VPWR VPWR sky130_fd_sc_hd__fill_1
XTAP_TAPCELL_ROW_46_542 VGND VPWR sky130_fd_sc_hd__tapvpwrvgnd_1
XFILLER_23_219 VGND VGND VPWR VPWR sky130_fd_sc_hd__decap_4
X_3941_ clknet_leaf_8_clk _0064_ VGND VGND VPWR VPWR mantisaA0\[15\] sky130_fd_sc_hd__dfxtp_1
X_3872_ clknet_leaf_9_clk net294 VGND VGND VPWR VPWR mantisaAshift\[57\] sky130_fd_sc_hd__dfxtp_1
X_2823_ _0671_ _0675_ net116 VGND VGND VPWR VPWR _0764_ sky130_fd_sc_hd__mux2_1
X_2754_ net148 _0696_ _0690_ VGND VGND VPWR VPWR _0697_ sky130_fd_sc_hd__o21ai_1
X_2685_ net123 _0627_ VGND VGND VPWR VPWR _0628_ sky130_fd_sc_hd__nand2_1
XPHY_EDGE_ROW_18_Left_98 VGND VGND VPWR VPWR sky130_fd_sc_hd__decap_3
X_3306_ mantisaresult\[49\] net155 net133 VGND VGND VPWR VPWR _1183_ sky130_fd_sc_hd__and3_1
XFILLER_58_138 VGND VGND VPWR VPWR sky130_fd_sc_hd__fill_2
X_3237_ _1116_ _1120_ VGND VGND VPWR VPWR _1121_ sky130_fd_sc_hd__xor2_1
X_3168_ _1056_ _1057_ VGND VGND VPWR VPWR _1058_ sky130_fd_sc_hd__nand2b_1
XFILLER_64_18 VGND VGND VPWR VPWR sky130_fd_sc_hd__fill_1
X_2119_ _1757_ _1778_ VGND VGND VPWR VPWR _1780_ sky130_fd_sc_hd__or2_1
XFILLER_64_29 VGND VGND VPWR VPWR sky130_fd_sc_hd__fill_2
XFILLER_14_219 VGND VGND VPWR VPWR sky130_fd_sc_hd__fill_2
XTAP_TAPCELL_ROW_1_178 VGND VPWR sky130_fd_sc_hd__tapvpwrvgnd_1
X_3099_ mantisaresult\[30\] _1001_ net202 VGND VGND VPWR VPWR _0138_ sky130_fd_sc_hd__mux2_1
XTAP_TAPCELL_ROW_52_589 VGND VPWR sky130_fd_sc_hd__tapvpwrvgnd_1
XFILLER_13_55 VGND VGND VPWR VPWR sky130_fd_sc_hd__fill_1
XFILLER_10_469 VGND VGND VPWR VPWR sky130_fd_sc_hd__decap_4
XFILLER_6_418 VGND VGND VPWR VPWR sky130_fd_sc_hd__fill_2
XTAP_TAPCELL_ROW_9_245 VGND VPWR sky130_fd_sc_hd__tapvpwrvgnd_1
XFILLER_1_167 VGND VGND VPWR VPWR sky130_fd_sc_hd__fill_1
XFILLER_77_447 VGND VGND VPWR VPWR sky130_fd_sc_hd__fill_1
XFILLER_38_41 VPWR VGND VPWR VGND sky130_ef_sc_hd__decap_12
XFILLER_38_85 VGND VGND VPWR VPWR sky130_fd_sc_hd__fill_2
XFILLER_45_311 VGND VGND VPWR VPWR sky130_fd_sc_hd__decap_8
XFILLER_72_141 VGND VGND VPWR VPWR sky130_fd_sc_hd__decap_4
XTAP_TAPCELL_ROW_43_512 VGND VPWR sky130_fd_sc_hd__tapvpwrvgnd_1
XFILLER_9_234 VGND VGND VPWR VPWR sky130_fd_sc_hd__decap_6
Xclkload26 clknet_leaf_17_clk VGND VGND VPWR VPWR clkload26/Y sky130_fd_sc_hd__clkinv_2
Xclkload15 clknet_leaf_9_clk VGND VGND VPWR VPWR clkload15/Y sky130_fd_sc_hd__inv_8
X_2470_ _0389_ _0393_ _0396_ _0405_ VGND VGND VPWR VPWR _0413_ sky130_fd_sc_hd__and4_1
XFILLER_55_6 VPWR VGND VPWR VGND sky130_ef_sc_hd__decap_12
XFILLER_79_81 VGND VGND VPWR VPWR sky130_fd_sc_hd__decap_3
X_4140_ clknet_leaf_3_clk _0247_ VGND VGND VPWR VPWR mantisaBshift\[37\] sky130_fd_sc_hd__dfxtp_1
XFILLER_68_447 VGND VGND VPWR VPWR sky130_fd_sc_hd__fill_2
X_4071_ clknet_leaf_21_clk _0180_ VGND VGND VPWR VPWR expmiddled\[4\] sky130_fd_sc_hd__dfxtp_1
X_3022_ net221 net194 net162 net216 VGND VGND VPWR VPWR _0943_ sky130_fd_sc_hd__a31o_1
XFILLER_51_314 VGND VGND VPWR VPWR sky130_fd_sc_hd__decap_8
X_3924_ clknet_leaf_26_clk _0047_ VGND VGND VPWR VPWR expmiddlea\[6\] sky130_fd_sc_hd__dfxtp_1
XTAP_TAPCELL_ROW_14_280 VGND VPWR sky130_fd_sc_hd__tapvpwrvgnd_1
Xclkload9 clknet_leaf_29_clk VGND VGND VPWR VPWR clkload9/Y sky130_fd_sc_hd__clkinv_8
X_3855_ clknet_leaf_4_clk net301 VGND VGND VPWR VPWR mantisaAshift\[40\] sky130_fd_sc_hd__dfxtp_1
X_2806_ _0746_ _0747_ net115 VGND VGND VPWR VPWR _0748_ sky130_fd_sc_hd__mux2_1
X_3786_ net255 _1577_ VGND VGND VPWR VPWR _1599_ sky130_fd_sc_hd__nor2_1
X_2737_ net138 _0679_ VGND VGND VPWR VPWR _0680_ sky130_fd_sc_hd__and2b_1
X_2668_ expmiddlec\[0\] net166 _0601_ VGND VGND VPWR VPWR _0611_ sky130_fd_sc_hd__mux2_1
Xfanout213 inf2 VGND VGND VPWR VPWR net213 sky130_fd_sc_hd__buf_2
X_2599_ _0469_ _0504_ _0505_ _0531_ VGND VGND VPWR VPWR _0542_ sky130_fd_sc_hd__and4b_1
Xfanout202 _1688_ VGND VGND VPWR VPWR net202 sky130_fd_sc_hd__buf_2
Xfanout246 net247 VGND VGND VPWR VPWR net246 sky130_fd_sc_hd__buf_2
Xfanout235 net236 VGND VGND VPWR VPWR net235 sky130_fd_sc_hd__clkbuf_4
Xfanout224 mantisaresult\[43\] VGND VGND VPWR VPWR net224 sky130_fd_sc_hd__buf_2
Xfanout257 expmiddle\[4\] VGND VGND VPWR VPWR net257 sky130_fd_sc_hd__clkbuf_2
Xfanout268 net269 VGND VGND VPWR VPWR net268 sky130_fd_sc_hd__buf_2
XTAP_TAPCELL_ROW_57_626 VGND VPWR sky130_fd_sc_hd__tapvpwrvgnd_1
XFILLER_27_322 VGND VGND VPWR VPWR sky130_fd_sc_hd__fill_2
XFILLER_27_333 VGND VGND VPWR VPWR sky130_fd_sc_hd__decap_3
XFILLER_27_377 VPWR VGND VPWR VGND sky130_ef_sc_hd__decap_12
XFILLER_54_141 VPWR VGND VPWR VGND sky130_ef_sc_hd__decap_12
XTAP_TAPCELL_ROW_65_692 VGND VPWR sky130_fd_sc_hd__tapvpwrvgnd_1
XFILLER_42_347 VPWR VGND VPWR VGND sky130_ef_sc_hd__decap_12
XFILLER_10_277 VGND VGND VPWR VPWR sky130_fd_sc_hd__fill_1
XFILLER_2_421 VPWR VGND VPWR VGND sky130_ef_sc_hd__decap_12
XFILLER_18_333 VPWR VGND VPWR VGND sky130_ef_sc_hd__decap_12
XFILLER_1_69 VPWR VGND VPWR VGND sky130_ef_sc_hd__decap_12
XFILLER_65_50 VGND VGND VPWR VPWR sky130_fd_sc_hd__decap_6
XFILLER_73_461 VPWR VGND VPWR VGND sky130_ef_sc_hd__decap_12
XFILLER_60_111 VGND VGND VPWR VPWR sky130_fd_sc_hd__fill_1
XTAP_TAPCELL_ROW_28_394 VGND VPWR sky130_fd_sc_hd__tapvpwrvgnd_1
X_1970_ net61 VGND VGND VPWR VPWR _1665_ sky130_fd_sc_hd__inv_2
X_3640_ _1469_ VGND VGND VPWR VPWR _1470_ sky130_fd_sc_hd__inv_2
XTAP_TAPCELL_ROW_11_261 VGND VPWR sky130_fd_sc_hd__tapvpwrvgnd_1
X_3571_ _1307_ _1403_ net124 VGND VGND VPWR VPWR _1404_ sky130_fd_sc_hd__mux2_1
X_2522_ _0435_ _0442_ _0453_ _0454_ _0452_ VGND VGND VPWR VPWR _0465_ sky130_fd_sc_hd__o41a_1
X_2453_ _0324_ _0344_ _0395_ _0394_ VGND VGND VPWR VPWR _0396_ sky130_fd_sc_hd__o31a_1
X_2384_ _0324_ _0325_ VGND VGND VPWR VPWR _0327_ sky130_fd_sc_hd__or2_1
X_4123_ clknet_leaf_1_clk _0230_ VGND VGND VPWR VPWR mantisaBshift\[22\] sky130_fd_sc_hd__dfxtp_1
Xinput2 expa[1] VGND VGND VPWR VPWR net2 sky130_fd_sc_hd__buf_1
X_4054_ clknet_leaf_10_clk _0165_ VGND VGND VPWR VPWR mantisaresult\[54\] sky130_fd_sc_hd__dfxtp_2
X_3005_ net150 net149 VGND VGND VPWR VPWR _0926_ sky130_fd_sc_hd__or2_2
XTAP_TAPCELL_ROW_54_607 VGND VPWR sky130_fd_sc_hd__tapvpwrvgnd_1
XFILLER_36_174 VGND VGND VPWR VPWR sky130_fd_sc_hd__decap_4
XFILLER_24_347 VGND VGND VPWR VPWR sky130_fd_sc_hd__decap_8
XFILLER_51_166 VGND VGND VPWR VPWR sky130_fd_sc_hd__fill_2
X_3907_ clknet_leaf_15_clk _0030_ VGND VGND VPWR VPWR net86 sky130_fd_sc_hd__dfxtp_1
X_3838_ net253 _1570_ _1620_ net191 VGND VGND VPWR VPWR _1621_ sky130_fd_sc_hd__a211o_1
X_3769_ _1423_ _1429_ _1434_ _1445_ net269 net265 VGND VGND VPWR VPWR _1586_ sky130_fd_sc_hd__mux4_1
XTAP_TAPCELL_ROW_17_309 VGND VPWR sky130_fd_sc_hd__tapvpwrvgnd_1
XFILLER_35_31 VGND VGND VPWR VPWR sky130_fd_sc_hd__decap_3
XTAP_TAPCELL_ROW_25_375 VGND VPWR sky130_fd_sc_hd__tapvpwrvgnd_1
XFILLER_23_391 VGND VGND VPWR VPWR sky130_fd_sc_hd__fill_1
XFILLER_2_251 VGND VGND VPWR VPWR sky130_fd_sc_hd__fill_1
XFILLER_38_428 VPWR VGND VPWR VGND sky130_ef_sc_hd__decap_12
XTAP_TAPCELL_ROW_76_776 VGND VPWR sky130_fd_sc_hd__tapvpwrvgnd_1
XFILLER_65_269 VGND VGND VPWR VPWR sky130_fd_sc_hd__decap_8
X_1953_ mantisaresult\[1\] VGND VGND VPWR VPWR _1648_ sky130_fd_sc_hd__inv_2
X_3623_ net251 mantisaB0\[21\] net274 VGND VGND VPWR VPWR _1454_ sky130_fd_sc_hd__and3b_1
X_3554_ _0831_ _0845_ net125 VGND VGND VPWR VPWR _1388_ sky130_fd_sc_hd__mux2_1
X_2505_ mantisaresult\[8\] mantisaresult\[9\] _0364_ _0374_ VGND VGND VPWR VPWR _0448_
+ sky130_fd_sc_hd__or4_1
X_3485_ mantisaresult\[53\] net195 net160 net215 VGND VGND VPWR VPWR _1331_ sky130_fd_sc_hd__a31o_1
X_2436_ _0338_ _0348_ _0377_ _0378_ VGND VGND VPWR VPWR _0379_ sky130_fd_sc_hd__or4_1
X_2367_ mantisaresult\[51\] mantisaresult\[50\] mantisaresult\[49\] VGND VGND VPWR
+ VPWR _0310_ sky130_fd_sc_hd__or3_4
XTAP_TAPCELL_ROW_67_710 VGND VPWR sky130_fd_sc_hd__tapvpwrvgnd_1
X_4106_ clknet_leaf_1_clk _0213_ VGND VGND VPWR VPWR mantisaBshift\[16\] sky130_fd_sc_hd__dfxtp_1
X_2298_ _1875_ net28 net102 VGND VGND VPWR VPWR _1920_ sky130_fd_sc_hd__mux2_1
XFILLER_56_236 VPWR VGND VPWR VGND sky130_ef_sc_hd__decap_12
X_4037_ clknet_leaf_12_clk _0148_ VGND VGND VPWR VPWR mantisaresult\[39\] sky130_fd_sc_hd__dfxtp_2
XFILLER_56_258 VPWR VGND VPWR VGND sky130_ef_sc_hd__decap_12
XTAP_TAPCELL_ROW_22_345 VGND VPWR sky130_fd_sc_hd__tapvpwrvgnd_1
XFILLER_21_44 VGND VGND VPWR VPWR sky130_fd_sc_hd__decap_3
XFILLER_21_55 VGND VGND VPWR VPWR sky130_fd_sc_hd__fill_1
XFILLER_21_99 VPWR VGND VPWR VGND sky130_ef_sc_hd__decap_12
XPHY_EDGE_ROW_6_Left_86 VGND VGND VPWR VPWR sky130_fd_sc_hd__decap_3
XFILLER_47_269 VGND VGND VPWR VPWR sky130_fd_sc_hd__decap_8
XFILLER_46_74 VGND VGND VPWR VPWR sky130_fd_sc_hd__decap_8
XFILLER_46_85 VPWR VGND VPWR VGND sky130_ef_sc_hd__decap_12
XTAP_TAPCELL_ROW_73_757 VGND VPWR sky130_fd_sc_hd__tapvpwrvgnd_1
XFILLER_30_103 VGND VGND VPWR VPWR sky130_fd_sc_hd__fill_1
XFILLER_7_57 VPWR VGND VPWR VGND sky130_ef_sc_hd__decap_12
X_3270_ _1132_ _1136_ _1134_ VGND VGND VPWR VPWR _1151_ sky130_fd_sc_hd__a21o_1
X_2221_ net7 net15 net99 VGND VGND VPWR VPWR _1869_ sky130_fd_sc_hd__mux2_1
X_2152_ _1808_ _1811_ _1810_ VGND VGND VPWR VPWR _1813_ sky130_fd_sc_hd__or3b_1
X_2083_ net209 net338 VGND VGND VPWR VPWR _0023_ sky130_fd_sc_hd__and2b_1
XFILLER_19_461 VPWR VGND VPWR VGND sky130_ef_sc_hd__decap_12
XTAP_TAPCELL_ROW_36_459 VGND VPWR sky130_fd_sc_hd__tapvpwrvgnd_1
XFILLER_61_250 VPWR VGND VPWR VGND sky130_ef_sc_hd__decap_12
X_2985_ net238 _0909_ mantisaBshift\[10\] VGND VGND VPWR VPWR _0910_ sky130_fd_sc_hd__a21oi_1
XFILLER_21_169 VGND VGND VPWR VPWR sky130_fd_sc_hd__decap_6
X_1936_ mantisaresult\[13\] VGND VGND VPWR VPWR _1631_ sky130_fd_sc_hd__inv_2
X_3606_ _1436_ VGND VGND VPWR VPWR _1437_ sky130_fd_sc_hd__inv_2
Xinput60 mantisaB[7] VGND VGND VPWR VPWR net60 sky130_fd_sc_hd__buf_1
X_3537_ _0786_ _0936_ _0793_ net126 VGND VGND VPWR VPWR _1373_ sky130_fd_sc_hd__o2bb2a_1
X_3468_ net208 net159 VGND VGND VPWR VPWR _1319_ sky130_fd_sc_hd__and2_1
XFILLER_76_309 VPWR VGND VPWR VGND sky130_ef_sc_hd__decap_12
X_2419_ mantisaresult\[21\] mantisaresult\[20\] mantisaresult\[19\] VGND VGND VPWR
+ VPWR _0362_ sky130_fd_sc_hd__or3_1
X_3399_ mantisaAshift\[61\] mantisaBshift\[61\] VGND VGND VPWR VPWR _1268_ sky130_fd_sc_hd__xor2_1
XFILLER_29_258 VGND VGND VPWR VPWR sky130_fd_sc_hd__decap_4
XFILLER_25_431 VGND VGND VPWR VPWR sky130_fd_sc_hd__decap_6
XFILLER_16_77 VGND VGND VPWR VPWR sky130_fd_sc_hd__decap_6
XFILLER_12_158 VGND VGND VPWR VPWR sky130_fd_sc_hd__fill_1
XFILLER_79_125 VPWR VGND VPWR VGND sky130_ef_sc_hd__decap_12
XFILLER_79_169 VGND VGND VPWR VPWR sky130_fd_sc_hd__decap_6
XFILLER_31_401 VPWR VGND VPWR VGND sky130_ef_sc_hd__decap_12
XFILLER_50_209 VPWR VGND VPWR VGND sky130_ef_sc_hd__decap_12
XFILLER_31_434 VPWR VGND VPWR VGND sky130_ef_sc_hd__decap_12
X_2770_ mantisaresult\[18\] net107 _0684_ net131 VGND VGND VPWR VPWR _0712_ sky130_fd_sc_hd__a22o_1
Xhold107 mantisaB0\[12\] VGND VGND VPWR VPWR net381 sky130_fd_sc_hd__dlygate4sd3_1
X_3322_ _1196_ _1197_ VGND VGND VPWR VPWR _1198_ sky130_fd_sc_hd__nand2b_1
XFILLER_58_309 VPWR VGND VPWR VGND sky130_ef_sc_hd__decap_12
X_3253_ _1133_ _1134_ VGND VGND VPWR VPWR _1135_ sky130_fd_sc_hd__nor2_1
X_2204_ _1767_ _1794_ _1768_ VGND VGND VPWR VPWR _1859_ sky130_fd_sc_hd__a21o_1
X_3184_ _1067_ _1071_ net235 VGND VGND VPWR VPWR _1073_ sky130_fd_sc_hd__a21oi_1
X_2135_ net33 _1658_ VGND VGND VPWR VPWR _1796_ sky130_fd_sc_hd__or2_1
XFILLER_26_217 VGND VGND VPWR VPWR sky130_fd_sc_hd__decap_4
XTAP_TAPCELL_ROW_49_562 VGND VPWR sky130_fd_sc_hd__tapvpwrvgnd_1
X_2066_ _1748_ _1749_ _1747_ VGND VGND VPWR VPWR _1752_ sky130_fd_sc_hd__a21bo_1
XFILLER_22_401 VGND VGND VPWR VPWR sky130_fd_sc_hd__decap_8
XFILLER_34_250 VGND VGND VPWR VPWR sky130_fd_sc_hd__fill_2
XFILLER_34_261 VGND VGND VPWR VPWR sky130_fd_sc_hd__decap_8
XFILLER_34_294 VPWR VGND VPWR VGND sky130_ef_sc_hd__decap_12
X_2968_ mantisaresult\[5\] _0897_ net201 VGND VGND VPWR VPWR _0111_ sky130_fd_sc_hd__mux2_1
X_2899_ net144 _0837_ VGND VGND VPWR VPWR _0838_ sky130_fd_sc_hd__nor2_1
XFILLER_57_364 VGND VGND VPWR VPWR sky130_fd_sc_hd__fill_1
XFILLER_72_345 VPWR VGND VPWR VGND sky130_ef_sc_hd__decap_12
XFILLER_27_98 VGND VGND VPWR VPWR sky130_fd_sc_hd__fill_1
XFILLER_72_389 VPWR VGND VPWR VGND sky130_ef_sc_hd__decap_12
XFILLER_9_449 VPWR VGND VPWR VGND sky130_ef_sc_hd__decap_12
XFILLER_40_286 VPWR VGND VPWR VGND sky130_ef_sc_hd__decap_12
XFILLER_4_121 VPWR VGND VPWR VGND sky130_ef_sc_hd__decap_12
XFILLER_4_165 VPWR VGND VPWR VGND sky130_ef_sc_hd__decap_12
XFILLER_0_393 VGND VGND VPWR VPWR sky130_fd_sc_hd__decap_8
XTAP_TAPCELL_ROW_46_543 VGND VPWR sky130_fd_sc_hd__tapvpwrvgnd_1
X_3940_ clknet_leaf_7_clk _0063_ VGND VGND VPWR VPWR mantisaA0\[14\] sky130_fd_sc_hd__dfxtp_1
X_3871_ clknet_leaf_9_clk net296 VGND VGND VPWR VPWR mantisaAshift\[56\] sky130_fd_sc_hd__dfxtp_1
X_2822_ net326 net208 _0759_ _0763_ VGND VGND VPWR VPWR _0099_ sky130_fd_sc_hd__o22a_1
XFILLER_31_275 VGND VGND VPWR VPWR sky130_fd_sc_hd__decap_4
X_2753_ net117 _0691_ _0695_ VGND VGND VPWR VPWR _0696_ sky130_fd_sc_hd__o21ai_1
X_2684_ net139 _0618_ _0626_ VGND VGND VPWR VPWR _0627_ sky130_fd_sc_hd__a21oi_1
XFILLER_58_106 VGND VGND VPWR VPWR sky130_fd_sc_hd__decap_8
X_3305_ net218 _1182_ net204 VGND VGND VPWR VPWR _0163_ sky130_fd_sc_hd__mux2_1
XFILLER_39_353 VGND VGND VPWR VPWR sky130_fd_sc_hd__decap_8
X_3236_ _1117_ _1119_ net245 VGND VGND VPWR VPWR _1120_ sky130_fd_sc_hd__mux2_1
XFILLER_54_301 VGND VGND VPWR VPWR sky130_fd_sc_hd__decap_3
X_3167_ mantisaAshift\[42\] mantisaBshift\[42\] VGND VGND VPWR VPWR _1057_ sky130_fd_sc_hd__nand2_1
X_2118_ _1778_ _1755_ VGND VGND VPWR VPWR _1779_ sky130_fd_sc_hd__nand2b_1
X_3098_ mantisaBshift\[30\] _1000_ VGND VGND VPWR VPWR _1001_ sky130_fd_sc_hd__xnor2_1
XTAP_TAPCELL_ROW_1_179 VGND VPWR sky130_fd_sc_hd__tapvpwrvgnd_1
X_2049_ expmiddled\[4\] expadd\[4\] VGND VGND VPWR VPWR _1738_ sky130_fd_sc_hd__or2_1
XTAP_TAPCELL_ROW_9_246 VGND VPWR sky130_fd_sc_hd__tapvpwrvgnd_1
XFILLER_1_113 VPWR VGND VPWR VGND sky130_ef_sc_hd__decap_12
XFILLER_38_53 VGND VGND VPWR VPWR sky130_fd_sc_hd__decap_3
XFILLER_72_131 VGND VGND VPWR VPWR sky130_fd_sc_hd__decap_3
XFILLER_45_356 VGND VGND VPWR VPWR sky130_fd_sc_hd__decap_3
XTAP_TAPCELL_ROW_43_513 VGND VPWR sky130_fd_sc_hd__tapvpwrvgnd_1
XFILLER_54_52 VGND VGND VPWR VPWR sky130_fd_sc_hd__fill_1
XFILLER_72_197 VPWR VGND VPWR VGND sky130_ef_sc_hd__decap_12
XFILLER_54_85 VGND VGND VPWR VPWR sky130_fd_sc_hd__decap_6
XFILLER_70_62 VPWR VGND VPWR VGND sky130_ef_sc_hd__decap_12
Xclkload16 clknet_leaf_10_clk VGND VGND VPWR VPWR clkload16/Y sky130_fd_sc_hd__inv_16
X_4070_ clknet_leaf_20_clk _0179_ VGND VGND VPWR VPWR expmiddled\[3\] sky130_fd_sc_hd__dfxtp_1
X_3021_ _0934_ _0941_ net159 VGND VGND VPWR VPWR _0942_ sky130_fd_sc_hd__o21a_1
X_3923_ clknet_leaf_26_clk _0046_ VGND VGND VPWR VPWR expmiddlea\[5\] sky130_fd_sc_hd__dfxtp_1
X_3854_ clknet_leaf_4_clk net281 VGND VGND VPWR VPWR mantisaAshift\[39\] sky130_fd_sc_hd__dfxtp_1
X_2805_ net131 _0619_ net111 mantisaresult\[3\] VGND VGND VPWR VPWR _0747_ sky130_fd_sc_hd__a2bb2o_1
XTAP_TAPCELL_ROW_14_281 VGND VPWR sky130_fd_sc_hd__tapvpwrvgnd_1
X_3785_ net186 _1598_ VGND VGND VPWR VPWR _0227_ sky130_fd_sc_hd__nor2_1
X_2736_ _0675_ _0678_ net116 VGND VGND VPWR VPWR _0679_ sky130_fd_sc_hd__mux2_1
X_2667_ net152 VGND VGND VPWR VPWR _0610_ sky130_fd_sc_hd__inv_2
X_2598_ _0373_ _0540_ _0527_ VGND VGND VPWR VPWR _0541_ sky130_fd_sc_hd__o21ai_1
Xfanout214 net318 VGND VGND VPWR VPWR net214 sky130_fd_sc_hd__clkbuf_2
XTAP_TAPCELL_ROW_6_216 VGND VPWR sky130_fd_sc_hd__tapvpwrvgnd_1
Xfanout203 net204 VGND VGND VPWR VPWR net203 sky130_fd_sc_hd__clkbuf_4
Xfanout236 inf1 VGND VGND VPWR VPWR net236 sky130_fd_sc_hd__buf_2
Xfanout225 mantisaresult\[42\] VGND VGND VPWR VPWR net225 sky130_fd_sc_hd__buf_2
Xfanout247 net248 VGND VGND VPWR VPWR net247 sky130_fd_sc_hd__buf_2
Xfanout269 expmiddle\[2\] VGND VGND VPWR VPWR net269 sky130_fd_sc_hd__buf_2
Xfanout258 net259 VGND VGND VPWR VPWR net258 sky130_fd_sc_hd__buf_2
XFILLER_39_150 VGND VGND VPWR VPWR sky130_fd_sc_hd__decap_6
XTAP_TAPCELL_ROW_57_627 VGND VPWR sky130_fd_sc_hd__tapvpwrvgnd_1
X_3219_ net222 _1104_ net205 VGND VGND VPWR VPWR _0155_ sky130_fd_sc_hd__mux2_1
XFILLER_39_172 VGND VGND VPWR VPWR sky130_fd_sc_hd__fill_1
XFILLER_54_153 VPWR VGND VPWR VGND sky130_ef_sc_hd__decap_12
XFILLER_27_389 VGND VGND VPWR VPWR sky130_fd_sc_hd__decap_3
XFILLER_42_304 VGND VGND VPWR VPWR sky130_fd_sc_hd__decap_4
XFILLER_42_337 VGND VGND VPWR VPWR sky130_fd_sc_hd__fill_1
XFILLER_54_197 VPWR VGND VPWR VGND sky130_ef_sc_hd__decap_12
XTAP_TAPCELL_ROW_65_693 VGND VPWR sky130_fd_sc_hd__tapvpwrvgnd_1
XFILLER_42_359 VGND VGND VPWR VPWR sky130_fd_sc_hd__decap_4
XFILLER_2_433 VPWR VGND VPWR VGND sky130_ef_sc_hd__decap_12
XFILLER_1_15 VPWR VGND VPWR VGND sky130_ef_sc_hd__decap_12
XFILLER_18_356 VGND VGND VPWR VPWR sky130_fd_sc_hd__fill_1
XFILLER_18_345 VGND VGND VPWR VPWR sky130_fd_sc_hd__decap_6
XFILLER_65_73 VGND VGND VPWR VPWR sky130_fd_sc_hd__decap_6
XFILLER_33_304 VGND VGND VPWR VPWR sky130_fd_sc_hd__fill_1
XFILLER_33_337 VGND VGND VPWR VPWR sky130_fd_sc_hd__decap_4
XTAP_TAPCELL_ROW_28_395 VGND VPWR sky130_fd_sc_hd__tapvpwrvgnd_1
XFILLER_33_348 VPWR VGND VPWR VGND sky130_ef_sc_hd__decap_12
XTAP_TAPCELL_ROW_11_262 VGND VPWR sky130_fd_sc_hd__tapvpwrvgnd_1
X_3570_ _1402_ _1358_ net147 VGND VGND VPWR VPWR _1403_ sky130_fd_sc_hd__mux2_1
X_2521_ _1648_ _0367_ _0439_ _0443_ VGND VGND VPWR VPWR _0464_ sky130_fd_sc_hd__or4_1
X_2452_ net221 net222 net227 mantisaresult\[39\] VGND VGND VPWR VPWR _0395_ sky130_fd_sc_hd__or4b_1
XPHY_EDGE_ROW_18_Right_18 VGND VGND VPWR VPWR sky130_fd_sc_hd__decap_3
X_2383_ _0324_ _0325_ VGND VGND VPWR VPWR _0326_ sky130_fd_sc_hd__nor2_1
XFILLER_68_212 VGND VGND VPWR VPWR sky130_fd_sc_hd__decap_3
X_4122_ clknet_leaf_2_clk _0229_ VGND VGND VPWR VPWR mantisaBshift\[23\] sky130_fd_sc_hd__dfxtp_1
X_4053_ clknet_leaf_16_clk _0164_ VGND VGND VPWR VPWR four_man\[50\] sky130_fd_sc_hd__dfxtp_1
Xinput3 expa[2] VGND VGND VPWR VPWR net3 sky130_fd_sc_hd__clkbuf_1
X_3004_ net150 _0604_ VGND VGND VPWR VPWR _0925_ sky130_fd_sc_hd__nor2_4
XFILLER_24_315 VGND VGND VPWR VPWR sky130_fd_sc_hd__decap_8
XFILLER_24_337 VGND VGND VPWR VPWR sky130_fd_sc_hd__fill_1
XPHY_EDGE_ROW_27_Right_27 VGND VGND VPWR VPWR sky130_fd_sc_hd__decap_3
X_3906_ clknet_leaf_17_clk _0029_ VGND VGND VPWR VPWR net84 sky130_fd_sc_hd__dfxtp_1
X_3837_ net254 _1573_ VGND VGND VPWR VPWR _1620_ sky130_fd_sc_hd__nor2_1
X_3768_ _1538_ _1540_ net260 VGND VGND VPWR VPWR _1585_ sky130_fd_sc_hd__mux2_1
X_2719_ net135 _0660_ net114 mantisaresult\[38\] VGND VGND VPWR VPWR _0662_ sky130_fd_sc_hd__a2bb2o_1
XFILLER_10_35 VGND VGND VPWR VPWR sky130_fd_sc_hd__fill_2
X_3699_ _1523_ _1524_ net266 VGND VGND VPWR VPWR _1525_ sky130_fd_sc_hd__mux2_1
XPHY_EDGE_ROW_36_Right_36 VGND VGND VPWR VPWR sky130_fd_sc_hd__decap_3
XFILLER_27_153 VGND VGND VPWR VPWR sky130_fd_sc_hd__decap_4
XFILLER_15_315 VGND VGND VPWR VPWR sky130_fd_sc_hd__decap_8
XFILLER_35_21 VGND VGND VPWR VPWR sky130_fd_sc_hd__fill_2
XPHY_EDGE_ROW_45_Right_45 VGND VGND VPWR VPWR sky130_fd_sc_hd__decap_3
XFILLER_70_421 VPWR VGND VPWR VGND sky130_ef_sc_hd__decap_12
XFILLER_51_97 VGND VGND VPWR VPWR sky130_fd_sc_hd__decap_4
XPHY_EDGE_ROW_54_Right_54 VGND VGND VPWR VPWR sky130_fd_sc_hd__decap_3
XFILLER_76_61 VGND VGND VPWR VPWR sky130_fd_sc_hd__decap_3
XFILLER_18_7 VGND VGND VPWR VPWR sky130_fd_sc_hd__fill_1
XFILLER_65_215 VGND VGND VPWR VPWR sky130_fd_sc_hd__decap_8
XTAP_TAPCELL_ROW_76_777 VGND VPWR sky130_fd_sc_hd__tapvpwrvgnd_1
XPHY_EDGE_ROW_63_Right_63 VGND VGND VPWR VPWR sky130_fd_sc_hd__decap_3
XFILLER_18_197 VPWR VGND VPWR VGND sky130_ef_sc_hd__decap_12
XFILLER_33_134 VGND VGND VPWR VPWR sky130_fd_sc_hd__decap_4
XFILLER_61_421 VGND VGND VPWR VPWR sky130_fd_sc_hd__fill_2
X_1952_ mantisaresult\[2\] VGND VGND VPWR VPWR _1647_ sky130_fd_sc_hd__inv_2
X_3622_ mantisaB0\[18\] net193 _1452_ VGND VGND VPWR VPWR _1453_ sky130_fd_sc_hd__a21oi_1
XPHY_EDGE_ROW_72_Right_72 VGND VGND VPWR VPWR sky130_fd_sc_hd__decap_3
X_3553_ net330 net206 _1385_ _1387_ VGND VGND VPWR VPWR _0206_ sky130_fd_sc_hd__o22a_1
X_2504_ _0364_ _0374_ VGND VGND VPWR VPWR _0447_ sky130_fd_sc_hd__or2_1
X_3484_ net157 _1326_ _1329_ VGND VGND VPWR VPWR _1330_ sky130_fd_sc_hd__and3_1
X_2435_ mantisaresult\[21\] mantisaresult\[20\] _1636_ _0355_ VGND VGND VPWR VPWR
+ _0378_ sky130_fd_sc_hd__or4_1
X_4105_ clknet_leaf_1_clk _0212_ VGND VGND VPWR VPWR mantisaBshift\[17\] sky130_fd_sc_hd__dfxtp_1
X_2366_ _0298_ _0299_ _0304_ _0308_ VGND VGND VPWR VPWR _0309_ sky130_fd_sc_hd__or4_2
X_2297_ _1919_ net379 net171 VGND VGND VPWR VPWR _0072_ sky130_fd_sc_hd__mux2_1
XTAP_TAPCELL_ROW_67_711 VGND VPWR sky130_fd_sc_hd__tapvpwrvgnd_1
X_4036_ clknet_leaf_12_clk _0147_ VGND VGND VPWR VPWR mantisaresult\[38\] sky130_fd_sc_hd__dfxtp_2
XFILLER_20_340 VGND VGND VPWR VPWR sky130_fd_sc_hd__fill_1
XTAP_TAPCELL_ROW_22_346 VGND VPWR sky130_fd_sc_hd__tapvpwrvgnd_1
XFILLER_21_34 VGND VGND VPWR VPWR sky130_fd_sc_hd__decap_3
XFILLER_46_97 VGND VGND VPWR VPWR sky130_fd_sc_hd__decap_4
XFILLER_55_281 VGND VGND VPWR VPWR sky130_fd_sc_hd__decap_3
XTAP_TAPCELL_ROW_73_758 VGND VPWR sky130_fd_sc_hd__tapvpwrvgnd_1
XFILLER_15_167 VGND VGND VPWR VPWR sky130_fd_sc_hd__fill_1
XFILLER_30_126 VGND VGND VPWR VPWR sky130_fd_sc_hd__fill_2
XFILLER_62_63 VGND VGND VPWR VPWR sky130_fd_sc_hd__fill_1
XFILLER_62_85 VGND VGND VPWR VPWR sky130_fd_sc_hd__fill_2
XFILLER_7_333 VGND VGND VPWR VPWR sky130_fd_sc_hd__decap_3
XFILLER_7_355 VGND VGND VPWR VPWR sky130_fd_sc_hd__fill_1
XFILLER_7_69 VGND VGND VPWR VPWR sky130_fd_sc_hd__decap_6
XFILLER_7_388 VGND VGND VPWR VPWR sky130_fd_sc_hd__fill_1
X_2220_ net298 net178 _1868_ VGND VGND VPWR VPWR _0046_ sky130_fd_sc_hd__o21a_1
X_2151_ net21 _1668_ VGND VGND VPWR VPWR _1812_ sky130_fd_sc_hd__and2_1
X_2082_ net211 net331 VGND VGND VPWR VPWR _0022_ sky130_fd_sc_hd__and2b_1
XFILLER_61_262 VGND VGND VPWR VPWR sky130_fd_sc_hd__decap_8
X_2984_ mantisaBshift\[7\] mantisaBshift\[8\] mantisaBshift\[9\] _0901_ VGND VGND
+ VPWR VPWR _0909_ sky130_fd_sc_hd__or4_2
X_1935_ mantisaresult\[14\] VGND VGND VPWR VPWR _1630_ sky130_fd_sc_hd__inv_2
Xinput50 mantisaB[19] VGND VGND VPWR VPWR net50 sky130_fd_sc_hd__buf_1
X_3605_ _1429_ _1434_ net269 VGND VGND VPWR VPWR _1436_ sky130_fd_sc_hd__mux2_1
Xinput61 mantisaB[8] VGND VGND VPWR VPWR net61 sky130_fd_sc_hd__buf_1
X_3536_ net151 _0772_ _1371_ VGND VGND VPWR VPWR _1372_ sky130_fd_sc_hd__o21ai_1
X_3467_ net208 _0544_ _1317_ _1318_ VGND VGND VPWR VPWR _0189_ sky130_fd_sc_hd__a31o_1
XFILLER_67_19 VPWR VGND VPWR VGND sky130_ef_sc_hd__decap_12
X_2418_ mantisaresult\[21\] _0331_ _0360_ VGND VGND VPWR VPWR _0361_ sky130_fd_sc_hd__or3_2
X_3398_ mantisaresult\[60\] _1267_ net204 VGND VGND VPWR VPWR _0171_ sky130_fd_sc_hd__mux2_1
X_2349_ mantisaresult\[20\] mantisaresult\[19\] mantisaresult\[18\] mantisaresult\[17\]
+ VGND VGND VPWR VPWR _0292_ sky130_fd_sc_hd__or4_1
X_4019_ clknet_leaf_23_clk _0130_ VGND VGND VPWR VPWR mantisaresult\[23\] sky130_fd_sc_hd__dfxtp_1
XFILLER_37_281 VGND VGND VPWR VPWR sky130_fd_sc_hd__fill_1
XPHY_EDGE_ROW_0_Right_0 VGND VGND VPWR VPWR sky130_fd_sc_hd__decap_3
XFILLER_52_251 VGND VGND VPWR VPWR sky130_fd_sc_hd__fill_1
XFILLER_52_284 VGND VGND VPWR VPWR sky130_fd_sc_hd__fill_2
XTAP_TAPCELL_ROW_70_728 VGND VPWR sky130_fd_sc_hd__tapvpwrvgnd_1
XFILLER_4_369 VGND VGND VPWR VPWR sky130_fd_sc_hd__fill_1
XFILLER_79_137 VGND VGND VPWR VPWR sky130_fd_sc_hd__decap_3
XFILLER_75_321 VPWR VGND VPWR VGND sky130_ef_sc_hd__decap_12
XFILLER_16_421 VPWR VGND VPWR VGND sky130_ef_sc_hd__decap_12
XFILLER_73_73 VGND VGND VPWR VPWR sky130_fd_sc_hd__decap_6
XFILLER_31_413 VGND VGND VPWR VPWR sky130_fd_sc_hd__fill_2
XFILLER_31_446 VGND VGND VPWR VPWR sky130_fd_sc_hd__fill_2
XTAP_TAPCELL_ROW_41_496 VGND VPWR sky130_fd_sc_hd__tapvpwrvgnd_1
Xhold108 expmiddle\[6\] VGND VGND VPWR VPWR net382 sky130_fd_sc_hd__dlygate4sd3_1
X_3321_ mantisaAshift\[54\] mantisaBshift\[54\] VGND VGND VPWR VPWR _1197_ sky130_fd_sc_hd__or2_1
X_3252_ mantisaAshift\[49\] mantisaBshift\[49\] VGND VGND VPWR VPWR _1134_ sky130_fd_sc_hd__nor2_1
X_2203_ net382 _1858_ net177 VGND VGND VPWR VPWR _0039_ sky130_fd_sc_hd__mux2_1
X_3183_ _1067_ _1071_ VGND VGND VPWR VPWR _1072_ sky130_fd_sc_hd__or2_1
XFILLER_66_321 VGND VGND VPWR VPWR sky130_fd_sc_hd__fill_1
X_2134_ _1763_ _1767_ _1770_ _1794_ _1764_ VGND VGND VPWR VPWR _1795_ sky130_fd_sc_hd__o221a_1
XFILLER_66_354 VGND VGND VPWR VPWR sky130_fd_sc_hd__fill_1
XTAP_TAPCELL_ROW_49_563 VGND VPWR sky130_fd_sc_hd__tapvpwrvgnd_1
X_2065_ _1750_ _1751_ net212 VGND VGND VPWR VPWR _0008_ sky130_fd_sc_hd__a21o_1
XPHY_EDGE_ROW_22_Left_102 VGND VGND VPWR VPWR sky130_fd_sc_hd__decap_3
XFILLER_34_273 VGND VGND VPWR VPWR sky130_fd_sc_hd__fill_1
XTAP_TAPCELL_ROW_32_430 VGND VPWR sky130_fd_sc_hd__tapvpwrvgnd_1
X_2967_ mantisaBshift\[5\] _0896_ VGND VGND VPWR VPWR _0897_ sky130_fd_sc_hd__xnor2_1
X_2898_ _0782_ _0836_ net119 VGND VGND VPWR VPWR _0837_ sky130_fd_sc_hd__mux2_1
XPHY_EDGE_ROW_31_Left_111 VGND VGND VPWR VPWR sky130_fd_sc_hd__decap_3
XFILLER_1_317 VGND VGND VPWR VPWR sky130_fd_sc_hd__fill_1
X_3519_ net354 net206 _1354_ _1356_ VGND VGND VPWR VPWR _0203_ sky130_fd_sc_hd__o22a_1
XFILLER_69_192 VGND VGND VPWR VPWR sky130_fd_sc_hd__fill_1
XFILLER_27_55 VGND VGND VPWR VPWR sky130_fd_sc_hd__fill_1
XPHY_EDGE_ROW_40_Left_120 VGND VGND VPWR VPWR sky130_fd_sc_hd__decap_3
XFILLER_72_357 VGND VGND VPWR VPWR sky130_fd_sc_hd__decap_6
XFILLER_43_54 VGND VGND VPWR VPWR sky130_fd_sc_hd__fill_2
Xclkbuf_leaf_20_clk clknet_2_2__leaf_clk VGND VGND VPWR VPWR clknet_leaf_20_clk sky130_fd_sc_hd__clkbuf_8
XFILLER_40_298 VGND VGND VPWR VPWR sky130_fd_sc_hd__decap_8
XFILLER_4_133 VGND VGND VPWR VPWR sky130_fd_sc_hd__decap_6
XFILLER_4_15 VPWR VGND VPWR VGND sky130_ef_sc_hd__decap_12
XFILLER_4_177 VPWR VGND VPWR VGND sky130_ef_sc_hd__decap_12
XFILLER_48_365 VGND VGND VPWR VPWR sky130_fd_sc_hd__decap_8
XFILLER_75_184 VGND VGND VPWR VPWR sky130_fd_sc_hd__fill_2
XFILLER_63_357 VGND VGND VPWR VPWR sky130_fd_sc_hd__fill_2
X_3870_ clknet_leaf_9_clk net297 VGND VGND VPWR VPWR mantisaAshift\[55\] sky130_fd_sc_hd__dfxtp_1
X_2821_ _0572_ _0760_ _0761_ net217 VGND VGND VPWR VPWR _0763_ sky130_fd_sc_hd__a31o_1
X_2752_ net137 _0694_ VGND VGND VPWR VPWR _0695_ sky130_fd_sc_hd__or2_1
Xclkbuf_leaf_11_clk clknet_2_1__leaf_clk VGND VGND VPWR VPWR clknet_leaf_11_clk sky130_fd_sc_hd__clkbuf_8
X_2683_ net138 _0625_ VGND VGND VPWR VPWR _0626_ sky130_fd_sc_hd__nor2_1
X_3304_ _1178_ _1181_ VGND VGND VPWR VPWR _1182_ sky130_fd_sc_hd__xnor2_1
X_3235_ _1107_ _1110_ _1118_ VGND VGND VPWR VPWR _1119_ sky130_fd_sc_hd__a21o_1
X_3166_ mantisaAshift\[42\] mantisaBshift\[42\] VGND VGND VPWR VPWR _1056_ sky130_fd_sc_hd__nor2_1
X_2117_ _1776_ _1777_ VGND VGND VPWR VPWR _1778_ sky130_fd_sc_hd__nand2b_1
X_3097_ mantisaBshift\[29\] _0997_ net242 VGND VGND VPWR VPWR _1000_ sky130_fd_sc_hd__o21ai_1
XFILLER_66_195 VGND VGND VPWR VPWR sky130_fd_sc_hd__fill_1
X_2048_ expmiddled\[4\] expadd\[4\] VGND VGND VPWR VPWR _1737_ sky130_fd_sc_hd__nand2_1
XFILLER_22_243 VGND VGND VPWR VPWR sky130_fd_sc_hd__decap_8
X_3999_ clknet_leaf_25_clk _0110_ VGND VGND VPWR VPWR mantisaresult\[4\] sky130_fd_sc_hd__dfxtp_1
XFILLER_13_57 VGND VGND VPWR VPWR sky130_fd_sc_hd__decap_4
XTAP_TAPCELL_ROW_9_247 VGND VPWR sky130_fd_sc_hd__tapvpwrvgnd_1
XFILLER_1_125 VPWR VGND VPWR VGND sky130_ef_sc_hd__decap_12
Xmax_cap180 _0476_ VGND VGND VPWR VPWR net180 sky130_fd_sc_hd__clkbuf_1
XFILLER_77_405 VPWR VGND VPWR VGND sky130_ef_sc_hd__decap_12
XFILLER_1_169 VPWR VGND VPWR VGND sky130_ef_sc_hd__decap_12
XFILLER_77_449 VPWR VGND VPWR VGND sky130_ef_sc_hd__decap_12
XTAP_TAPCELL_ROW_43_514 VGND VPWR sky130_fd_sc_hd__tapvpwrvgnd_1
XTAP_TAPCELL_ROW_51_580 VGND VPWR sky130_fd_sc_hd__tapvpwrvgnd_1
Xclkload17 clknet_leaf_11_clk VGND VGND VPWR VPWR clkload17/Y sky130_fd_sc_hd__inv_12
XFILLER_70_74 VGND VGND VPWR VPWR sky130_fd_sc_hd__fill_1
X_3020_ _0935_ _0937_ _0939_ _0940_ VGND VGND VPWR VPWR _0941_ sky130_fd_sc_hd__a2bb2o_1
Xclkbuf_leaf_0_clk clknet_2_0__leaf_clk VGND VGND VPWR VPWR clknet_leaf_0_clk sky130_fd_sc_hd__clkbuf_8
XFILLER_63_110 VGND VGND VPWR VPWR sky130_fd_sc_hd__fill_2
XFILLER_36_346 VGND VGND VPWR VPWR sky130_fd_sc_hd__decap_4
XFILLER_51_305 VGND VGND VPWR VPWR sky130_fd_sc_hd__fill_2
X_3922_ clknet_leaf_26_clk _0045_ VGND VGND VPWR VPWR expmiddlea\[4\] sky130_fd_sc_hd__dfxtp_1
X_3853_ net258 net189 _1566_ VGND VGND VPWR VPWR _0272_ sky130_fd_sc_hd__nor3_1
X_2804_ mantisaresult\[2\] net107 _0745_ VGND VGND VPWR VPWR _0746_ sky130_fd_sc_hd__a21o_1
XTAP_TAPCELL_ROW_14_282 VGND VPWR sky130_fd_sc_hd__tapvpwrvgnd_1
X_3784_ _1596_ _1597_ net255 VGND VGND VPWR VPWR _1598_ sky130_fd_sc_hd__mux2_1
XFILLER_8_280 VGND VGND VPWR VPWR sky130_fd_sc_hd__fill_2
X_2735_ mantisaresult\[15\] net107 _0677_ VGND VGND VPWR VPWR _0678_ sky130_fd_sc_hd__a21o_1
X_2666_ expmiddlec\[7\] _0578_ VGND VGND VPWR VPWR _0609_ sky130_fd_sc_hd__nand2_1
X_2597_ mantisaresult\[15\] _1630_ _0375_ _0428_ VGND VGND VPWR VPWR _0540_ sky130_fd_sc_hd__or4_1
Xfanout204 _1688_ VGND VGND VPWR VPWR net204 sky130_fd_sc_hd__buf_2
XTAP_TAPCELL_ROW_6_217 VGND VPWR sky130_fd_sc_hd__tapvpwrvgnd_1
Xfanout237 net238 VGND VGND VPWR VPWR net237 sky130_fd_sc_hd__buf_2
Xfanout226 mantisaresult\[41\] VGND VGND VPWR VPWR net226 sky130_fd_sc_hd__buf_2
Xfanout215 net216 VGND VGND VPWR VPWR net215 sky130_fd_sc_hd__buf_2
Xfanout259 expmiddle\[4\] VGND VGND VPWR VPWR net259 sky130_fd_sc_hd__clkbuf_2
Xfanout248 net249 VGND VGND VPWR VPWR net248 sky130_fd_sc_hd__clkbuf_2
X_3218_ _1098_ _1103_ VGND VGND VPWR VPWR _1104_ sky130_fd_sc_hd__xor2_1
XFILLER_74_419 VGND VGND VPWR VPWR sky130_fd_sc_hd__fill_1
X_3149_ mantisaAshift\[40\] mantisaBshift\[40\] VGND VGND VPWR VPWR _1041_ sky130_fd_sc_hd__nand2_1
XTAP_TAPCELL_ROW_57_628 VGND VPWR sky130_fd_sc_hd__tapvpwrvgnd_1
XFILLER_27_346 VGND VGND VPWR VPWR sky130_fd_sc_hd__fill_2
XTAP_TAPCELL_ROW_65_694 VGND VPWR sky130_fd_sc_hd__tapvpwrvgnd_1
XFILLER_24_67 VGND VGND VPWR VPWR sky130_fd_sc_hd__decap_4
XFILLER_2_401 VPWR VGND VPWR VGND sky130_ef_sc_hd__decap_12
XFILLER_2_445 VPWR VGND VPWR VGND sky130_ef_sc_hd__decap_12
XFILLER_49_64 VGND VGND VPWR VPWR sky130_fd_sc_hd__fill_1
XFILLER_77_279 VGND VGND VPWR VPWR sky130_fd_sc_hd__fill_1
XFILLER_1_27 VPWR VGND VPWR VGND sky130_ef_sc_hd__decap_12
XFILLER_73_441 VGND VGND VPWR VPWR sky130_fd_sc_hd__decap_6
XTAP_TAPCELL_ROW_28_396 VGND VPWR sky130_fd_sc_hd__tapvpwrvgnd_1
XTAP_TAPCELL_ROW_11_263 VGND VPWR sky130_fd_sc_hd__tapvpwrvgnd_1
X_2520_ mantisaresult\[1\] _0435_ _0443_ mantisaresult\[0\] VGND VGND VPWR VPWR _0463_
+ sky130_fd_sc_hd__or4b_1
XFILLER_5_261 VGND VGND VPWR VPWR sky130_fd_sc_hd__fill_1
X_2451_ mantisaresult\[38\] _0347_ VGND VGND VPWR VPWR _0394_ sky130_fd_sc_hd__nand2_1
X_2382_ net220 mantisaresult\[47\] mantisaresult\[46\] net222 VGND VGND VPWR VPWR
+ _0325_ sky130_fd_sc_hd__or4_2
X_4121_ clknet_leaf_2_clk _0228_ VGND VGND VPWR VPWR mantisaBshift\[24\] sky130_fd_sc_hd__dfxtp_1
XFILLER_56_408 VGND VGND VPWR VPWR sky130_fd_sc_hd__fill_2
XFILLER_56_419 VGND VGND VPWR VPWR sky130_fd_sc_hd__fill_1
X_4052_ clknet_leaf_14_clk _0163_ VGND VGND VPWR VPWR mantisaresult\[53\] sky130_fd_sc_hd__dfxtp_1
Xinput4 expa[3] VGND VGND VPWR VPWR net4 sky130_fd_sc_hd__dlymetal6s2s_1
X_3003_ net106 _0920_ _0921_ _0923_ VGND VGND VPWR VPWR _0924_ sky130_fd_sc_hd__a22o_1
XFILLER_36_154 VGND VGND VPWR VPWR sky130_fd_sc_hd__decap_4
Xclkbuf_2_1__f_clk clknet_0_clk VGND VGND VPWR VPWR clknet_2_1__leaf_clk sky130_fd_sc_hd__clkbuf_16
XFILLER_51_146 VGND VGND VPWR VPWR sky130_fd_sc_hd__decap_4
XTAP_TAPCELL_ROW_62_664 VGND VPWR sky130_fd_sc_hd__tapvpwrvgnd_1
X_3905_ clknet_leaf_16_clk _0028_ VGND VGND VPWR VPWR net83 sky130_fd_sc_hd__dfxtp_1
XFILLER_32_371 VPWR VGND VPWR VGND sky130_ef_sc_hd__decap_12
X_3836_ net258 net187 _1566_ _1619_ VGND VGND VPWR VPWR _0257_ sky130_fd_sc_hd__o31ai_1
X_3767_ net186 _1584_ VGND VGND VPWR VPWR _0223_ sky130_fd_sc_hd__nor2_1
X_2718_ _0660_ VGND VGND VPWR VPWR _0661_ sky130_fd_sc_hd__inv_2
X_3698_ _1477_ _1481_ net271 VGND VGND VPWR VPWR _1524_ sky130_fd_sc_hd__mux2_1
X_2649_ _0506_ net166 _0572_ _0567_ VGND VGND VPWR VPWR _0592_ sky130_fd_sc_hd__a22o_1
XFILLER_74_205 VGND VGND VPWR VPWR sky130_fd_sc_hd__fill_1
XFILLER_27_110 VGND VGND VPWR VPWR sky130_fd_sc_hd__fill_2
XFILLER_67_290 VPWR VGND VPWR VGND sky130_ef_sc_hd__decap_12
XFILLER_15_305 VGND VGND VPWR VPWR sky130_fd_sc_hd__decap_3
XFILLER_35_55 VGND VGND VPWR VPWR sky130_fd_sc_hd__fill_1
XFILLER_70_433 VPWR VGND VPWR VGND sky130_ef_sc_hd__decap_12
XFILLER_2_253 VPWR VGND VPWR VGND sky130_ef_sc_hd__decap_12
XFILLER_38_408 VGND VGND VPWR VPWR sky130_fd_sc_hd__fill_2
XFILLER_76_73 VGND VGND VPWR VPWR sky130_fd_sc_hd__fill_2
XPHY_EDGE_ROW_69_Left_149 VGND VGND VPWR VPWR sky130_fd_sc_hd__decap_3
XTAP_TAPCELL_ROW_76_778 VGND VPWR sky130_fd_sc_hd__tapvpwrvgnd_1
XFILLER_61_400 VGND VGND VPWR VPWR sky130_fd_sc_hd__fill_2
XFILLER_73_260 VGND VGND VPWR VPWR sky130_fd_sc_hd__decap_3
XTAP_TAPCELL_ROW_16_300 VGND VPWR sky130_fd_sc_hd__tapvpwrvgnd_1
XFILLER_61_455 VGND VGND VPWR VPWR sky130_fd_sc_hd__fill_2
X_1951_ mantisaresult\[34\] VGND VGND VPWR VPWR _1646_ sky130_fd_sc_hd__inv_2
XPHY_EDGE_ROW_78_Left_158 VGND VGND VPWR VPWR sky130_fd_sc_hd__decap_3
X_3621_ net251 mantisaB0\[19\] net274 VGND VGND VPWR VPWR _1452_ sky130_fd_sc_hd__and3b_1
X_3552_ mantisaresult\[59\] net199 net164 _1386_ VGND VGND VPWR VPWR _1387_ sky130_fd_sc_hd__a31o_1
X_2503_ _1648_ _0367_ _0439_ _0443_ VGND VGND VPWR VPWR _0446_ sky130_fd_sc_hd__nor4_1
X_3483_ _1327_ _1328_ VGND VGND VPWR VPWR _1329_ sky130_fd_sc_hd__or2_1
X_2434_ net229 _0293_ _0294_ _0314_ VGND VGND VPWR VPWR _0377_ sky130_fd_sc_hd__or4_1
X_2365_ net218 net219 VGND VGND VPWR VPWR _0308_ sky130_fd_sc_hd__or2_1
X_4104_ clknet_leaf_26_clk _0211_ VGND VGND VPWR VPWR mantisaBshift\[0\] sky130_fd_sc_hd__dfxtp_1
X_2296_ _1873_ net17 net102 VGND VGND VPWR VPWR _1919_ sky130_fd_sc_hd__mux2_1
XFILLER_56_205 VGND VGND VPWR VPWR sky130_fd_sc_hd__fill_2
XFILLER_37_441 VGND VGND VPWR VPWR sky130_fd_sc_hd__decap_6
X_4035_ clknet_leaf_12_clk _0146_ VGND VGND VPWR VPWR mantisaresult\[37\] sky130_fd_sc_hd__dfxtp_2
XFILLER_24_179 VPWR VGND VPWR VGND sky130_ef_sc_hd__decap_12
XTAP_TAPCELL_ROW_22_347 VGND VPWR sky130_fd_sc_hd__tapvpwrvgnd_1
XFILLER_20_363 VGND VGND VPWR VPWR sky130_fd_sc_hd__fill_1
X_3819_ net257 _1512_ _1607_ net191 VGND VGND VPWR VPWR _0252_ sky130_fd_sc_hd__a211oi_1
XFILLER_28_430 VPWR VGND VPWR VGND sky130_ef_sc_hd__decap_12
XFILLER_28_452 VGND VGND VPWR VPWR sky130_fd_sc_hd__fill_2
XFILLER_43_400 VPWR VGND VPWR VGND sky130_ef_sc_hd__decap_12
XTAP_TAPCELL_ROW_73_759 VGND VPWR sky130_fd_sc_hd__tapvpwrvgnd_1
XFILLER_78_363 VGND VGND VPWR VPWR sky130_fd_sc_hd__fill_1
X_2150_ net22 _1671_ VGND VGND VPWR VPWR _1811_ sky130_fd_sc_hd__and2_1
X_2081_ net209 net324 VGND VGND VPWR VPWR _0021_ sky130_fd_sc_hd__and2b_1
X_2983_ _0907_ _0908_ mantisaresult\[9\] net231 VGND VGND VPWR VPWR _0115_ sky130_fd_sc_hd__a2bb2o_1
XFILLER_21_149 VGND VGND VPWR VPWR sky130_fd_sc_hd__decap_3
X_1934_ mantisaresult\[16\] VGND VGND VPWR VPWR _1629_ sky130_fd_sc_hd__inv_2
Xinput40 mantisaB[0] VGND VGND VPWR VPWR net40 sky130_fd_sc_hd__buf_1
X_3604_ _1434_ VGND VGND VPWR VPWR _1435_ sky130_fd_sc_hd__inv_2
Xinput51 mantisaB[1] VGND VGND VPWR VPWR net51 sky130_fd_sc_hd__buf_1
Xinput62 mantisaB[9] VGND VGND VPWR VPWR net62 sky130_fd_sc_hd__buf_1
X_3535_ _0922_ _1079_ _1370_ net126 VGND VGND VPWR VPWR _1371_ sky130_fd_sc_hd__o211a_1
X_3466_ net386 net213 VGND VGND VPWR VPWR _1318_ sky130_fd_sc_hd__and2_1
X_2417_ _0332_ _0359_ VGND VGND VPWR VPWR _0360_ sky130_fd_sc_hd__or2_1
X_3397_ _1257_ _1266_ VGND VGND VPWR VPWR _1267_ sky130_fd_sc_hd__xor2_1
X_2348_ _0291_ net347 net171 VGND VGND VPWR VPWR _0097_ sky130_fd_sc_hd__mux2_1
X_2279_ net25 _1907_ net101 VGND VGND VPWR VPWR _1908_ sky130_fd_sc_hd__mux2_1
X_4018_ clknet_leaf_23_clk _0129_ VGND VGND VPWR VPWR mantisaresult\[22\] sky130_fd_sc_hd__dfxtp_1
XFILLER_25_466 VGND VGND VPWR VPWR sky130_fd_sc_hd__decap_3
XTAP_TAPCELL_ROW_35_450 VGND VPWR sky130_fd_sc_hd__tapvpwrvgnd_1
XFILLER_52_263 VPWR VGND VPWR VGND sky130_ef_sc_hd__decap_12
XTAP_TAPCELL_ROW_70_729 VGND VPWR sky130_fd_sc_hd__tapvpwrvgnd_1
XFILLER_12_138 VGND VGND VPWR VPWR sky130_fd_sc_hd__fill_2
XFILLER_40_447 VGND VGND VPWR VPWR sky130_fd_sc_hd__fill_2
XFILLER_32_67 VGND VGND VPWR VPWR sky130_fd_sc_hd__decap_4
XFILLER_75_333 VGND VGND VPWR VPWR sky130_fd_sc_hd__decap_3
XFILLER_57_75 VGND VGND VPWR VPWR sky130_fd_sc_hd__decap_4
XFILLER_16_433 VPWR VGND VPWR VGND sky130_ef_sc_hd__decap_12
XFILLER_43_263 VGND VGND VPWR VPWR sky130_fd_sc_hd__decap_4
XTAP_TAPCELL_ROW_41_497 VGND VPWR sky130_fd_sc_hd__tapvpwrvgnd_1
Xhold109 mantisaresult\[29\] VGND VGND VPWR VPWR net383 sky130_fd_sc_hd__dlygate4sd3_1
X_3320_ mantisaAshift\[54\] mantisaBshift\[54\] VGND VGND VPWR VPWR _1196_ sky130_fd_sc_hd__and2_1
X_3251_ _1132_ VGND VGND VPWR VPWR _1133_ sky130_fd_sc_hd__inv_2
X_2202_ _1769_ _1857_ VGND VGND VPWR VPWR _1858_ sky130_fd_sc_hd__xor2_1
X_3182_ _1068_ _1070_ net244 VGND VGND VPWR VPWR _1071_ sky130_fd_sc_hd__mux2_1
X_2133_ _1771_ _1793_ _1772_ VGND VGND VPWR VPWR _1794_ sky130_fd_sc_hd__a21bo_1
XTAP_TAPCELL_ROW_49_564 VGND VPWR sky130_fd_sc_hd__tapvpwrvgnd_1
X_2064_ _1747_ _1748_ _1749_ VGND VGND VPWR VPWR _1751_ sky130_fd_sc_hd__a21o_1
XFILLER_19_271 VGND VGND VPWR VPWR sky130_fd_sc_hd__decap_8
XFILLER_22_458 VPWR VGND VPWR VGND sky130_ef_sc_hd__decap_12
XTAP_TAPCELL_ROW_32_431 VGND VPWR sky130_fd_sc_hd__tapvpwrvgnd_1
X_2966_ mantisaBshift\[4\] _0893_ net239 VGND VGND VPWR VPWR _0896_ sky130_fd_sc_hd__o21ai_1
X_2897_ mantisaresult\[42\] net113 _0835_ net134 VGND VGND VPWR VPWR _0836_ sky130_fd_sc_hd__o2bb2a_1
X_3518_ mantisaresult\[56\] net196 net165 _1355_ VGND VGND VPWR VPWR _1356_ sky130_fd_sc_hd__a31o_1
X_3449_ _1184_ _1305_ net118 VGND VGND VPWR VPWR _1306_ sky130_fd_sc_hd__mux2_1
XFILLER_57_333 VGND VGND VPWR VPWR sky130_fd_sc_hd__decap_3
XFILLER_25_274 VGND VGND VPWR VPWR sky130_fd_sc_hd__fill_1
XFILLER_40_211 VGND VGND VPWR VPWR sky130_fd_sc_hd__decap_8
XFILLER_13_447 VGND VGND VPWR VPWR sky130_fd_sc_hd__fill_1
XFILLER_4_27 VGND VGND VPWR VPWR sky130_fd_sc_hd__fill_1
XFILLER_4_189 VGND VGND VPWR VPWR sky130_fd_sc_hd__decap_6
XFILLER_68_85 VGND VGND VPWR VPWR sky130_fd_sc_hd__decap_4
XFILLER_48_322 VPWR VGND VPWR VGND sky130_ef_sc_hd__decap_12
XFILLER_16_296 VGND VGND VPWR VPWR sky130_fd_sc_hd__decap_3
XFILLER_31_222 VGND VGND VPWR VPWR sky130_fd_sc_hd__fill_2
X_2820_ _0570_ _0573_ _0571_ VGND VGND VPWR VPWR _0762_ sky130_fd_sc_hd__a21oi_1
X_2751_ mantisaresult\[23\] net108 _0693_ net132 VGND VGND VPWR VPWR _0694_ sky130_fd_sc_hd__a22o_1
X_2682_ _0621_ _0624_ net115 VGND VGND VPWR VPWR _0625_ sky130_fd_sc_hd__mux2_1
X_3303_ _1164_ _1172_ _1179_ net246 _1180_ VGND VGND VPWR VPWR _1181_ sky130_fd_sc_hd__o221a_1
X_3234_ mantisaBshift\[46\] mantisaAshift\[46\] VGND VGND VPWR VPWR _1118_ sky130_fd_sc_hd__and2b_1
XFILLER_39_377 VPWR VGND VPWR VGND sky130_ef_sc_hd__decap_12
X_3165_ net226 _1055_ net205 VGND VGND VPWR VPWR _0150_ sky130_fd_sc_hd__mux2_1
XFILLER_66_141 VPWR VGND VPWR VGND sky130_ef_sc_hd__decap_12
X_2116_ net2 net10 VGND VGND VPWR VPWR _1777_ sky130_fd_sc_hd__nand2b_1
X_3096_ net383 net202 _0998_ _0999_ VGND VGND VPWR VPWR _0137_ sky130_fd_sc_hd__o22a_1
XFILLER_66_185 VGND VGND VPWR VPWR sky130_fd_sc_hd__fill_1
X_2047_ net212 _1736_ VGND VGND VPWR VPWR _0005_ sky130_fd_sc_hd__or2_1
XFILLER_54_369 VGND VGND VPWR VPWR sky130_fd_sc_hd__fill_1
XFILLER_10_406 VPWR VGND VPWR VGND sky130_ef_sc_hd__decap_12
X_3998_ clknet_leaf_17_clk _0109_ VGND VGND VPWR VPWR four_man\[45\] sky130_fd_sc_hd__dfxtp_1
X_2949_ _0836_ _0880_ net119 VGND VGND VPWR VPWR _0881_ sky130_fd_sc_hd__mux2_1
XFILLER_1_137 VPWR VGND VPWR VGND sky130_ef_sc_hd__decap_12
Xmax_cap181 _0429_ VGND VGND VPWR VPWR net181 sky130_fd_sc_hd__clkbuf_1
XFILLER_77_417 VPWR VGND VPWR VGND sky130_ef_sc_hd__decap_12
XFILLER_49_108 VGND VGND VPWR VPWR sky130_fd_sc_hd__fill_1
XTAP_TAPCELL_ROW_0_170 VGND VPWR sky130_fd_sc_hd__tapvpwrvgnd_1
XTAP_TAPCELL_ROW_43_515 VGND VPWR sky130_fd_sc_hd__tapvpwrvgnd_1
XFILLER_13_299 VGND VGND VPWR VPWR sky130_fd_sc_hd__fill_1
XFILLER_9_248 VPWR VGND VPWR VGND sky130_ef_sc_hd__decap_12
XTAP_TAPCELL_ROW_51_581 VGND VPWR sky130_fd_sc_hd__tapvpwrvgnd_1
Xclkload18 clknet_leaf_12_clk VGND VGND VPWR VPWR clkload18/Y sky130_fd_sc_hd__inv_12
XFILLER_0_181 VPWR VGND VPWR VGND sky130_ef_sc_hd__decap_12
XFILLER_36_336 VGND VGND VPWR VPWR sky130_fd_sc_hd__decap_3
X_3921_ clknet_leaf_27_clk _0044_ VGND VGND VPWR VPWR expmiddlea\[3\] sky130_fd_sc_hd__dfxtp_1
X_3852_ net192 _1503_ VGND VGND VPWR VPWR _0271_ sky130_fd_sc_hd__and2_1
X_2803_ mantisaresult\[1\] net152 net130 VGND VGND VPWR VPWR _0745_ sky130_fd_sc_hd__and3_1
XTAP_TAPCELL_ROW_14_283 VGND VPWR sky130_fd_sc_hd__tapvpwrvgnd_1
X_3783_ _1563_ _1565_ net263 VGND VGND VPWR VPWR _1597_ sky130_fd_sc_hd__mux2_1
X_2734_ mantisaresult\[14\] net153 net131 VGND VGND VPWR VPWR _0677_ sky130_fd_sc_hd__and3_1
X_2665_ net136 VGND VGND VPWR VPWR _0608_ sky130_fd_sc_hd__inv_2
X_2596_ mantisaresult\[47\] _0313_ _0518_ _0536_ _0538_ VGND VGND VPWR VPWR _0539_
+ sky130_fd_sc_hd__a2111o_1
XFILLER_5_81 VPWR VGND VPWR VGND sky130_ef_sc_hd__decap_12
Xfanout205 _1688_ VGND VGND VPWR VPWR net205 sky130_fd_sc_hd__clkbuf_4
Xfanout238 net243 VGND VGND VPWR VPWR net238 sky130_fd_sc_hd__clkbuf_2
XTAP_TAPCELL_ROW_6_218 VGND VPWR sky130_fd_sc_hd__tapvpwrvgnd_1
Xfanout227 net228 VGND VGND VPWR VPWR net227 sky130_fd_sc_hd__buf_2
Xfanout216 net217 VGND VGND VPWR VPWR net216 sky130_fd_sc_hd__clkbuf_2
Xfanout249 sub VGND VGND VPWR VPWR net249 sky130_fd_sc_hd__clkbuf_2
X_3217_ _1100_ _1102_ net244 VGND VGND VPWR VPWR _1103_ sky130_fd_sc_hd__mux2_1
X_3148_ mantisaAshift\[40\] mantisaBshift\[40\] VGND VGND VPWR VPWR _1040_ sky130_fd_sc_hd__nor2_1
XTAP_TAPCELL_ROW_57_629 VGND VPWR sky130_fd_sc_hd__tapvpwrvgnd_1
XFILLER_67_472 VGND VGND VPWR VPWR sky130_fd_sc_hd__fill_1
X_3079_ net241 _0986_ mantisaBshift\[25\] VGND VGND VPWR VPWR _0987_ sky130_fd_sc_hd__a21oi_1
XTAP_TAPCELL_ROW_65_695 VGND VPWR sky130_fd_sc_hd__tapvpwrvgnd_1
XFILLER_2_413 VGND VGND VPWR VPWR sky130_fd_sc_hd__decap_6
XFILLER_2_457 VPWR VGND VPWR VGND sky130_ef_sc_hd__decap_12
XFILLER_49_32 VGND VGND VPWR VPWR sky130_fd_sc_hd__decap_8
XFILLER_49_54 VGND VGND VPWR VPWR sky130_fd_sc_hd__fill_2
XFILLER_77_225 VPWR VGND VPWR VGND sky130_ef_sc_hd__decap_12
XFILLER_49_98 VGND VGND VPWR VPWR sky130_fd_sc_hd__fill_1
XFILLER_1_39 VPWR VGND VPWR VGND sky130_ef_sc_hd__decap_12
XFILLER_33_328 VGND VGND VPWR VPWR sky130_fd_sc_hd__decap_8
XFILLER_60_103 VGND VGND VPWR VPWR sky130_fd_sc_hd__decap_8
XTAP_TAPCELL_ROW_28_397 VGND VPWR sky130_fd_sc_hd__tapvpwrvgnd_1
X_2450_ _0390_ _0392_ VGND VGND VPWR VPWR _0393_ sky130_fd_sc_hd__nor2_1
X_2381_ mantisaresult\[44\] net224 net225 mantisaresult\[41\] VGND VGND VPWR VPWR
+ _0324_ sky130_fd_sc_hd__or4_2
X_4120_ clknet_leaf_24_clk _0227_ VGND VGND VPWR VPWR mantisaBshift\[2\] sky130_fd_sc_hd__dfxtp_1
XFILLER_68_269 VGND VGND VPWR VPWR sky130_fd_sc_hd__decap_4
X_4051_ clknet_leaf_14_clk _0162_ VGND VGND VPWR VPWR mantisaresult\[52\] sky130_fd_sc_hd__dfxtp_1
Xinput5 expa[4] VGND VGND VPWR VPWR net5 sky130_fd_sc_hd__buf_1
X_3002_ _0809_ _0807_ net143 VGND VGND VPWR VPWR _0923_ sky130_fd_sc_hd__mux2_1
XTAP_TAPCELL_ROW_19_320 VGND VPWR sky130_fd_sc_hd__tapvpwrvgnd_1
XFILLER_24_306 VGND VGND VPWR VPWR sky130_fd_sc_hd__fill_2
XFILLER_51_125 VPWR VGND VPWR VGND sky130_ef_sc_hd__decap_12
X_3904_ clknet_leaf_16_clk _0027_ VGND VGND VPWR VPWR net82 sky130_fd_sc_hd__dfxtp_1
XTAP_TAPCELL_ROW_62_665 VGND VPWR sky130_fd_sc_hd__tapvpwrvgnd_1
XFILLER_32_383 VPWR VGND VPWR VGND sky130_ef_sc_hd__decap_12
X_3835_ net258 _1564_ _1618_ net189 VGND VGND VPWR VPWR _1619_ sky130_fd_sc_hd__a211o_1
X_3766_ net258 _1583_ _1582_ VGND VGND VPWR VPWR _1584_ sky130_fd_sc_hd__o21ai_1
X_2717_ mantisaresult\[39\] net156 VGND VGND VPWR VPWR _0660_ sky130_fd_sc_hd__nand2_1
X_3697_ _1469_ _1476_ net271 VGND VGND VPWR VPWR _1523_ sky130_fd_sc_hd__mux2_1
XFILLER_10_59 VGND VGND VPWR VPWR sky130_fd_sc_hd__decap_8
X_2648_ _0567_ _0572_ VGND VGND VPWR VPWR _0591_ sky130_fd_sc_hd__nand2_1
X_2579_ _1645_ _0306_ _0334_ _0345_ VGND VGND VPWR VPWR _0522_ sky130_fd_sc_hd__or4_1
XFILLER_19_13 VGND VGND VPWR VPWR sky130_fd_sc_hd__fill_1
XFILLER_70_401 VPWR VGND VPWR VGND sky130_ef_sc_hd__decap_12
XFILLER_35_67 VPWR VGND VPWR VGND sky130_ef_sc_hd__decap_12
XFILLER_70_445 VPWR VGND VPWR VGND sky130_ef_sc_hd__decap_12
XFILLER_30_309 VGND VGND VPWR VPWR sky130_fd_sc_hd__fill_2
XFILLER_42_169 VPWR VGND VPWR VGND sky130_ef_sc_hd__decap_12
XFILLER_51_22 VPWR VGND VPWR VGND sky130_ef_sc_hd__decap_12
XFILLER_2_221 VPWR VGND VPWR VGND sky130_ef_sc_hd__decap_12
XFILLER_2_265 VPWR VGND VPWR VGND sky130_ef_sc_hd__decap_12
XFILLER_76_85 VGND VGND VPWR VPWR sky130_fd_sc_hd__decap_6
XFILLER_46_431 VGND VGND VPWR VPWR sky130_fd_sc_hd__decap_8
XFILLER_58_280 VGND VGND VPWR VPWR sky130_fd_sc_hd__decap_3
XTAP_TAPCELL_ROW_76_779 VGND VPWR sky130_fd_sc_hd__tapvpwrvgnd_1
XTAP_TAPCELL_ROW_16_301 VGND VPWR sky130_fd_sc_hd__tapvpwrvgnd_1
X_1950_ net225 VGND VGND VPWR VPWR _1645_ sky130_fd_sc_hd__inv_2
X_3620_ _1444_ _1450_ net269 VGND VGND VPWR VPWR _1451_ sky130_fd_sc_hd__mux2_1
X_3551_ mantisaresult\[58\] net197 net160 net215 VGND VGND VPWR VPWR _1386_ sky130_fd_sc_hd__a31o_1
X_2502_ _0431_ _0444_ VGND VGND VPWR VPWR _0445_ sky130_fd_sc_hd__nor2_1
X_3482_ _0756_ _0874_ _0925_ _1324_ net128 VGND VGND VPWR VPWR _1328_ sky130_fd_sc_hd__a221o_1
XFILLER_51_3 VGND VGND VPWR VPWR sky130_fd_sc_hd__fill_1
X_2433_ _1637_ _0371_ _0372_ _0375_ VGND VGND VPWR VPWR _0376_ sky130_fd_sc_hd__or4_1
X_2364_ net218 _0306_ VGND VGND VPWR VPWR _0307_ sky130_fd_sc_hd__nor2_1
X_4103_ clknet_leaf_26_clk _0210_ VGND VGND VPWR VPWR mantisaBshift\[1\] sky130_fd_sc_hd__dfxtp_1
X_2295_ _1918_ net310 net171 VGND VGND VPWR VPWR _0071_ sky130_fd_sc_hd__mux2_1
X_4034_ clknet_leaf_12_clk _0145_ VGND VGND VPWR VPWR mantisaresult\[36\] sky130_fd_sc_hd__dfxtp_2
XFILLER_64_294 VGND VGND VPWR VPWR sky130_fd_sc_hd__fill_1
XFILLER_12_309 VGND VGND VPWR VPWR sky130_fd_sc_hd__fill_1
XFILLER_20_331 VGND VGND VPWR VPWR sky130_fd_sc_hd__fill_1
XTAP_TAPCELL_ROW_22_348 VGND VPWR sky130_fd_sc_hd__tapvpwrvgnd_1
XFILLER_20_353 VGND VGND VPWR VPWR sky130_fd_sc_hd__fill_1
X_3818_ net260 _1516_ net252 VGND VGND VPWR VPWR _1607_ sky130_fd_sc_hd__a21oi_1
X_3749_ _1437_ _1451_ net260 VGND VGND VPWR VPWR _1570_ sky130_fd_sc_hd__mux2_1
XFILLER_79_309 VPWR VGND VPWR VGND sky130_ef_sc_hd__decap_12
XFILLER_28_442 VGND VGND VPWR VPWR sky130_fd_sc_hd__fill_1
XFILLER_46_55 VGND VGND VPWR VPWR sky130_fd_sc_hd__fill_1
XFILLER_55_261 VPWR VGND VPWR VGND sky130_ef_sc_hd__decap_12
XFILLER_43_412 VGND VGND VPWR VPWR sky130_fd_sc_hd__fill_2
XFILLER_43_423 VPWR VGND VPWR VGND sky130_ef_sc_hd__decap_12
XFILLER_15_147 VPWR VGND VPWR VGND sky130_ef_sc_hd__decap_12
XFILLER_70_253 VGND VGND VPWR VPWR sky130_fd_sc_hd__decap_8
XFILLER_11_320 VGND VGND VPWR VPWR sky130_fd_sc_hd__fill_2
XFILLER_30_139 VGND VGND VPWR VPWR sky130_fd_sc_hd__fill_1
X_2080_ net210 net328 VGND VGND VPWR VPWR _0020_ sky130_fd_sc_hd__and2b_1
X_2982_ net240 mantisaBshift\[9\] _0906_ net231 VGND VGND VPWR VPWR _0908_ sky130_fd_sc_hd__a31o_1
X_1933_ mantisaresult\[6\] VGND VGND VPWR VPWR _1628_ sky130_fd_sc_hd__inv_2
Xinput30 mantisaA[21] VGND VGND VPWR VPWR net30 sky130_fd_sc_hd__buf_1
X_3603_ _1431_ _1433_ net270 VGND VGND VPWR VPWR _1434_ sky130_fd_sc_hd__mux2_1
Xinput41 mantisaB[10] VGND VGND VPWR VPWR net41 sky130_fd_sc_hd__buf_1
Xinput63 op VGND VGND VPWR VPWR net63 sky130_fd_sc_hd__buf_1
Xinput52 mantisaB[20] VGND VGND VPWR VPWR net52 sky130_fd_sc_hd__buf_1
X_3534_ _0925_ _1369_ VGND VGND VPWR VPWR _1370_ sky130_fd_sc_hd__nand2_1
X_3465_ _0530_ _0543_ VGND VGND VPWR VPWR _1317_ sky130_fd_sc_hd__nand2_1
X_2416_ mantisaresult\[32\] _0293_ _0294_ _0355_ VGND VGND VPWR VPWR _0359_ sky130_fd_sc_hd__or4_1
X_3396_ _1259_ _1265_ net247 VGND VGND VPWR VPWR _1266_ sky130_fd_sc_hd__mux2_1
XFILLER_69_331 VGND VGND VPWR VPWR sky130_fd_sc_hd__decap_4
X_2347_ net65 net64 net99 VGND VGND VPWR VPWR _0291_ sky130_fd_sc_hd__mux2_1
X_2278_ net48 net168 VGND VGND VPWR VPWR _1907_ sky130_fd_sc_hd__and2_1
X_4017_ clknet_leaf_23_clk _0128_ VGND VGND VPWR VPWR mantisaresult\[21\] sky130_fd_sc_hd__dfxtp_1
XFILLER_25_401 VGND VGND VPWR VPWR sky130_fd_sc_hd__decap_8
XFILLER_52_253 VGND VGND VPWR VPWR sky130_fd_sc_hd__decap_4
XTAP_TAPCELL_ROW_35_451 VGND VPWR sky130_fd_sc_hd__tapvpwrvgnd_1
XFILLER_52_275 VGND VGND VPWR VPWR sky130_fd_sc_hd__decap_6
XFILLER_32_57 VGND VGND VPWR VPWR sky130_fd_sc_hd__decap_3
XFILLER_57_21 VGND VGND VPWR VPWR sky130_fd_sc_hd__fill_1
XFILLER_16_445 VPWR VGND VPWR VGND sky130_ef_sc_hd__decap_12
XFILLER_73_53 VGND VGND VPWR VPWR sky130_fd_sc_hd__decap_3
XTAP_TAPCELL_ROW_41_498 VGND VPWR sky130_fd_sc_hd__tapvpwrvgnd_1
XFILLER_3_393 VPWR VGND VPWR VGND sky130_ef_sc_hd__decap_12
X_3250_ mantisaAshift\[49\] mantisaBshift\[49\] VGND VGND VPWR VPWR _1132_ sky130_fd_sc_hd__nand2_1
X_2201_ _1856_ _1794_ net98 VGND VGND VPWR VPWR _1857_ sky130_fd_sc_hd__mux2_1
X_3181_ _1058_ _1061_ _1069_ VGND VGND VPWR VPWR _1070_ sky130_fd_sc_hd__a21o_1
X_2132_ _1773_ _1792_ VGND VGND VPWR VPWR _1793_ sky130_fd_sc_hd__nor2_1
XTAP_TAPCELL_ROW_49_565 VGND VPWR sky130_fd_sc_hd__tapvpwrvgnd_1
X_2063_ _1747_ _1748_ _1749_ VGND VGND VPWR VPWR _1750_ sky130_fd_sc_hd__nand3_1
X_2965_ mantisaresult\[4\] net201 _0894_ _0895_ VGND VGND VPWR VPWR _0110_ sky130_fd_sc_hd__o22a_1
X_2896_ net224 net155 VGND VGND VPWR VPWR _0835_ sky130_fd_sc_hd__nand2_1
XFILLER_8_70 VGND VGND VPWR VPWR sky130_fd_sc_hd__decap_4
X_3517_ mantisaresult\[55\] net196 net161 net215 VGND VGND VPWR VPWR _1355_ sky130_fd_sc_hd__a31o_1
X_3448_ net219 net109 _1290_ net133 VGND VGND VPWR VPWR _1305_ sky130_fd_sc_hd__a22o_1
X_3379_ mantisaBshift\[58\] mantisaAshift\[58\] VGND VGND VPWR VPWR _1250_ sky130_fd_sc_hd__and2b_1
XFILLER_27_57 VGND VGND VPWR VPWR sky130_fd_sc_hd__fill_2
XFILLER_27_68 VGND VGND VPWR VPWR sky130_fd_sc_hd__decap_6
XFILLER_57_389 VGND VGND VPWR VPWR sky130_fd_sc_hd__decap_3
XFILLER_40_267 VGND VGND VPWR VPWR sky130_fd_sc_hd__fill_1
XFILLER_0_363 VGND VGND VPWR VPWR sky130_fd_sc_hd__fill_1
XFILLER_0_385 VGND VGND VPWR VPWR sky130_fd_sc_hd__decap_6
XFILLER_48_334 VGND VGND VPWR VPWR sky130_fd_sc_hd__decap_4
XFILLER_63_326 VGND VGND VPWR VPWR sky130_fd_sc_hd__fill_2
XFILLER_16_275 VGND VGND VPWR VPWR sky130_fd_sc_hd__fill_1
XFILLER_71_381 VGND VGND VPWR VPWR sky130_fd_sc_hd__decap_8
X_2750_ _0692_ VGND VGND VPWR VPWR _0693_ sky130_fd_sc_hd__inv_2
XFILLER_31_289 VGND VGND VPWR VPWR sky130_fd_sc_hd__fill_1
X_2681_ mantisaresult\[7\] net107 _0623_ VGND VGND VPWR VPWR _0624_ sky130_fd_sc_hd__a21o_1
X_3302_ net246 mantisaAshift\[52\] _1682_ VGND VGND VPWR VPWR _1180_ sky130_fd_sc_hd__nand3_1
X_3233_ _1105_ _1108_ _1106_ VGND VGND VPWR VPWR _1117_ sky130_fd_sc_hd__a21boi_1
X_3164_ _1050_ _1054_ VGND VGND VPWR VPWR _1055_ sky130_fd_sc_hd__xor2_1
X_2115_ net10 net2 VGND VGND VPWR VPWR _1776_ sky130_fd_sc_hd__and2b_1
X_3095_ net242 _1675_ _0997_ net235 VGND VGND VPWR VPWR _0999_ sky130_fd_sc_hd__a31o_1
XFILLER_39_389 VGND VGND VPWR VPWR sky130_fd_sc_hd__decap_3
X_2046_ _1734_ _1735_ VGND VGND VPWR VPWR _1736_ sky130_fd_sc_hd__xnor2_1
XFILLER_54_359 VGND VGND VPWR VPWR sky130_fd_sc_hd__fill_2
X_3997_ clknet_leaf_25_clk _0108_ VGND VGND VPWR VPWR mantisaresult\[3\] sky130_fd_sc_hd__dfxtp_1
XFILLER_10_418 VGND VGND VPWR VPWR sky130_fd_sc_hd__fill_2
XFILLER_22_278 VGND VGND VPWR VPWR sky130_fd_sc_hd__decap_3
X_2948_ net223 net113 _0879_ net134 VGND VGND VPWR VPWR _0880_ sky130_fd_sc_hd__o2bb2a_1
X_2879_ _0818_ VGND VGND VPWR VPWR _0819_ sky130_fd_sc_hd__inv_2
XFILLER_1_105 VGND VGND VPWR VPWR sky130_fd_sc_hd__decap_6
XFILLER_1_149 VPWR VGND VPWR VGND sky130_ef_sc_hd__decap_12
Xmax_cap182 net183 VGND VGND VPWR VPWR net182 sky130_fd_sc_hd__clkbuf_1
XFILLER_77_429 VPWR VGND VPWR VGND sky130_ef_sc_hd__decap_12
XFILLER_45_348 VGND VGND VPWR VPWR sky130_fd_sc_hd__decap_8
XTAP_TAPCELL_ROW_0_160 VGND VPWR sky130_fd_sc_hd__tapvpwrvgnd_1
XTAP_TAPCELL_ROW_0_171 VGND VPWR sky130_fd_sc_hd__tapvpwrvgnd_1
XTAP_TAPCELL_ROW_43_516 VGND VPWR sky130_fd_sc_hd__tapvpwrvgnd_1
XFILLER_60_307 VGND VGND VPWR VPWR sky130_fd_sc_hd__fill_1
XFILLER_9_205 VGND VGND VPWR VPWR sky130_fd_sc_hd__decap_4
XTAP_TAPCELL_ROW_51_582 VGND VPWR sky130_fd_sc_hd__tapvpwrvgnd_1
Xclkload19 clknet_leaf_13_clk VGND VGND VPWR VPWR clkload19/Y sky130_fd_sc_hd__clkinv_8
XFILLER_79_85 VPWR VGND VPWR VGND sky130_ef_sc_hd__decap_12
XFILLER_0_193 VGND VGND VPWR VPWR sky130_fd_sc_hd__decap_3
XFILLER_48_153 VGND VGND VPWR VPWR sky130_fd_sc_hd__fill_1
X_3920_ clknet_leaf_26_clk _0043_ VGND VGND VPWR VPWR expmiddlea\[2\] sky130_fd_sc_hd__dfxtp_1
X_3851_ net259 net190 _1597_ VGND VGND VPWR VPWR _0270_ sky130_fd_sc_hd__nor3_1
X_2802_ net151 net149 VGND VGND VPWR VPWR _0744_ sky130_fd_sc_hd__or2_1
X_3782_ _1568_ _1562_ net263 VGND VGND VPWR VPWR _1596_ sky130_fd_sc_hd__mux2_1
XTAP_TAPCELL_ROW_14_284 VGND VPWR sky130_fd_sc_hd__tapvpwrvgnd_1
X_2733_ mantisaresult\[14\] net153 VGND VGND VPWR VPWR _0676_ sky130_fd_sc_hd__nand2_1
X_2664_ expmiddlec\[1\] _0593_ _0601_ VGND VGND VPWR VPWR _0607_ sky130_fd_sc_hd__mux2_1
X_2595_ net227 _0311_ _0326_ _0397_ _0537_ VGND VGND VPWR VPWR _0538_ sky130_fd_sc_hd__a311o_1
XTAP_TAPCELL_ROW_6_219 VGND VPWR sky130_fd_sc_hd__tapvpwrvgnd_1
XFILLER_5_93 VPWR VGND VPWR VGND sky130_ef_sc_hd__decap_12
Xfanout217 inf2 VGND VGND VPWR VPWR net217 sky130_fd_sc_hd__clkbuf_2
Xfanout206 net207 VGND VGND VPWR VPWR net206 sky130_fd_sc_hd__buf_2
Xfanout228 mantisaresult\[40\] VGND VGND VPWR VPWR net228 sky130_fd_sc_hd__clkbuf_2
Xfanout239 net243 VGND VGND VPWR VPWR net239 sky130_fd_sc_hd__buf_2
X_3216_ _1089_ _1092_ _1101_ VGND VGND VPWR VPWR _1102_ sky130_fd_sc_hd__a21o_1
X_3147_ mantisaresult\[39\] _1039_ net205 VGND VGND VPWR VPWR _0148_ sky130_fd_sc_hd__mux2_1
XFILLER_54_134 VGND VGND VPWR VPWR sky130_fd_sc_hd__decap_6
X_3078_ mantisaBshift\[23\] mantisaBshift\[24\] _0969_ VGND VGND VPWR VPWR _0986_
+ sky130_fd_sc_hd__or3_1
X_2029_ expmiddled\[0\] expadd\[0\] VGND VGND VPWR VPWR _1722_ sky130_fd_sc_hd__or2_1
XFILLER_10_237 VPWR VGND VPWR VGND sky130_ef_sc_hd__decap_12
XFILLER_40_79 VGND VGND VPWR VPWR sky130_fd_sc_hd__decap_4
XFILLER_2_469 VGND VGND VPWR VPWR sky130_fd_sc_hd__decap_4
XFILLER_77_237 VPWR VGND VPWR VGND sky130_ef_sc_hd__decap_12
XFILLER_26_381 VGND VGND VPWR VPWR sky130_fd_sc_hd__decap_6
XTAP_TAPCELL_ROW_28_398 VGND VPWR sky130_fd_sc_hd__tapvpwrvgnd_1
X_2380_ net188 _0312_ _0314_ _0322_ VGND VGND VPWR VPWR _0323_ sky130_fd_sc_hd__nor4_1
XFILLER_68_237 VPWR VGND VPWR VGND sky130_ef_sc_hd__decap_12
X_4050_ clknet_leaf_14_clk _0161_ VGND VGND VPWR VPWR mantisaresult\[51\] sky130_fd_sc_hd__dfxtp_2
Xinput6 expa[5] VGND VGND VPWR VPWR net6 sky130_fd_sc_hd__buf_1
X_3001_ net151 _0604_ VGND VGND VPWR VPWR _0922_ sky130_fd_sc_hd__nand2_2
XTAP_TAPCELL_ROW_19_321 VGND VPWR sky130_fd_sc_hd__tapvpwrvgnd_1
XFILLER_51_104 VGND VGND VPWR VPWR sky130_fd_sc_hd__decap_8
XFILLER_51_137 VGND VGND VPWR VPWR sky130_fd_sc_hd__decap_6
X_3903_ clknet_leaf_16_clk _0026_ VGND VGND VPWR VPWR net81 sky130_fd_sc_hd__dfxtp_1
XTAP_TAPCELL_ROW_62_666 VGND VPWR sky130_fd_sc_hd__tapvpwrvgnd_1
X_3834_ net259 _1569_ VGND VGND VPWR VPWR _1618_ sky130_fd_sc_hd__nor2_1
XFILLER_32_395 VPWR VGND VPWR VGND sky130_ef_sc_hd__decap_12
X_3765_ _1536_ _1526_ net264 VGND VGND VPWR VPWR _1583_ sky130_fd_sc_hd__mux2_1
X_2716_ net135 _0657_ net114 mantisaresult\[36\] VGND VGND VPWR VPWR _0659_ sky130_fd_sc_hd__a2bb2o_1
X_3696_ _1520_ _1521_ net266 VGND VGND VPWR VPWR _1522_ sky130_fd_sc_hd__mux2_1
X_2647_ expmiddlec\[1\] expmiddlec\[0\] _0569_ VGND VGND VPWR VPWR _0590_ sky130_fd_sc_hd__and3_1
XFILLER_10_27 VGND VGND VPWR VPWR sky130_fd_sc_hd__fill_1
X_2578_ _0480_ _0520_ _0515_ _0513_ VGND VGND VPWR VPWR _0521_ sky130_fd_sc_hd__or4b_1
XFILLER_70_413 VGND VGND VPWR VPWR sky130_fd_sc_hd__decap_6
XFILLER_35_79 VGND VGND VPWR VPWR sky130_fd_sc_hd__decap_6
XFILLER_70_457 VGND VGND VPWR VPWR sky130_fd_sc_hd__decap_8
XFILLER_23_351 VGND VGND VPWR VPWR sky130_fd_sc_hd__decap_8
XTAP_TAPCELL_ROW_25_368 VGND VPWR sky130_fd_sc_hd__tapvpwrvgnd_1
XPHY_EDGE_ROW_14_Right_14 VGND VGND VPWR VPWR sky130_fd_sc_hd__decap_3
XFILLER_51_34 VPWR VGND VPWR VGND sky130_ef_sc_hd__decap_12
XFILLER_2_233 VPWR VGND VPWR VGND sky130_ef_sc_hd__decap_12
XFILLER_2_277 VGND VGND VPWR VPWR sky130_fd_sc_hd__decap_4
XPHY_EDGE_ROW_23_Right_23 VGND VGND VPWR VPWR sky130_fd_sc_hd__decap_3
XFILLER_76_53 VGND VGND VPWR VPWR sky130_fd_sc_hd__decap_8
XFILLER_18_123 VGND VGND VPWR VPWR sky130_fd_sc_hd__fill_1
XFILLER_18_167 VGND VGND VPWR VPWR sky130_fd_sc_hd__decap_3
XTAP_TAPCELL_ROW_16_302 VGND VPWR sky130_fd_sc_hd__tapvpwrvgnd_1
XFILLER_33_126 VGND VGND VPWR VPWR sky130_fd_sc_hd__decap_3
XPHY_EDGE_ROW_32_Right_32 VGND VGND VPWR VPWR sky130_fd_sc_hd__decap_3
X_3550_ _1378_ _1384_ net157 VGND VGND VPWR VPWR _1385_ sky130_fd_sc_hd__o21a_1
X_2501_ mantisaresult\[1\] _0435_ _0443_ mantisaresult\[0\] VGND VGND VPWR VPWR _0444_
+ sky130_fd_sc_hd__or4b_1
X_3481_ net106 _0885_ _0921_ _0883_ VGND VGND VPWR VPWR _1327_ sky130_fd_sc_hd__a22o_1
X_2432_ _0362_ _0374_ VGND VGND VPWR VPWR _0375_ sky130_fd_sc_hd__or2_1
XPHY_EDGE_ROW_41_Right_41 VGND VGND VPWR VPWR sky130_fd_sc_hd__decap_3
X_2363_ _0298_ _0299_ _0304_ VGND VGND VPWR VPWR _0306_ sky130_fd_sc_hd__or3_4
X_4102_ clknet_leaf_15_clk _0209_ VGND VGND VPWR VPWR four_man\[61\] sky130_fd_sc_hd__dfxtp_1
X_2294_ net31 _1917_ net100 VGND VGND VPWR VPWR _1918_ sky130_fd_sc_hd__mux2_1
X_4033_ clknet_leaf_2_clk _0144_ VGND VGND VPWR VPWR mantisaresult\[35\] sky130_fd_sc_hd__dfxtp_1
XFILLER_2_83 VGND VGND VPWR VPWR sky130_fd_sc_hd__fill_1
XFILLER_49_281 VPWR VGND VPWR VGND sky130_ef_sc_hd__decap_12
XPHY_EDGE_ROW_50_Right_50 VGND VGND VPWR VPWR sky130_fd_sc_hd__decap_3
XFILLER_24_159 VGND VGND VPWR VPWR sky130_fd_sc_hd__decap_4
XTAP_TAPCELL_ROW_22_349 VGND VPWR sky130_fd_sc_hd__tapvpwrvgnd_1
XFILLER_20_365 VPWR VGND VPWR VGND sky130_ef_sc_hd__decap_12
X_3817_ _1498_ net189 VGND VGND VPWR VPWR _0251_ sky130_fd_sc_hd__nor2_1
X_3748_ net187 _1567_ _1569_ _1501_ VGND VGND VPWR VPWR _0219_ sky130_fd_sc_hd__a2bb2o_1
X_3679_ _1685_ _1441_ _1505_ VGND VGND VPWR VPWR _1506_ sky130_fd_sc_hd__o21a_1
XFILLER_28_465 VGND VGND VPWR VPWR sky130_fd_sc_hd__decap_8
XFILLER_46_45 VGND VGND VPWR VPWR sky130_fd_sc_hd__fill_2
XFILLER_43_435 VGND VGND VPWR VPWR sky130_fd_sc_hd__decap_6
XFILLER_55_273 VGND VGND VPWR VPWR sky130_fd_sc_hd__decap_6
XFILLER_15_159 VGND VGND VPWR VPWR sky130_fd_sc_hd__decap_8
XFILLER_43_457 VPWR VGND VPWR VGND sky130_ef_sc_hd__decap_12
XFILLER_23_181 VGND VGND VPWR VPWR sky130_fd_sc_hd__decap_8
XFILLER_11_365 VPWR VGND VPWR VGND sky130_ef_sc_hd__decap_12
XFILLER_11_387 VGND VGND VPWR VPWR sky130_fd_sc_hd__decap_4
XFILLER_78_321 VPWR VGND VPWR VGND sky130_ef_sc_hd__decap_12
XFILLER_78_365 VPWR VGND VPWR VGND sky130_ef_sc_hd__decap_12
XFILLER_46_251 VGND VGND VPWR VPWR sky130_fd_sc_hd__fill_1
XTAP_TAPCELL_ROW_72_750 VGND VPWR sky130_fd_sc_hd__tapvpwrvgnd_1
X_2981_ net239 _0906_ mantisaBshift\[9\] VGND VGND VPWR VPWR _0907_ sky130_fd_sc_hd__a21oi_1
XFILLER_61_276 VGND VGND VPWR VPWR sky130_fd_sc_hd__decap_4
X_1932_ mantisaresult\[4\] VGND VGND VPWR VPWR _1627_ sky130_fd_sc_hd__inv_2
XFILLER_21_129 VPWR VGND VPWR VGND sky130_ef_sc_hd__decap_12
Xinput31 mantisaA[22] VGND VGND VPWR VPWR net31 sky130_fd_sc_hd__buf_1
X_3602_ mantisaB0\[8\] net193 _1432_ net273 VGND VGND VPWR VPWR _1433_ sky130_fd_sc_hd__a22o_1
Xinput20 mantisaA[12] VGND VGND VPWR VPWR net20 sky130_fd_sc_hd__buf_1
Xinput42 mantisaB[11] VGND VGND VPWR VPWR net42 sky130_fd_sc_hd__clkbuf_1
Xinput64 signa VGND VGND VPWR VPWR net64 sky130_fd_sc_hd__buf_1
Xinput53 mantisaB[21] VGND VGND VPWR VPWR net53 sky130_fd_sc_hd__buf_1
X_3533_ _1368_ _1323_ net145 VGND VGND VPWR VPWR _1369_ sky130_fd_sc_hd__mux2_1
X_3464_ net341 net213 _1316_ VGND VGND VPWR VPWR _0188_ sky130_fd_sc_hd__a21o_1
X_2415_ mantisaresult\[30\] _0294_ _0354_ VGND VGND VPWR VPWR _0358_ sky130_fd_sc_hd__or3_1
X_3395_ _1262_ _1264_ VGND VGND VPWR VPWR _1265_ sky130_fd_sc_hd__and2_1
XFILLER_69_343 VGND VGND VPWR VPWR sky130_fd_sc_hd__decap_4
X_2346_ _1759_ _0290_ _0289_ VGND VGND VPWR VPWR _0096_ sky130_fd_sc_hd__a21o_1
X_2277_ _1906_ net297 net173 VGND VGND VPWR VPWR _0065_ sky130_fd_sc_hd__mux2_1
X_4016_ clknet_leaf_24_clk _0127_ VGND VGND VPWR VPWR mantisaresult\[20\] sky130_fd_sc_hd__dfxtp_2
XFILLER_16_37 VPWR VGND VPWR VGND sky130_ef_sc_hd__decap_12
XTAP_TAPCELL_ROW_35_452 VGND VPWR sky130_fd_sc_hd__tapvpwrvgnd_1
XFILLER_52_298 VGND VGND VPWR VPWR sky130_fd_sc_hd__decap_8
XFILLER_32_25 VGND VGND VPWR VPWR sky130_fd_sc_hd__decap_3
XFILLER_4_317 VGND VGND VPWR VPWR sky130_fd_sc_hd__decap_6
XFILLER_4_339 VPWR VGND VPWR VGND sky130_ef_sc_hd__decap_12
XFILLER_57_44 VGND VGND VPWR VPWR sky130_fd_sc_hd__fill_2
XFILLER_57_55 VGND VGND VPWR VPWR sky130_fd_sc_hd__fill_1
XFILLER_28_251 VGND VGND VPWR VPWR sky130_fd_sc_hd__fill_1
XFILLER_16_457 VPWR VGND VPWR VGND sky130_ef_sc_hd__decap_12
Xclkbuf_leaf_23_clk clknet_2_2__leaf_clk VGND VGND VPWR VPWR clknet_leaf_23_clk sky130_fd_sc_hd__clkbuf_8
XFILLER_31_449 VGND VGND VPWR VPWR sky130_fd_sc_hd__decap_4
XFILLER_43_287 VGND VGND VPWR VPWR sky130_fd_sc_hd__fill_1
XTAP_TAPCELL_ROW_41_499 VGND VPWR sky130_fd_sc_hd__tapvpwrvgnd_1
X_2200_ _1791_ _1832_ _1794_ VGND VGND VPWR VPWR _1856_ sky130_fd_sc_hd__a21oi_1
X_3180_ mantisaBshift\[42\] mantisaAshift\[42\] VGND VGND VPWR VPWR _1069_ sky130_fd_sc_hd__and2b_1
XFILLER_78_195 VGND VGND VPWR VPWR sky130_fd_sc_hd__fill_1
X_2131_ _1788_ _1791_ _1775_ VGND VGND VPWR VPWR _1792_ sky130_fd_sc_hd__a21oi_1
X_2062_ _1743_ _1745_ _1742_ VGND VGND VPWR VPWR _1749_ sky130_fd_sc_hd__a21bo_1
XTAP_TAPCELL_ROW_49_566 VGND VPWR sky130_fd_sc_hd__tapvpwrvgnd_1
XFILLER_19_284 VPWR VGND VPWR VGND sky130_ef_sc_hd__decap_12
X_2964_ net239 _1674_ _0893_ net231 VGND VGND VPWR VPWR _0895_ sky130_fd_sc_hd__a31o_1
XFILLER_22_438 VGND VGND VPWR VPWR sky130_fd_sc_hd__fill_2
Xclkbuf_leaf_14_clk clknet_2_3__leaf_clk VGND VGND VPWR VPWR clknet_leaf_14_clk sky130_fd_sc_hd__clkbuf_8
XFILLER_30_460 VPWR VGND VPWR VGND sky130_ef_sc_hd__decap_12
X_2895_ net140 _0656_ _0833_ VGND VGND VPWR VPWR _0834_ sky130_fd_sc_hd__o21ai_1
X_3516_ _1347_ _1353_ net157 VGND VGND VPWR VPWR _1354_ sky130_fd_sc_hd__o21a_1
XPHY_EDGE_ROW_4_Right_4 VGND VGND VPWR VPWR sky130_fd_sc_hd__decap_3
X_3447_ net364 net213 _1304_ expmiddlec\[7\] VGND VGND VPWR VPWR _0183_ sky130_fd_sc_hd__a22o_1
X_3378_ _1237_ _1244_ _1238_ VGND VGND VPWR VPWR _1249_ sky130_fd_sc_hd__o21ai_1
XFILLER_69_151 VPWR VGND VPWR VGND sky130_ef_sc_hd__decap_12
X_2329_ _0281_ net374 net176 VGND VGND VPWR VPWR _0088_ sky130_fd_sc_hd__mux2_1
XFILLER_27_36 VPWR VGND VPWR VGND sky130_ef_sc_hd__decap_12
XFILLER_13_405 VPWR VGND VPWR VGND sky130_ef_sc_hd__decap_12
XFILLER_13_449 VPWR VGND VPWR VGND sky130_ef_sc_hd__decap_12
XFILLER_9_409 VPWR VGND VPWR VGND sky130_ef_sc_hd__decap_12
XFILLER_43_57 VGND VGND VPWR VPWR sky130_fd_sc_hd__decap_3
XFILLER_4_29 VPWR VGND VPWR VGND sky130_ef_sc_hd__decap_12
XFILLER_68_43 VGND VGND VPWR VPWR sky130_fd_sc_hd__decap_3
XFILLER_75_121 VGND VGND VPWR VPWR sky130_fd_sc_hd__decap_8
XFILLER_75_154 VPWR VGND VPWR VGND sky130_ef_sc_hd__decap_12
XTAP_TAPCELL_ROW_46_536 VGND VPWR sky130_fd_sc_hd__tapvpwrvgnd_1
XFILLER_71_393 VPWR VGND VPWR VGND sky130_ef_sc_hd__decap_12
XFILLER_31_279 VGND VGND VPWR VPWR sky130_fd_sc_hd__fill_1
XFILLER_76_6 VGND VGND VPWR VPWR sky130_fd_sc_hd__fill_1
X_2680_ mantisaresult\[6\] net152 net130 VGND VGND VPWR VPWR _0623_ sky130_fd_sc_hd__and3_1
X_3301_ _1161_ _1173_ _1162_ VGND VGND VPWR VPWR _1179_ sky130_fd_sc_hd__o21a_1
Xclkbuf_leaf_3_clk clknet_2_1__leaf_clk VGND VGND VPWR VPWR clknet_leaf_3_clk sky130_fd_sc_hd__clkbuf_8
X_3232_ _1114_ _1115_ VGND VGND VPWR VPWR _1116_ sky130_fd_sc_hd__nand2b_1
X_3163_ _1051_ _1053_ net244 VGND VGND VPWR VPWR _1054_ sky130_fd_sc_hd__mux2_1
X_2114_ _1773_ _1774_ VGND VGND VPWR VPWR _1775_ sky130_fd_sc_hd__or2_1
X_3094_ net242 _0997_ _1675_ VGND VGND VPWR VPWR _0998_ sky130_fd_sc_hd__a21oi_1
X_2045_ _1728_ _1730_ _1727_ VGND VGND VPWR VPWR _1735_ sky130_fd_sc_hd__a21bo_1
XFILLER_22_224 VGND VGND VPWR VPWR sky130_fd_sc_hd__fill_2
XFILLER_62_393 VGND VGND VPWR VPWR sky130_fd_sc_hd__decap_8
X_3996_ clknet_leaf_25_clk _0107_ VGND VGND VPWR VPWR mantisaresult\[2\] sky130_fd_sc_hd__dfxtp_1
X_2947_ net222 net155 VGND VGND VPWR VPWR _0879_ sky130_fd_sc_hd__nand2_1
X_2878_ _0817_ _0816_ net142 VGND VGND VPWR VPWR _0818_ sky130_fd_sc_hd__mux2_1
XPHY_EDGE_ROW_13_Left_93 VGND VGND VPWR VPWR sky130_fd_sc_hd__decap_3
XPHY_EDGE_ROW_79_Right_79 VGND VGND VPWR VPWR sky130_fd_sc_hd__decap_3
XFILLER_57_165 VGND VGND VPWR VPWR sky130_fd_sc_hd__decap_3
XTAP_TAPCELL_ROW_0_161 VGND VPWR sky130_fd_sc_hd__tapvpwrvgnd_1
XTAP_TAPCELL_ROW_0_172 VGND VPWR sky130_fd_sc_hd__tapvpwrvgnd_1
XTAP_TAPCELL_ROW_43_517 VGND VPWR sky130_fd_sc_hd__tapvpwrvgnd_1
XFILLER_54_67 VGND VGND VPWR VPWR sky130_fd_sc_hd__fill_1
XFILLER_13_279 VGND VGND VPWR VPWR sky130_fd_sc_hd__fill_1
XTAP_TAPCELL_ROW_51_583 VGND VPWR sky130_fd_sc_hd__tapvpwrvgnd_1
XFILLER_5_401 VPWR VGND VPWR VGND sky130_ef_sc_hd__decap_12
XFILLER_5_445 VGND VGND VPWR VPWR sky130_fd_sc_hd__decap_3
XFILLER_79_97 VPWR VGND VPWR VGND sky130_ef_sc_hd__decap_12
XFILLER_63_102 VGND VGND VPWR VPWR sky130_fd_sc_hd__decap_8
XFILLER_63_113 VGND VGND VPWR VPWR sky130_fd_sc_hd__decap_6
X_3850_ net192 _1605_ VGND VGND VPWR VPWR _0269_ sky130_fd_sc_hd__and2_1
X_2801_ net151 net149 VGND VGND VPWR VPWR _0743_ sky130_fd_sc_hd__nor2_1
X_3781_ net186 _1595_ VGND VGND VPWR VPWR _0226_ sky130_fd_sc_hd__nor2_1
XTAP_TAPCELL_ROW_14_285 VGND VPWR sky130_fd_sc_hd__tapvpwrvgnd_1
X_2732_ mantisaresult\[13\] net107 _0674_ net131 VGND VGND VPWR VPWR _0675_ sky130_fd_sc_hd__a22o_1
X_2663_ expmiddlec\[2\] _0588_ _0601_ VGND VGND VPWR VPWR _0606_ sky130_fd_sc_hd__mux2_1
X_2594_ net221 _0343_ _0406_ net179 VGND VGND VPWR VPWR _0537_ sky130_fd_sc_hd__a211o_1
Xfanout218 mantisaresult\[53\] VGND VGND VPWR VPWR net218 sky130_fd_sc_hd__buf_2
Xfanout229 mantisaresult\[34\] VGND VGND VPWR VPWR net229 sky130_fd_sc_hd__buf_2
Xfanout207 net208 VGND VGND VPWR VPWR net207 sky130_fd_sc_hd__buf_2
X_3215_ mantisaBshift\[44\] mantisaAshift\[44\] VGND VGND VPWR VPWR _1101_ sky130_fd_sc_hd__and2b_1
X_3146_ _1037_ _1038_ VGND VGND VPWR VPWR _1039_ sky130_fd_sc_hd__xnor2_1
X_3077_ mantisaresult\[24\] _0985_ net202 VGND VGND VPWR VPWR _0132_ sky130_fd_sc_hd__mux2_1
X_2028_ expmiddled\[0\] expadd\[0\] VGND VGND VPWR VPWR _1721_ sky130_fd_sc_hd__nand2_1
XFILLER_35_393 VPWR VGND VPWR VGND sky130_ef_sc_hd__decap_12
XFILLER_50_330 VGND VGND VPWR VPWR sky130_fd_sc_hd__decap_3
XFILLER_50_363 VGND VGND VPWR VPWR sky130_fd_sc_hd__fill_1
XFILLER_50_374 VPWR VGND VPWR VGND sky130_ef_sc_hd__decap_12
XFILLER_10_249 VGND VGND VPWR VPWR sky130_fd_sc_hd__decap_3
X_3979_ clknet_leaf_17_clk _0101_ VGND VGND VPWR VPWR four_man\[42\] sky130_fd_sc_hd__dfxtp_1
XFILLER_6_209 VPWR VGND VPWR VGND sky130_ef_sc_hd__decap_12
XFILLER_6_6 VPWR VGND VPWR VGND sky130_ef_sc_hd__decap_12
XFILLER_77_249 VPWR VGND VPWR VGND sky130_ef_sc_hd__decap_12
XFILLER_45_113 VGND VGND VPWR VPWR sky130_fd_sc_hd__decap_6
XTAP_TAPCELL_ROW_56_620 VGND VPWR sky130_fd_sc_hd__tapvpwrvgnd_1
XFILLER_33_308 VGND VGND VPWR VPWR sky130_fd_sc_hd__fill_1
XFILLER_45_157 VGND VGND VPWR VPWR sky130_fd_sc_hd__fill_2
XTAP_TAPCELL_ROW_28_399 VGND VPWR sky130_fd_sc_hd__tapvpwrvgnd_1
XFILLER_53_190 VGND VGND VPWR VPWR sky130_fd_sc_hd__fill_2
XFILLER_41_385 VGND VGND VPWR VPWR sky130_fd_sc_hd__decap_3
XFILLER_68_249 VGND VGND VPWR VPWR sky130_fd_sc_hd__decap_3
Xinput7 expa[6] VGND VGND VPWR VPWR net7 sky130_fd_sc_hd__clkbuf_1
X_3000_ net150 _0605_ VGND VGND VPWR VPWR _0921_ sky130_fd_sc_hd__nor2_4
XTAP_TAPCELL_ROW_19_322 VGND VPWR sky130_fd_sc_hd__tapvpwrvgnd_1
XFILLER_64_411 VGND VGND VPWR VPWR sky130_fd_sc_hd__fill_1
XFILLER_32_330 VGND VGND VPWR VPWR sky130_fd_sc_hd__decap_3
XTAP_TAPCELL_ROW_62_667 VGND VPWR sky130_fd_sc_hd__tapvpwrvgnd_1
X_3902_ clknet_leaf_16_clk _0025_ VGND VGND VPWR VPWR net80 sky130_fd_sc_hd__dfxtp_1
XFILLER_32_363 VGND VGND VPWR VPWR sky130_fd_sc_hd__fill_1
X_3833_ net252 net186 _1558_ _1617_ VGND VGND VPWR VPWR _0256_ sky130_fd_sc_hd__o31ai_1
X_3764_ net258 _1581_ VGND VGND VPWR VPWR _1582_ sky130_fd_sc_hd__nand2_1
X_3695_ _1489_ _1493_ net272 VGND VGND VPWR VPWR _1521_ sky130_fd_sc_hd__mux2_1
X_2715_ _0657_ VGND VGND VPWR VPWR _0658_ sky130_fd_sc_hd__inv_2
X_2646_ expmiddlec\[2\] _0587_ VGND VGND VPWR VPWR _0589_ sky130_fd_sc_hd__nor2_1
X_2577_ _0384_ _0390_ _0516_ _0519_ VGND VGND VPWR VPWR _0520_ sky130_fd_sc_hd__or4b_1
XFILLER_27_102 VGND VGND VPWR VPWR sky130_fd_sc_hd__decap_8
XFILLER_27_113 VPWR VGND VPWR VGND sky130_ef_sc_hd__decap_12
XFILLER_27_157 VGND VGND VPWR VPWR sky130_fd_sc_hd__fill_1
X_3129_ mantisaBshift\[32\] mantisaBshift\[33\] mantisaBshift\[34\] _1005_ net242
+ VGND VGND VPWR VPWR _1026_ sky130_fd_sc_hd__o41a_1
XFILLER_23_341 VGND VGND VPWR VPWR sky130_fd_sc_hd__fill_1
XFILLER_42_138 VGND VGND VPWR VPWR sky130_fd_sc_hd__fill_2
XTAP_TAPCELL_ROW_25_369 VGND VPWR sky130_fd_sc_hd__tapvpwrvgnd_1
XFILLER_50_171 VPWR VGND VPWR VGND sky130_ef_sc_hd__decap_12
XFILLER_51_46 VGND VGND VPWR VPWR sky130_fd_sc_hd__decap_3
XFILLER_51_57 VGND VGND VPWR VPWR sky130_fd_sc_hd__decap_3
XFILLER_2_245 VGND VGND VPWR VPWR sky130_fd_sc_hd__decap_6
XFILLER_4_3 VPWR VGND VPWR VGND sky130_ef_sc_hd__decap_12
XPHY_EDGE_ROW_29_Left_109 VGND VGND VPWR VPWR sky130_fd_sc_hd__decap_3
XFILLER_65_208 VGND VGND VPWR VPWR sky130_fd_sc_hd__fill_1
XTAP_TAPCELL_ROW_16_303 VGND VPWR sky130_fd_sc_hd__tapvpwrvgnd_1
XPHY_EDGE_ROW_38_Left_118 VGND VGND VPWR VPWR sky130_fd_sc_hd__decap_3
XFILLER_61_447 VGND VGND VPWR VPWR sky130_fd_sc_hd__fill_1
XFILLER_14_374 VPWR VGND VPWR VGND sky130_ef_sc_hd__decap_12
X_2500_ mantisaresult\[3\] mantisaresult\[2\] _0442_ VGND VGND VPWR VPWR _0443_ sky130_fd_sc_hd__or3_1
X_3480_ net106 _0873_ _1325_ net126 VGND VGND VPWR VPWR _1326_ sky130_fd_sc_hd__a211o_1
XFILLER_41_90 VGND VGND VPWR VPWR sky130_fd_sc_hd__decap_4
X_2431_ _0293_ _0294_ _0314_ _0355_ VGND VGND VPWR VPWR _0374_ sky130_fd_sc_hd__or4_1
XPHY_EDGE_ROW_47_Left_127 VGND VGND VPWR VPWR sky130_fd_sc_hd__decap_3
X_2362_ _0298_ _0299_ _0304_ VGND VGND VPWR VPWR _0305_ sky130_fd_sc_hd__nor3_1
X_2293_ net54 net168 VGND VGND VPWR VPWR _1917_ sky130_fd_sc_hd__and2_1
X_4101_ clknet_leaf_15_clk _0208_ VGND VGND VPWR VPWR four_man\[60\] sky130_fd_sc_hd__dfxtp_1
X_4032_ clknet_leaf_13_clk _0143_ VGND VGND VPWR VPWR mantisaresult\[34\] sky130_fd_sc_hd__dfxtp_1
XTAP_TAPCELL_ROW_67_704 VGND VPWR sky130_fd_sc_hd__tapvpwrvgnd_1
XFILLER_49_293 VPWR VGND VPWR VGND sky130_ef_sc_hd__decap_12
XPHY_EDGE_ROW_56_Left_136 VGND VGND VPWR VPWR sky130_fd_sc_hd__decap_3
XTAP_TAPCELL_ROW_75_770 VGND VPWR sky130_fd_sc_hd__tapvpwrvgnd_1
XFILLER_24_105 VGND VGND VPWR VPWR sky130_fd_sc_hd__fill_1
XFILLER_52_425 VGND VGND VPWR VPWR sky130_fd_sc_hd__decap_6
XFILLER_52_447 VGND VGND VPWR VPWR sky130_fd_sc_hd__fill_2
X_3816_ net191 _1598_ VGND VGND VPWR VPWR _0250_ sky130_fd_sc_hd__nor2_1
XFILLER_20_377 VGND VGND VPWR VPWR sky130_fd_sc_hd__decap_6
XFILLER_21_27 VGND VGND VPWR VPWR sky130_fd_sc_hd__fill_1
X_3747_ net263 net267 _1533_ VGND VGND VPWR VPWR _1569_ sky130_fd_sc_hd__and3_1
XPHY_EDGE_ROW_65_Left_145 VGND VGND VPWR VPWR sky130_fd_sc_hd__decap_3
X_3678_ _1685_ _1433_ VGND VGND VPWR VPWR _1505_ sky130_fd_sc_hd__nand2_1
X_2629_ _0445_ _0506_ VGND VGND VPWR VPWR _0572_ sky130_fd_sc_hd__nor2_2
XPHY_EDGE_ROW_74_Left_154 VGND VGND VPWR VPWR sky130_fd_sc_hd__decap_3
XTAP_TAPCELL_ROW_38_472 VGND VPWR sky130_fd_sc_hd__tapvpwrvgnd_1
XFILLER_15_138 VGND VGND VPWR VPWR sky130_fd_sc_hd__fill_1
XFILLER_30_108 VGND VGND VPWR VPWR sky130_fd_sc_hd__fill_1
XFILLER_43_469 VGND VGND VPWR VPWR sky130_fd_sc_hd__decap_4
XFILLER_11_377 VGND VGND VPWR VPWR sky130_fd_sc_hd__fill_1
XFILLER_7_337 VPWR VGND VPWR VGND sky130_ef_sc_hd__decap_12
XFILLER_78_333 VPWR VGND VPWR VGND sky130_ef_sc_hd__decap_12
XFILLER_78_377 VPWR VGND VPWR VGND sky130_ef_sc_hd__decap_12
XPHY_EDGE_ROW_1_Left_81 VGND VGND VPWR VPWR sky130_fd_sc_hd__decap_3
XFILLER_34_447 VGND VGND VPWR VPWR sky130_fd_sc_hd__fill_1
XFILLER_61_233 VGND VGND VPWR VPWR sky130_fd_sc_hd__fill_1
X_2980_ mantisaBshift\[7\] mantisaBshift\[8\] _0901_ VGND VGND VPWR VPWR _0906_ sky130_fd_sc_hd__or3_1
XTAP_TAPCELL_ROW_72_751 VGND VPWR sky130_fd_sc_hd__tapvpwrvgnd_1
X_1931_ expmiddlec\[3\] VGND VGND VPWR VPWR _1626_ sky130_fd_sc_hd__inv_2
Xinput10 expb[1] VGND VGND VPWR VPWR net10 sky130_fd_sc_hd__buf_1
X_3601_ net250 mantisaB0\[9\] VGND VGND VPWR VPWR _1432_ sky130_fd_sc_hd__and2b_1
Xinput21 mantisaA[13] VGND VGND VPWR VPWR net21 sky130_fd_sc_hd__buf_1
Xinput54 mantisaB[22] VGND VGND VPWR VPWR net54 sky130_fd_sc_hd__buf_1
Xinput32 mantisaA[2] VGND VGND VPWR VPWR net32 sky130_fd_sc_hd__buf_1
Xinput43 mantisaB[12] VGND VGND VPWR VPWR net43 sky130_fd_sc_hd__buf_1
Xinput65 signb VGND VGND VPWR VPWR net65 sky130_fd_sc_hd__clkbuf_1
X_3532_ _1349_ _1367_ net119 VGND VGND VPWR VPWR _1368_ sky130_fd_sc_hd__mux2_1
X_3463_ _0471_ _0571_ _0530_ net208 VGND VGND VPWR VPWR _1316_ sky130_fd_sc_hd__o211a_1
X_2414_ net229 mantisaresult\[33\] _0350_ VGND VGND VPWR VPWR _0357_ sky130_fd_sc_hd__or3_1
X_3394_ _1248_ _1263_ _1261_ VGND VGND VPWR VPWR _1264_ sky130_fd_sc_hd__a21oi_1
X_2345_ net64 net65 _1714_ VGND VGND VPWR VPWR _0290_ sky130_fd_sc_hd__mux2_1
XFILLER_69_377 VPWR VGND VPWR VGND sky130_ef_sc_hd__decap_12
X_2276_ net24 _1905_ net100 VGND VGND VPWR VPWR _1906_ sky130_fd_sc_hd__mux2_1
X_4015_ clknet_leaf_24_clk _0126_ VGND VGND VPWR VPWR mantisaresult\[19\] sky130_fd_sc_hd__dfxtp_1
XFILLER_16_16 VGND VGND VPWR VPWR sky130_fd_sc_hd__fill_1
XFILLER_16_49 VPWR VGND VPWR VGND sky130_ef_sc_hd__decap_12
XFILLER_16_27 VGND VGND VPWR VPWR sky130_fd_sc_hd__fill_1
XTAP_TAPCELL_ROW_35_453 VGND VPWR sky130_fd_sc_hd__tapvpwrvgnd_1
XFILLER_20_152 VGND VGND VPWR VPWR sky130_fd_sc_hd__decap_6
XFILLER_20_185 VGND VGND VPWR VPWR sky130_fd_sc_hd__fill_1
XFILLER_28_285 VGND VGND VPWR VPWR sky130_fd_sc_hd__fill_2
XFILLER_16_469 VGND VGND VPWR VPWR sky130_fd_sc_hd__decap_4
XFILLER_43_299 VGND VGND VPWR VPWR sky130_fd_sc_hd__decap_8
XFILLER_11_130 VGND VGND VPWR VPWR sky130_fd_sc_hd__decap_4
XFILLER_7_167 VGND VGND VPWR VPWR sky130_fd_sc_hd__fill_1
XFILLER_3_340 VGND VGND VPWR VPWR sky130_fd_sc_hd__decap_8
XFILLER_78_141 VPWR VGND VPWR VGND sky130_ef_sc_hd__decap_12
XFILLER_21_6 VGND VGND VPWR VPWR sky130_fd_sc_hd__decap_4
X_2130_ _1782_ _1790_ _1783_ VGND VGND VPWR VPWR _1791_ sky130_fd_sc_hd__a21oi_1
X_2061_ expmiddled\[6\] expadd\[6\] VGND VGND VPWR VPWR _1748_ sky130_fd_sc_hd__or2_1
XTAP_TAPCELL_ROW_49_567 VGND VPWR sky130_fd_sc_hd__tapvpwrvgnd_1
XFILLER_19_296 VGND VGND VPWR VPWR sky130_fd_sc_hd__decap_6
X_2963_ net239 _0893_ _1674_ VGND VGND VPWR VPWR _0894_ sky130_fd_sc_hd__a21oi_1
XFILLER_30_472 VGND VGND VPWR VPWR sky130_fd_sc_hd__fill_1
X_2894_ net140 _0647_ VGND VGND VPWR VPWR _0833_ sky130_fd_sc_hd__nand2_1
XFILLER_8_83 VGND VGND VPWR VPWR sky130_fd_sc_hd__fill_1
X_3515_ _0665_ _0936_ _1352_ _0632_ VGND VGND VPWR VPWR _1353_ sky130_fd_sc_hd__a22o_1
X_3446_ net361 net213 _1304_ expmiddlec\[6\] VGND VGND VPWR VPWR _0182_ sky130_fd_sc_hd__a22o_1
X_3377_ mantisaAshift\[59\] mantisaBshift\[59\] VGND VGND VPWR VPWR _1248_ sky130_fd_sc_hd__xnor2_1
X_2328_ _1905_ net24 net101 VGND VGND VPWR VPWR _0281_ sky130_fd_sc_hd__mux2_1
XFILLER_57_303 VGND VGND VPWR VPWR sky130_fd_sc_hd__decap_6
XFILLER_57_325 VGND VGND VPWR VPWR sky130_fd_sc_hd__decap_8
XFILLER_69_163 VGND VGND VPWR VPWR sky130_fd_sc_hd__decap_4
XFILLER_69_185 VGND VGND VPWR VPWR sky130_fd_sc_hd__fill_2
XFILLER_27_48 VGND VGND VPWR VPWR sky130_fd_sc_hd__fill_2
X_2259_ _1894_ net289 net175 VGND VGND VPWR VPWR _0059_ sky130_fd_sc_hd__mux2_1
XFILLER_25_222 VGND VGND VPWR VPWR sky130_fd_sc_hd__fill_2
XFILLER_65_391 VGND VGND VPWR VPWR sky130_fd_sc_hd__fill_1
XFILLER_13_417 VPWR VGND VPWR VGND sky130_ef_sc_hd__decap_12
XFILLER_21_461 VPWR VGND VPWR VGND sky130_ef_sc_hd__decap_12
XFILLER_0_321 VGND VGND VPWR VPWR sky130_fd_sc_hd__decap_8
XFILLER_68_55 VGND VGND VPWR VPWR sky130_fd_sc_hd__decap_4
XFILLER_75_111 VGND VGND VPWR VPWR sky130_fd_sc_hd__fill_1
XFILLER_0_365 VPWR VGND VPWR VGND sky130_ef_sc_hd__decap_12
XFILLER_68_99 VGND VGND VPWR VPWR sky130_fd_sc_hd__decap_4
XFILLER_75_177 VGND VGND VPWR VPWR sky130_fd_sc_hd__fill_2
XFILLER_75_166 VGND VGND VPWR VPWR sky130_fd_sc_hd__fill_2
XFILLER_75_199 VGND VGND VPWR VPWR sky130_fd_sc_hd__decap_8
XTAP_TAPCELL_ROW_3_192 VGND VPWR sky130_fd_sc_hd__tapvpwrvgnd_1
XTAP_TAPCELL_ROW_46_537 VGND VPWR sky130_fd_sc_hd__tapvpwrvgnd_1
XFILLER_71_361 VGND VGND VPWR VPWR sky130_fd_sc_hd__decap_4
XFILLER_31_203 VGND VGND VPWR VPWR sky130_fd_sc_hd__decap_4
XFILLER_31_225 VPWR VGND VPWR VGND sky130_ef_sc_hd__decap_12
XFILLER_8_421 VPWR VGND VPWR VGND sky130_ef_sc_hd__decap_12
XFILLER_8_410 VGND VGND VPWR VPWR sky130_fd_sc_hd__decap_8
XFILLER_69_6 VGND VGND VPWR VPWR sky130_fd_sc_hd__fill_1
X_3300_ _1176_ _1177_ VGND VGND VPWR VPWR _1178_ sky130_fd_sc_hd__nand2b_1
XFILLER_3_181 VPWR VGND VPWR VGND sky130_ef_sc_hd__decap_12
XFILLER_79_461 VPWR VGND VPWR VGND sky130_ef_sc_hd__decap_12
X_3231_ mantisaAshift\[47\] mantisaBshift\[47\] VGND VGND VPWR VPWR _1115_ sky130_fd_sc_hd__nand2_1
X_3162_ _1042_ _1045_ _1052_ VGND VGND VPWR VPWR _1053_ sky130_fd_sc_hd__o21ai_1
X_2113_ net13 net5 VGND VGND VPWR VPWR _1774_ sky130_fd_sc_hd__and2b_1
X_3093_ mantisaBshift\[26\] mantisaBshift\[27\] mantisaBshift\[28\] _0989_ VGND VGND
+ VPWR VPWR _0997_ sky130_fd_sc_hd__or4_2
XFILLER_66_177 VGND VGND VPWR VPWR sky130_fd_sc_hd__fill_2
X_2044_ _1732_ _1733_ VGND VGND VPWR VPWR _1734_ sky130_fd_sc_hd__nand2_1
XFILLER_54_339 VPWR VGND VPWR VGND sky130_ef_sc_hd__decap_12
XFILLER_62_361 VGND VGND VPWR VPWR sky130_fd_sc_hd__decap_3
X_3995_ clknet_leaf_25_clk _0106_ VGND VGND VPWR VPWR mantisaresult\[1\] sky130_fd_sc_hd__dfxtp_1
X_2946_ net144 _0779_ _0877_ VGND VGND VPWR VPWR _0878_ sky130_fd_sc_hd__o21a_1
X_2877_ _0708_ _0712_ net116 VGND VGND VPWR VPWR _0817_ sky130_fd_sc_hd__mux2_1
X_3429_ _1293_ _0975_ net145 VGND VGND VPWR VPWR _1295_ sky130_fd_sc_hd__mux2_1
XFILLER_54_13 VGND VGND VPWR VPWR sky130_fd_sc_hd__fill_1
XFILLER_72_114 VGND VGND VPWR VPWR sky130_fd_sc_hd__fill_1
XTAP_TAPCELL_ROW_0_162 VGND VPWR sky130_fd_sc_hd__tapvpwrvgnd_1
XFILLER_54_46 VGND VGND VPWR VPWR sky130_fd_sc_hd__decap_6
XFILLER_60_309 VGND VGND VPWR VPWR sky130_fd_sc_hd__decap_4
XFILLER_13_225 VPWR VGND VPWR VGND sky130_ef_sc_hd__decap_12
XFILLER_13_214 VGND VGND VPWR VPWR sky130_fd_sc_hd__fill_1
XTAP_TAPCELL_ROW_0_173 VGND VPWR sky130_fd_sc_hd__tapvpwrvgnd_1
XTAP_TAPCELL_ROW_43_518 VGND VPWR sky130_fd_sc_hd__tapvpwrvgnd_1
XFILLER_5_413 VPWR VGND VPWR VGND sky130_ef_sc_hd__decap_12
XFILLER_79_54 VGND VGND VPWR VPWR sky130_fd_sc_hd__fill_2
XTAP_TAPCELL_ROW_59_640 VGND VPWR sky130_fd_sc_hd__tapvpwrvgnd_1
XFILLER_36_328 VGND VGND VPWR VPWR sky130_fd_sc_hd__decap_8
XFILLER_48_188 VGND VGND VPWR VPWR sky130_fd_sc_hd__decap_8
XFILLER_63_169 VGND VGND VPWR VPWR sky130_fd_sc_hd__decap_8
XFILLER_44_361 VGND VGND VPWR VPWR sky130_fd_sc_hd__decap_3
XFILLER_71_191 VGND VGND VPWR VPWR sky130_fd_sc_hd__decap_6
X_2800_ _0632_ _0741_ VGND VGND VPWR VPWR _0742_ sky130_fd_sc_hd__nand2_1
X_3780_ _1593_ _1594_ net255 VGND VGND VPWR VPWR _1595_ sky130_fd_sc_hd__mux2_1
XTAP_TAPCELL_ROW_14_286 VGND VPWR sky130_fd_sc_hd__tapvpwrvgnd_1
X_2731_ _0673_ VGND VGND VPWR VPWR _0674_ sky130_fd_sc_hd__inv_2
X_2662_ net149 VGND VGND VPWR VPWR _0605_ sky130_fd_sc_hd__inv_2
X_2593_ mantisaresult\[37\] _0307_ _0408_ _0346_ net222 VGND VGND VPWR VPWR _0536_
+ sky130_fd_sc_hd__a32o_1
Xfanout219 mantisaresult\[52\] VGND VGND VPWR VPWR net219 sky130_fd_sc_hd__buf_2
Xfanout208 _1687_ VGND VGND VPWR VPWR net208 sky130_fd_sc_hd__clkbuf_4
X_3214_ mantisaAshift\[44\] mantisaBshift\[44\] _1099_ VGND VGND VPWR VPWR _1100_
+ sky130_fd_sc_hd__o21ai_1
XFILLER_39_111 VGND VGND VPWR VPWR sky130_fd_sc_hd__fill_1
XFILLER_67_431 VGND VGND VPWR VPWR sky130_fd_sc_hd__fill_1
X_3145_ mantisaBshift\[36\] mantisaBshift\[37\] mantisaBshift\[38\] _1030_ net244
+ VGND VGND VPWR VPWR _1038_ sky130_fd_sc_hd__o41a_1
X_3076_ mantisaBshift\[24\] _0984_ VGND VGND VPWR VPWR _0985_ sky130_fd_sc_hd__xnor2_1
X_2027_ net347 _1720_ VGND VGND VPWR VPWR _0001_ sky130_fd_sc_hd__xnor2_1
XFILLER_42_309 VGND VGND VPWR VPWR sky130_fd_sc_hd__fill_2
XFILLER_35_372 VPWR VGND VPWR VGND sky130_ef_sc_hd__decap_12
XFILLER_24_38 VGND VGND VPWR VPWR sky130_fd_sc_hd__decap_3
X_3978_ clknet_2_3__leaf_clk _0100_ VGND VGND VPWR VPWR four_man\[41\] sky130_fd_sc_hd__dfxtp_1
XFILLER_50_386 VPWR VGND VPWR VGND sky130_ef_sc_hd__decap_12
X_2929_ net329 net208 _0864_ _0866_ VGND VGND VPWR VPWR _0103_ sky130_fd_sc_hd__o22a_1
XFILLER_49_13 VGND VGND VPWR VPWR sky130_fd_sc_hd__fill_1
XTAP_TAPCELL_ROW_5_210 VGND VPWR sky130_fd_sc_hd__tapvpwrvgnd_1
XFILLER_18_306 VGND VGND VPWR VPWR sky130_fd_sc_hd__fill_2
XFILLER_45_125 VPWR VGND VPWR VGND sky130_ef_sc_hd__decap_12
XTAP_TAPCELL_ROW_56_621 VGND VPWR sky130_fd_sc_hd__tapvpwrvgnd_1
XFILLER_45_169 VGND VGND VPWR VPWR sky130_fd_sc_hd__decap_8
XFILLER_26_361 VGND VGND VPWR VPWR sky130_fd_sc_hd__decap_3
XTAP_TAPCELL_ROW_11_256 VGND VPWR sky130_fd_sc_hd__tapvpwrvgnd_1
XFILLER_76_250 VGND VGND VPWR VPWR sky130_fd_sc_hd__fill_2
Xinput8 expa[7] VGND VGND VPWR VPWR net8 sky130_fd_sc_hd__clkbuf_1
XTAP_TAPCELL_ROW_19_323 VGND VPWR sky130_fd_sc_hd__tapvpwrvgnd_1
X_3901_ clknet_leaf_16_clk _0024_ VGND VGND VPWR VPWR net79 sky130_fd_sc_hd__dfxtp_1
X_3832_ net252 _1556_ _1616_ net191 VGND VGND VPWR VPWR _1617_ sky130_fd_sc_hd__a211o_1
XTAP_TAPCELL_ROW_62_668 VGND VPWR sky130_fd_sc_hd__tapvpwrvgnd_1
X_3763_ _1522_ _1529_ net264 VGND VGND VPWR VPWR _1581_ sky130_fd_sc_hd__mux2_1
X_2714_ mantisaresult\[37\] net156 VGND VGND VPWR VPWR _0657_ sky130_fd_sc_hd__nand2_1
X_3694_ _1483_ _1487_ net271 VGND VGND VPWR VPWR _1520_ sky130_fd_sc_hd__mux2_1
X_2645_ _0587_ VGND VGND VPWR VPWR _0588_ sky130_fd_sc_hd__inv_2
X_2576_ _1643_ _0517_ _0310_ _0309_ VGND VGND VPWR VPWR _0519_ sky130_fd_sc_hd__a211o_1
XFILLER_27_125 VGND VGND VPWR VPWR sky130_fd_sc_hd__fill_1
X_3128_ net229 _1025_ net202 VGND VGND VPWR VPWR _0143_ sky130_fd_sc_hd__mux2_1
XFILLER_27_169 VGND VGND VPWR VPWR sky130_fd_sc_hd__decap_4
X_3059_ net241 _0969_ mantisaBshift\[23\] VGND VGND VPWR VPWR _0970_ sky130_fd_sc_hd__a21oi_1
XFILLER_50_183 VPWR VGND VPWR VGND sky130_ef_sc_hd__decap_12
XFILLER_46_401 VGND VGND VPWR VPWR sky130_fd_sc_hd__decap_3
XFILLER_58_294 VGND VGND VPWR VPWR sky130_fd_sc_hd__fill_2
XFILLER_14_320 VGND VGND VPWR VPWR sky130_fd_sc_hd__decap_4
XFILLER_73_297 VPWR VGND VPWR VGND sky130_ef_sc_hd__decap_12
XFILLER_14_386 VPWR VGND VPWR VGND sky130_ef_sc_hd__decap_12
X_2430_ _0371_ _0372_ VGND VGND VPWR VPWR _0373_ sky130_fd_sc_hd__or2_2
X_2361_ mantisaresult\[57\] mantisaresult\[56\] mantisaresult\[55\] mantisaresult\[54\]
+ VGND VGND VPWR VPWR _0304_ sky130_fd_sc_hd__or4_1
X_2292_ _1916_ net309 net171 VGND VGND VPWR VPWR _0070_ sky130_fd_sc_hd__mux2_1
X_4100_ clknet_leaf_15_clk _0207_ VGND VGND VPWR VPWR four_man\[59\] sky130_fd_sc_hd__dfxtp_1
XFILLER_2_41 VPWR VGND VPWR VGND sky130_ef_sc_hd__decap_12
X_4031_ clknet_leaf_17_clk _0142_ VGND VGND VPWR VPWR four_man\[48\] sky130_fd_sc_hd__dfxtp_1
XTAP_TAPCELL_ROW_67_705 VGND VPWR sky130_fd_sc_hd__tapvpwrvgnd_1
XFILLER_2_85 VPWR VGND VPWR VGND sky130_ef_sc_hd__decap_12
XFILLER_49_272 VGND VGND VPWR VPWR sky130_fd_sc_hd__decap_8
XTAP_TAPCELL_ROW_75_771 VGND VPWR sky130_fd_sc_hd__tapvpwrvgnd_1
XFILLER_24_139 VGND VGND VPWR VPWR sky130_fd_sc_hd__fill_1
XFILLER_20_323 VGND VGND VPWR VPWR sky130_fd_sc_hd__decap_8
XFILLER_32_172 VPWR VGND VPWR VGND sky130_ef_sc_hd__decap_12
XFILLER_32_194 VGND VGND VPWR VPWR sky130_fd_sc_hd__fill_2
X_3815_ net191 _1595_ VGND VGND VPWR VPWR _0249_ sky130_fd_sc_hd__nor2_1
X_3746_ net267 _1533_ VGND VGND VPWR VPWR _1568_ sky130_fd_sc_hd__nand2_1
X_3677_ _1475_ net184 _1504_ _1418_ VGND VGND VPWR VPWR _0213_ sky130_fd_sc_hd__a22o_1
X_2628_ _0492_ _0502_ _0570_ VGND VGND VPWR VPWR _0571_ sky130_fd_sc_hd__nor3_1
X_2559_ _0441_ _0496_ _0501_ VGND VGND VPWR VPWR _0502_ sky130_fd_sc_hd__nand3_1
XFILLER_47_209 VGND VGND VPWR VPWR sky130_fd_sc_hd__decap_6
XTAP_TAPCELL_ROW_38_473 VGND VPWR sky130_fd_sc_hd__tapvpwrvgnd_1
XFILLER_62_46 VGND VGND VPWR VPWR sky130_fd_sc_hd__fill_1
XFILLER_7_316 VGND VGND VPWR VPWR sky130_fd_sc_hd__fill_1
XTAP_TAPCELL_ROW_21_340 VGND VPWR sky130_fd_sc_hd__tapvpwrvgnd_1
XFILLER_7_349 VGND VGND VPWR VPWR sky130_fd_sc_hd__decap_6
XFILLER_78_301 VGND VGND VPWR VPWR sky130_fd_sc_hd__decap_6
XFILLER_78_345 VPWR VGND VPWR VGND sky130_ef_sc_hd__decap_12
XFILLER_78_389 VPWR VGND VPWR VGND sky130_ef_sc_hd__decap_12
XFILLER_16_9 VGND VGND VPWR VPWR sky130_fd_sc_hd__fill_1
XFILLER_46_253 VPWR VGND VPWR VGND sky130_ef_sc_hd__decap_12
XFILLER_34_459 VPWR VGND VPWR VGND sky130_ef_sc_hd__decap_12
XFILLER_36_80 VGND VGND VPWR VPWR sky130_fd_sc_hd__decap_4
X_1930_ expmiddlec\[4\] VGND VGND VPWR VPWR _1625_ sky130_fd_sc_hd__inv_2
XFILLER_14_161 VPWR VGND VPWR VGND sky130_ef_sc_hd__decap_12
Xinput22 mantisaA[14] VGND VGND VPWR VPWR net22 sky130_fd_sc_hd__buf_1
Xinput11 expb[2] VGND VGND VPWR VPWR net11 sky130_fd_sc_hd__buf_1
X_3600_ mantisaB0\[6\] net193 _1430_ net273 VGND VGND VPWR VPWR _1431_ sky130_fd_sc_hd__a22o_1
Xinput55 mantisaB[2] VGND VGND VPWR VPWR net55 sky130_fd_sc_hd__buf_1
Xinput33 mantisaA[3] VGND VGND VPWR VPWR net33 sky130_fd_sc_hd__buf_1
X_3531_ net133 _1366_ net113 mantisaresult\[56\] VGND VGND VPWR VPWR _1367_ sky130_fd_sc_hd__a2bb2o_1
Xinput44 mantisaB[13] VGND VGND VPWR VPWR net44 sky130_fd_sc_hd__buf_1
X_3462_ net353 _0762_ net208 VGND VGND VPWR VPWR _0187_ sky130_fd_sc_hd__mux2_1
X_2413_ _0355_ VGND VGND VPWR VPWR _0356_ sky130_fd_sc_hd__inv_2
X_3393_ _1239_ _1242_ _1250_ VGND VGND VPWR VPWR _1263_ sky130_fd_sc_hd__a21o_1
X_2344_ net65 _1836_ _0288_ net177 VGND VGND VPWR VPWR _0289_ sky130_fd_sc_hd__o211a_1
X_2275_ net47 net168 VGND VGND VPWR VPWR _1905_ sky130_fd_sc_hd__and2_1
XFILLER_69_389 VGND VGND VPWR VPWR sky130_fd_sc_hd__decap_3
X_4014_ clknet_leaf_24_clk _0125_ VGND VGND VPWR VPWR mantisaresult\[18\] sky130_fd_sc_hd__dfxtp_2
XFILLER_25_437 VGND VGND VPWR VPWR sky130_fd_sc_hd__fill_1
XFILLER_12_109 VGND VGND VPWR VPWR sky130_fd_sc_hd__fill_2
XTAP_TAPCELL_ROW_35_454 VGND VPWR sky130_fd_sc_hd__tapvpwrvgnd_1
XFILLER_40_418 VGND VGND VPWR VPWR sky130_fd_sc_hd__fill_2
XFILLER_20_197 VGND VGND VPWR VPWR sky130_fd_sc_hd__decap_8
X_3729_ net268 _1515_ VGND VGND VPWR VPWR _1552_ sky130_fd_sc_hd__nor2_1
XFILLER_79_109 VGND VGND VPWR VPWR sky130_fd_sc_hd__decap_3
XFILLER_75_337 VPWR VGND VPWR VGND sky130_ef_sc_hd__decap_12
XFILLER_57_79 VGND VGND VPWR VPWR sky130_fd_sc_hd__fill_1
XFILLER_28_253 VGND VGND VPWR VPWR sky130_fd_sc_hd__decap_6
XFILLER_73_23 VGND VGND VPWR VPWR sky130_fd_sc_hd__fill_2
XFILLER_73_34 VGND VGND VPWR VPWR sky130_fd_sc_hd__fill_2
XFILLER_73_45 VGND VGND VPWR VPWR sky130_fd_sc_hd__decap_3
XFILLER_43_278 VGND VGND VPWR VPWR sky130_fd_sc_hd__fill_2
XFILLER_7_113 VGND VGND VPWR VPWR sky130_fd_sc_hd__decap_6
XFILLER_7_135 VGND VGND VPWR VPWR sky130_fd_sc_hd__fill_2
XFILLER_78_153 VPWR VGND VPWR VGND sky130_ef_sc_hd__decap_12
XFILLER_78_197 VGND VGND VPWR VPWR sky130_fd_sc_hd__decap_8
X_2060_ expmiddled\[6\] expadd\[6\] VGND VGND VPWR VPWR _1747_ sky130_fd_sc_hd__nand2_1
X_2962_ mantisaBshift\[0\] mantisaBshift\[1\] mantisaBshift\[2\] mantisaBshift\[3\]
+ VGND VGND VPWR VPWR _0893_ sky130_fd_sc_hd__or4_2
XTAP_TAPCELL_ROW_32_424 VGND VPWR sky130_fd_sc_hd__tapvpwrvgnd_1
X_2893_ net125 _0831_ net151 VGND VGND VPWR VPWR _0832_ sky130_fd_sc_hd__a21o_1
XTAP_TAPCELL_ROW_40_490 VGND VPWR sky130_fd_sc_hd__tapvpwrvgnd_1
X_3514_ _0977_ _1351_ net123 VGND VGND VPWR VPWR _1352_ sky130_fd_sc_hd__mux2_1
X_3445_ net356 net213 _1304_ expmiddlec\[5\] VGND VGND VPWR VPWR _0181_ sky130_fd_sc_hd__a22o_1
X_3376_ mantisaresult\[58\] _1247_ net203 VGND VGND VPWR VPWR _0169_ sky130_fd_sc_hd__mux2_1
X_2327_ _0280_ net378 net174 VGND VGND VPWR VPWR _0087_ sky130_fd_sc_hd__mux2_1
XFILLER_57_337 VPWR VGND VPWR VGND sky130_ef_sc_hd__decap_12
X_2258_ net18 _1893_ net103 VGND VGND VPWR VPWR _1894_ sky130_fd_sc_hd__mux2_1
X_2189_ net265 _1847_ net178 VGND VGND VPWR VPWR _0036_ sky130_fd_sc_hd__mux2_1
XFILLER_25_201 VGND VGND VPWR VPWR sky130_fd_sc_hd__decap_4
XFILLER_25_234 VGND VGND VPWR VPWR sky130_fd_sc_hd__decap_6
XFILLER_25_256 VPWR VGND VPWR VGND sky130_ef_sc_hd__decap_12
XFILLER_13_429 VPWR VGND VPWR VGND sky130_ef_sc_hd__decap_12
XFILLER_0_377 VGND VGND VPWR VPWR sky130_fd_sc_hd__decap_4
XFILLER_68_89 VGND VGND VPWR VPWR sky130_fd_sc_hd__fill_1
XTAP_TAPCELL_ROW_3_193 VGND VPWR sky130_fd_sc_hd__tapvpwrvgnd_1
XTAP_TAPCELL_ROW_46_538 VGND VPWR sky130_fd_sc_hd__tapvpwrvgnd_1
XFILLER_16_289 VGND VGND VPWR VPWR sky130_fd_sc_hd__fill_1
XFILLER_31_237 VGND VGND VPWR VPWR sky130_fd_sc_hd__fill_2
XFILLER_8_433 VPWR VGND VPWR VGND sky130_ef_sc_hd__decap_12
XFILLER_3_193 VPWR VGND VPWR VGND sky130_ef_sc_hd__decap_12
X_3230_ mantisaAshift\[47\] mantisaBshift\[47\] VGND VGND VPWR VPWR _1114_ sky130_fd_sc_hd__nor2_1
X_3161_ mantisaBshift\[40\] mantisaAshift\[40\] VGND VGND VPWR VPWR _1052_ sky130_fd_sc_hd__nand2b_1
X_2112_ net5 net13 VGND VGND VPWR VPWR _1773_ sky130_fd_sc_hd__and2b_1
X_3092_ _0995_ _0996_ mantisaresult\[28\] net234 VGND VGND VPWR VPWR _0136_ sky130_fd_sc_hd__a2bb2o_1
X_2043_ expmiddled\[3\] expadd\[3\] VGND VGND VPWR VPWR _1733_ sky130_fd_sc_hd__or2_1
XFILLER_54_329 VGND VGND VPWR VPWR sky130_fd_sc_hd__decap_3
XFILLER_62_384 VGND VGND VPWR VPWR sky130_fd_sc_hd__fill_2
X_3994_ clknet_leaf_25_clk _0105_ VGND VGND VPWR VPWR mantisaresult\[0\] sky130_fd_sc_hd__dfxtp_1
X_2945_ net144 _0777_ VGND VGND VPWR VPWR _0877_ sky130_fd_sc_hd__nand2_1
X_2876_ net136 _0707_ _0815_ VGND VGND VPWR VPWR _0816_ sky130_fd_sc_hd__o21a_1
X_3428_ _1293_ VGND VGND VPWR VPWR _1294_ sky130_fd_sc_hd__inv_2
XFILLER_38_15 VGND VGND VPWR VPWR sky130_fd_sc_hd__fill_2
XFILLER_38_26 VGND VGND VPWR VPWR sky130_fd_sc_hd__fill_2
X_3359_ _1230_ _1231_ VGND VGND VPWR VPWR _1232_ sky130_fd_sc_hd__nand2b_1
XFILLER_45_329 VGND VGND VPWR VPWR sky130_fd_sc_hd__fill_1
XFILLER_72_137 VGND VGND VPWR VPWR sky130_fd_sc_hd__decap_3
XTAP_TAPCELL_ROW_0_163 VGND VPWR sky130_fd_sc_hd__tapvpwrvgnd_1
XTAP_TAPCELL_ROW_0_174 VGND VPWR sky130_fd_sc_hd__tapvpwrvgnd_1
XTAP_TAPCELL_ROW_43_519 VGND VPWR sky130_fd_sc_hd__tapvpwrvgnd_1
XFILLER_13_237 VPWR VGND VPWR VGND sky130_ef_sc_hd__decap_12
XFILLER_5_425 VPWR VGND VPWR VGND sky130_ef_sc_hd__decap_12
XFILLER_0_141 VPWR VGND VPWR VGND sky130_ef_sc_hd__decap_12
XFILLER_76_421 VPWR VGND VPWR VGND sky130_ef_sc_hd__decap_12
XFILLER_36_307 VGND VGND VPWR VPWR sky130_fd_sc_hd__fill_1
XFILLER_36_318 VGND VGND VPWR VPWR sky130_fd_sc_hd__fill_1
XTAP_TAPCELL_ROW_59_641 VGND VPWR sky130_fd_sc_hd__tapvpwrvgnd_1
XTAP_TAPCELL_ROW_14_287 VGND VPWR sky130_fd_sc_hd__tapvpwrvgnd_1
X_2730_ mantisaresult\[12\] net153 VGND VGND VPWR VPWR _0673_ sky130_fd_sc_hd__nand2_1
X_2661_ expmiddlec\[3\] _0585_ _0601_ VGND VGND VPWR VPWR _0604_ sky130_fd_sc_hd__mux2_2
XFILLER_5_30 VPWR VGND VPWR VGND sky130_ef_sc_hd__decap_12
X_2592_ net227 _0311_ _0326_ _0343_ net221 VGND VGND VPWR VPWR _0535_ sky130_fd_sc_hd__a32o_1
Xfanout209 net211 VGND VGND VPWR VPWR net209 sky130_fd_sc_hd__clkbuf_2
X_3213_ mantisaAshift\[44\] mantisaBshift\[44\] _1090_ VGND VGND VPWR VPWR _1099_
+ sky130_fd_sc_hd__a21o_1
XFILLER_79_281 VPWR VGND VPWR VGND sky130_ef_sc_hd__decap_12
XFILLER_39_156 VGND VGND VPWR VPWR sky130_fd_sc_hd__fill_1
X_3144_ mantisaAshift\[39\] mantisaBshift\[39\] VGND VGND VPWR VPWR _1037_ sky130_fd_sc_hd__xnor2_1
X_3075_ mantisaBshift\[23\] _0969_ net241 VGND VGND VPWR VPWR _0984_ sky130_fd_sc_hd__o21ai_1
X_2026_ signA0 op0 VGND VGND VPWR VPWR _1720_ sky130_fd_sc_hd__xnor2_1
XTAP_TAPCELL_ROW_65_688 VGND VPWR sky130_fd_sc_hd__tapvpwrvgnd_1
XFILLER_35_384 VGND VGND VPWR VPWR sky130_fd_sc_hd__decap_8
X_3977_ clknet_leaf_19_clk _0099_ VGND VGND VPWR VPWR four_man\[40\] sky130_fd_sc_hd__dfxtp_1
X_2928_ net222 net200 net166 _0865_ VGND VGND VPWR VPWR _0866_ sky130_fd_sc_hd__a31o_1
X_2859_ net142 _0798_ VGND VGND VPWR VPWR _0799_ sky130_fd_sc_hd__and2b_1
XTAP_TAPCELL_ROW_5_211 VGND VPWR sky130_fd_sc_hd__tapvpwrvgnd_1
XFILLER_58_443 VGND VGND VPWR VPWR sky130_fd_sc_hd__fill_1
XTAP_TAPCELL_ROW_56_622 VGND VPWR sky130_fd_sc_hd__tapvpwrvgnd_1
XFILLER_45_137 VPWR VGND VPWR VGND sky130_ef_sc_hd__decap_12
XFILLER_65_79 VGND VGND VPWR VPWR sky130_fd_sc_hd__fill_1
XFILLER_41_343 VPWR VGND VPWR VGND sky130_ef_sc_hd__decap_12
XFILLER_14_72 VPWR VGND VPWR VGND sky130_ef_sc_hd__decap_12
XFILLER_14_94 VGND VGND VPWR VPWR sky130_fd_sc_hd__fill_1
XTAP_TAPCELL_ROW_11_257 VGND VPWR sky130_fd_sc_hd__tapvpwrvgnd_1
XFILLER_1_461 VPWR VGND VPWR VGND sky130_ef_sc_hd__decap_12
XFILLER_49_443 VGND VGND VPWR VPWR sky130_fd_sc_hd__decap_4
Xinput9 expb[0] VGND VGND VPWR VPWR net9 sky130_fd_sc_hd__buf_1
XTAP_TAPCELL_ROW_19_324 VGND VPWR sky130_fd_sc_hd__tapvpwrvgnd_1
XFILLER_64_457 VGND VGND VPWR VPWR sky130_fd_sc_hd__decap_8
XFILLER_44_181 VPWR VGND VPWR VGND sky130_ef_sc_hd__decap_12
X_3900_ clknet_leaf_16_clk _0023_ VGND VGND VPWR VPWR net78 sky130_fd_sc_hd__dfxtp_1
XTAP_TAPCELL_ROW_27_390 VGND VPWR sky130_fd_sc_hd__tapvpwrvgnd_1
X_3831_ net252 _1561_ VGND VGND VPWR VPWR _1616_ sky130_fd_sc_hd__nor2_1
XTAP_TAPCELL_ROW_62_669 VGND VPWR sky130_fd_sc_hd__tapvpwrvgnd_1
X_3762_ net186 _1580_ VGND VGND VPWR VPWR _0222_ sky130_fd_sc_hd__nor2_1
X_3693_ expmiddle\[5\] net254 _1519_ _1673_ VGND VGND VPWR VPWR _0214_ sky130_fd_sc_hd__o211a_1
X_2713_ _0652_ _0655_ net120 VGND VGND VPWR VPWR _0656_ sky130_fd_sc_hd__mux2_1
X_2644_ _0570_ _0574_ VGND VGND VPWR VPWR _0587_ sky130_fd_sc_hd__xor2_1
X_2575_ net188 _0310_ _0517_ VGND VGND VPWR VPWR _0518_ sky130_fd_sc_hd__nor3_1
XFILLER_59_229 VPWR VGND VPWR VGND sky130_ef_sc_hd__decap_12
X_3127_ mantisaBshift\[34\] _1024_ VGND VGND VPWR VPWR _1025_ sky130_fd_sc_hd__xor2_1
XFILLER_55_413 VGND VGND VPWR VPWR sky130_fd_sc_hd__decap_4
X_3058_ mantisaBshift\[20\] mantisaBshift\[21\] mantisaBshift\[22\] _0961_ VGND VGND
+ VPWR VPWR _0969_ sky130_fd_sc_hd__or4_2
XFILLER_23_310 VPWR VGND VPWR VGND sky130_ef_sc_hd__decap_12
X_2009_ _1702_ _1703_ VGND VGND VPWR VPWR _1704_ sky130_fd_sc_hd__nor2_1
XFILLER_35_181 VPWR VGND VPWR VGND sky130_ef_sc_hd__decap_12
XFILLER_50_195 VGND VGND VPWR VPWR sky130_fd_sc_hd__fill_1
XFILLER_46_457 VPWR VGND VPWR VGND sky130_ef_sc_hd__decap_12
XFILLER_14_398 VPWR VGND VPWR VGND sky130_ef_sc_hd__decap_12
XTAP_TAPCELL_ROW_24_360 VGND VPWR sky130_fd_sc_hd__tapvpwrvgnd_1
X_2360_ mantisaresult\[55\] _0302_ VGND VGND VPWR VPWR _0303_ sky130_fd_sc_hd__or2_1
X_2291_ net30 _1915_ net100 VGND VGND VPWR VPWR _1916_ sky130_fd_sc_hd__mux2_1
XPHY_EDGE_ROW_10_Right_10 VGND VGND VPWR VPWR sky130_fd_sc_hd__decap_3
XFILLER_2_53 VPWR VGND VPWR VGND sky130_ef_sc_hd__decap_12
X_4030_ clknet_leaf_13_clk _0141_ VGND VGND VPWR VPWR mantisaresult\[33\] sky130_fd_sc_hd__dfxtp_1
XTAP_TAPCELL_ROW_67_706 VGND VPWR sky130_fd_sc_hd__tapvpwrvgnd_1
XFILLER_37_402 VGND VGND VPWR VPWR sky130_fd_sc_hd__decap_6
XFILLER_2_97 VPWR VGND VPWR VGND sky130_ef_sc_hd__decap_12
XTAP_TAPCELL_ROW_75_772 VGND VPWR sky130_fd_sc_hd__tapvpwrvgnd_1
XFILLER_32_151 VGND VGND VPWR VPWR sky130_fd_sc_hd__fill_2
XFILLER_32_184 VGND VGND VPWR VPWR sky130_fd_sc_hd__decap_6
X_3814_ net192 _1592_ VGND VGND VPWR VPWR _0248_ sky130_fd_sc_hd__and2_1
X_3745_ _1564_ _1566_ net259 VGND VGND VPWR VPWR _1567_ sky130_fd_sc_hd__mux2_1
X_3676_ net255 _1496_ VGND VGND VPWR VPWR _1504_ sky130_fd_sc_hd__nor2_1
X_2627_ _0466_ _0528_ _0529_ VGND VGND VPWR VPWR _0570_ sky130_fd_sc_hd__or3_1
X_2558_ _0361_ _0500_ _0498_ VGND VGND VPWR VPWR _0501_ sky130_fd_sc_hd__o21a_1
X_2489_ mantisaresult\[13\] mantisaresult\[12\] mantisaresult\[11\] VGND VGND VPWR
+ VPWR _0432_ sky130_fd_sc_hd__or3_1
X_4159_ clknet_leaf_10_clk _0266_ VGND VGND VPWR VPWR mantisaBshift\[54\] sky130_fd_sc_hd__dfxtp_1
XTAP_TAPCELL_ROW_38_474 VGND VPWR sky130_fd_sc_hd__tapvpwrvgnd_1
XFILLER_55_287 VPWR VGND VPWR VGND sky130_ef_sc_hd__decap_12
XFILLER_70_235 VGND VGND VPWR VPWR sky130_fd_sc_hd__decap_8
XFILLER_62_14 VGND VGND VPWR VPWR sky130_fd_sc_hd__decap_3
XFILLER_11_335 VGND VGND VPWR VPWR sky130_fd_sc_hd__fill_1
XFILLER_23_195 VPWR VGND VPWR VGND sky130_ef_sc_hd__decap_12
XTAP_TAPCELL_ROW_21_341 VGND VPWR sky130_fd_sc_hd__tapvpwrvgnd_1
XFILLER_78_357 VGND VGND VPWR VPWR sky130_fd_sc_hd__decap_6
XFILLER_19_402 VGND VGND VPWR VPWR sky130_fd_sc_hd__fill_1
XFILLER_46_221 VPWR VGND VPWR VGND sky130_ef_sc_hd__decap_12
XFILLER_34_405 VGND VGND VPWR VPWR sky130_fd_sc_hd__decap_8
XFILLER_46_265 VPWR VGND VPWR VGND sky130_ef_sc_hd__decap_12
Xclkbuf_leaf_26_clk clknet_2_0__leaf_clk VGND VGND VPWR VPWR clknet_leaf_26_clk sky130_fd_sc_hd__clkbuf_8
XFILLER_14_173 VPWR VGND VPWR VGND sky130_ef_sc_hd__decap_12
XFILLER_14_195 VGND VGND VPWR VPWR sky130_fd_sc_hd__fill_1
Xinput12 expb[3] VGND VGND VPWR VPWR net12 sky130_fd_sc_hd__buf_1
Xinput45 mantisaB[14] VGND VGND VPWR VPWR net45 sky130_fd_sc_hd__buf_1
Xinput34 mantisaA[4] VGND VGND VPWR VPWR net34 sky130_fd_sc_hd__buf_1
X_3530_ mantisaresult\[57\] net155 VGND VGND VPWR VPWR _1366_ sky130_fd_sc_hd__nand2_1
Xinput23 mantisaA[15] VGND VGND VPWR VPWR net23 sky130_fd_sc_hd__buf_1
Xinput56 mantisaB[3] VGND VGND VPWR VPWR net56 sky130_fd_sc_hd__buf_1
X_3461_ net351 _0573_ net208 VGND VGND VPWR VPWR _0186_ sky130_fd_sc_hd__mux2_1
X_2412_ mantisaresult\[25\] mantisaresult\[24\] mantisaresult\[23\] mantisaresult\[22\]
+ VGND VGND VPWR VPWR _0355_ sky130_fd_sc_hd__or4_2
X_3392_ _1222_ _1224_ _1240_ _1260_ VGND VGND VPWR VPWR _1262_ sky130_fd_sc_hd__a211o_1
X_2343_ net64 net99 VGND VGND VPWR VPWR _0288_ sky130_fd_sc_hd__or2_1
XFILLER_69_335 VGND VGND VPWR VPWR sky130_fd_sc_hd__fill_1
X_2274_ _1904_ net292 net173 VGND VGND VPWR VPWR _0064_ sky130_fd_sc_hd__mux2_1
X_4013_ clknet_leaf_23_clk _0124_ VGND VGND VPWR VPWR mantisaresult\[17\] sky130_fd_sc_hd__dfxtp_2
XFILLER_37_287 VPWR VGND VPWR VGND sky130_ef_sc_hd__decap_12
XTAP_TAPCELL_ROW_35_455 VGND VPWR sky130_fd_sc_hd__tapvpwrvgnd_1
Xclkbuf_leaf_17_clk clknet_2_3__leaf_clk VGND VGND VPWR VPWR clknet_leaf_17_clk sky130_fd_sc_hd__clkbuf_8
XFILLER_33_471 VGND VGND VPWR VPWR sky130_fd_sc_hd__fill_2
XFILLER_32_17 VGND VGND VPWR VPWR sky130_fd_sc_hd__fill_1
X_1989_ mantisaAshift\[62\] VGND VGND VPWR VPWR _1684_ sky130_fd_sc_hd__inv_2
X_3728_ net187 _1549_ _1551_ _1501_ VGND VGND VPWR VPWR _0217_ sky130_fd_sc_hd__a2bb2o_1
X_3659_ mantisaB0\[20\] net185 _1488_ VGND VGND VPWR VPWR _1489_ sky130_fd_sc_hd__a21boi_1
XFILLER_75_349 VPWR VGND VPWR VGND sky130_ef_sc_hd__decap_12
XFILLER_16_405 VPWR VGND VPWR VGND sky130_ef_sc_hd__decap_12
XFILLER_28_265 VPWR VGND VPWR VGND sky130_ef_sc_hd__decap_12
XFILLER_73_79 VGND VGND VPWR VPWR sky130_fd_sc_hd__fill_1
XFILLER_7_169 VPWR VGND VPWR VGND sky130_ef_sc_hd__decap_12
XFILLER_78_165 VGND VGND VPWR VPWR sky130_fd_sc_hd__decap_4
XFILLER_59_390 VGND VGND VPWR VPWR sky130_fd_sc_hd__fill_2
X_2961_ net339 net206 _0890_ _0892_ VGND VGND VPWR VPWR _0109_ sky130_fd_sc_hd__o22a_1
XTAP_TAPCELL_ROW_32_425 VGND VPWR sky130_fd_sc_hd__tapvpwrvgnd_1
X_2892_ _0829_ _0830_ net122 VGND VGND VPWR VPWR _0831_ sky130_fd_sc_hd__mux2_1
XFILLER_8_52 VGND VGND VPWR VPWR sky130_fd_sc_hd__fill_1
XTAP_TAPCELL_ROW_40_491 VGND VPWR sky130_fd_sc_hd__tapvpwrvgnd_1
X_3513_ _1350_ _1294_ net145 VGND VGND VPWR VPWR _1351_ sky130_fd_sc_hd__mux2_1
X_3444_ net362 net213 _1304_ expmiddlec\[4\] VGND VGND VPWR VPWR _0180_ sky130_fd_sc_hd__a22o_1
Xclkbuf_leaf_6_clk clknet_2_1__leaf_clk VGND VGND VPWR VPWR clknet_leaf_6_clk sky130_fd_sc_hd__clkbuf_8
X_3375_ _1239_ _1246_ VGND VGND VPWR VPWR _1247_ sky130_fd_sc_hd__xnor2_1
XFILLER_69_132 VGND VGND VPWR VPWR sky130_fd_sc_hd__fill_1
X_2326_ _1903_ net23 net103 VGND VGND VPWR VPWR _0280_ sky130_fd_sc_hd__mux2_1
XFILLER_57_349 VGND VGND VPWR VPWR sky130_fd_sc_hd__fill_2
XFILLER_69_198 VGND VGND VPWR VPWR sky130_fd_sc_hd__decap_3
X_2257_ net41 net169 VGND VGND VPWR VPWR _1893_ sky130_fd_sc_hd__and2_1
X_2188_ _1784_ _1846_ VGND VGND VPWR VPWR _1847_ sky130_fd_sc_hd__xnor2_1
XFILLER_65_360 VPWR VGND VPWR VGND sky130_ef_sc_hd__decap_12
XFILLER_65_393 VGND VGND VPWR VPWR sky130_fd_sc_hd__decap_4
XFILLER_25_268 VGND VGND VPWR VPWR sky130_fd_sc_hd__decap_6
XFILLER_40_205 VGND VGND VPWR VPWR sky130_fd_sc_hd__fill_1
XFILLER_4_139 VGND VGND VPWR VPWR sky130_fd_sc_hd__fill_1
XFILLER_48_305 VGND VGND VPWR VPWR sky130_fd_sc_hd__decap_3
XFILLER_48_349 VGND VGND VPWR VPWR sky130_fd_sc_hd__fill_1
XTAP_TAPCELL_ROW_3_194 VGND VPWR sky130_fd_sc_hd__tapvpwrvgnd_1
XTAP_TAPCELL_ROW_46_539 VGND VPWR sky130_fd_sc_hd__tapvpwrvgnd_1
XFILLER_17_83 VPWR VGND VPWR VGND sky130_ef_sc_hd__decap_12
XFILLER_8_445 VPWR VGND VPWR VGND sky130_ef_sc_hd__decap_12
XFILLER_3_161 VGND VGND VPWR VPWR sky130_fd_sc_hd__decap_6
XFILLER_39_305 VGND VGND VPWR VPWR sky130_fd_sc_hd__fill_2
X_3160_ _1678_ _1679_ _1040_ _1041_ VGND VGND VPWR VPWR _1051_ sky130_fd_sc_hd__o31a_1
X_2111_ net14 net6 VGND VGND VPWR VPWR _1772_ sky130_fd_sc_hd__nand2b_1
X_3091_ net241 mantisaBshift\[28\] _0994_ net234 VGND VGND VPWR VPWR _0996_ sky130_fd_sc_hd__a31o_1
Xhold1 four_man\[41\] VGND VGND VPWR VPWR net275 sky130_fd_sc_hd__dlygate4sd3_1
X_2042_ expmiddled\[3\] expadd\[3\] VGND VGND VPWR VPWR _1732_ sky130_fd_sc_hd__nand2_1
XFILLER_66_157 VGND VGND VPWR VPWR sky130_fd_sc_hd__decap_3
XPHY_EDGE_ROW_8_Right_8 VGND VGND VPWR VPWR sky130_fd_sc_hd__decap_3
XFILLER_22_216 VGND VGND VPWR VPWR sky130_fd_sc_hd__decap_8
X_3993_ clknet_leaf_28_clk _0104_ VGND VGND VPWR VPWR op0 sky130_fd_sc_hd__dfxtp_1
X_2944_ net126 _0875_ _0602_ VGND VGND VPWR VPWR _0876_ sky130_fd_sc_hd__a21o_1
X_2875_ net136 _0705_ VGND VGND VPWR VPWR _0815_ sky130_fd_sc_hd__nand2_1
XPHY_EDGE_ROW_39_Right_39 VGND VGND VPWR VPWR sky130_fd_sc_hd__decap_3
X_3427_ _1076_ _1292_ net119 VGND VGND VPWR VPWR _1293_ sky130_fd_sc_hd__mux2_1
X_3358_ mantisaAshift\[57\] mantisaBshift\[57\] VGND VGND VPWR VPWR _1231_ sky130_fd_sc_hd__or2_1
XFILLER_57_113 VGND VGND VPWR VPWR sky130_fd_sc_hd__decap_4
XFILLER_57_135 VGND VGND VPWR VPWR sky130_fd_sc_hd__fill_2
X_2309_ _1925_ net377 net175 VGND VGND VPWR VPWR _0078_ sky130_fd_sc_hd__mux2_1
X_3289_ _1145_ _1156_ _1166_ VGND VGND VPWR VPWR _1168_ sky130_fd_sc_hd__o21ai_1
XFILLER_45_319 VGND VGND VPWR VPWR sky130_fd_sc_hd__fill_2
XFILLER_53_341 VGND VGND VPWR VPWR sky130_fd_sc_hd__fill_1
XTAP_TAPCELL_ROW_0_164 VGND VPWR sky130_fd_sc_hd__tapvpwrvgnd_1
XTAP_TAPCELL_ROW_0_175 VGND VPWR sky130_fd_sc_hd__tapvpwrvgnd_1
XFILLER_13_249 VPWR VGND VPWR VGND sky130_ef_sc_hd__decap_12
XPHY_EDGE_ROW_48_Right_48 VGND VGND VPWR VPWR sky130_fd_sc_hd__decap_3
XFILLER_5_437 VGND VGND VPWR VPWR sky130_fd_sc_hd__decap_8
XPHY_EDGE_ROW_57_Right_57 VGND VGND VPWR VPWR sky130_fd_sc_hd__decap_3
XFILLER_0_153 VPWR VGND VPWR VGND sky130_ef_sc_hd__decap_12
XFILLER_76_433 VPWR VGND VPWR VGND sky130_ef_sc_hd__decap_12
XFILLER_0_197 VPWR VGND VPWR VGND sky130_ef_sc_hd__decap_12
XFILLER_48_157 VGND VGND VPWR VPWR sky130_fd_sc_hd__fill_2
XTAP_TAPCELL_ROW_59_642 VGND VPWR sky130_fd_sc_hd__tapvpwrvgnd_1
XFILLER_28_93 VGND VGND VPWR VPWR sky130_fd_sc_hd__fill_2
XFILLER_29_393 VGND VGND VPWR VPWR sky130_fd_sc_hd__fill_1
XPHY_EDGE_ROW_66_Right_66 VGND VGND VPWR VPWR sky130_fd_sc_hd__decap_3
XFILLER_44_81 VGND VGND VPWR VPWR sky130_fd_sc_hd__decap_3
X_2660_ expmiddlec\[5\] _0583_ _0601_ VGND VGND VPWR VPWR _0603_ sky130_fd_sc_hd__mux2_2
XFILLER_8_253 VPWR VGND VPWR VGND sky130_ef_sc_hd__decap_12
XFILLER_74_6 VPWR VGND VPWR VGND sky130_ef_sc_hd__decap_12
XPHY_EDGE_ROW_75_Right_75 VGND VGND VPWR VPWR sky130_fd_sc_hd__decap_3
X_2591_ _0460_ _0533_ VGND VGND VPWR VPWR _0534_ sky130_fd_sc_hd__nand2_1
XFILLER_5_42 VPWR VGND VPWR VGND sky130_ef_sc_hd__decap_12
X_3212_ _1096_ _1097_ VGND VGND VPWR VPWR _1098_ sky130_fd_sc_hd__nand2b_1
XFILLER_67_400 VGND VGND VPWR VPWR sky130_fd_sc_hd__fill_2
XFILLER_79_293 VPWR VGND VPWR VGND sky130_ef_sc_hd__decap_12
X_3143_ mantisaresult\[38\] _1036_ net205 VGND VGND VPWR VPWR _0147_ sky130_fd_sc_hd__mux2_1
XFILLER_67_455 VGND VGND VPWR VPWR sky130_fd_sc_hd__fill_1
X_3074_ net334 net206 _0981_ _0983_ VGND VGND VPWR VPWR _0131_ sky130_fd_sc_hd__o22a_1
X_2025_ _1701_ _1715_ _1719_ VGND VGND VPWR VPWR _0000_ sky130_fd_sc_hd__a21oi_1
XTAP_TAPCELL_ROW_65_689 VGND VPWR sky130_fd_sc_hd__tapvpwrvgnd_1
X_3976_ clknet_leaf_17_clk _0098_ VGND VGND VPWR VPWR four_man\[39\] sky130_fd_sc_hd__dfxtp_1
X_2927_ net223 net194 net163 net216 VGND VGND VPWR VPWR _0865_ sky130_fd_sc_hd__a31o_1
XPHY_EDGE_ROW_17_Left_97 VGND VGND VPWR VPWR sky130_fd_sc_hd__decap_3
X_2858_ net115 _0754_ _0797_ VGND VGND VPWR VPWR _0798_ sky130_fd_sc_hd__o21ai_1
X_2789_ net143 _0730_ VGND VGND VPWR VPWR _0731_ sky130_fd_sc_hd__and2b_1
XTAP_TAPCELL_ROW_5_212 VGND VPWR sky130_fd_sc_hd__tapvpwrvgnd_1
XFILLER_58_455 VGND VGND VPWR VPWR sky130_fd_sc_hd__fill_2
XTAP_TAPCELL_ROW_56_623 VGND VPWR sky130_fd_sc_hd__tapvpwrvgnd_1
XFILLER_45_149 VGND VGND VPWR VPWR sky130_fd_sc_hd__decap_8
XFILLER_73_447 VGND VGND VPWR VPWR sky130_fd_sc_hd__fill_1
XFILLER_41_355 VGND VGND VPWR VPWR sky130_fd_sc_hd__decap_3
XFILLER_41_377 VGND VGND VPWR VPWR sky130_fd_sc_hd__decap_8
XTAP_TAPCELL_ROW_11_258 VGND VPWR sky130_fd_sc_hd__tapvpwrvgnd_1
XFILLER_5_223 VGND VGND VPWR VPWR sky130_fd_sc_hd__fill_1
XFILLER_5_278 VGND VGND VPWR VPWR sky130_fd_sc_hd__fill_2
XFILLER_30_72 VGND VGND VPWR VPWR sky130_fd_sc_hd__fill_2
XFILLER_49_433 VGND VGND VPWR VPWR sky130_fd_sc_hd__fill_1
XFILLER_76_230 VPWR VGND VPWR VGND sky130_ef_sc_hd__decap_12
XTAP_TAPCELL_ROW_19_325 VGND VPWR sky130_fd_sc_hd__tapvpwrvgnd_1
XFILLER_32_322 VGND VGND VPWR VPWR sky130_fd_sc_hd__decap_8
XTAP_TAPCELL_ROW_27_391 VGND VPWR sky130_fd_sc_hd__tapvpwrvgnd_1
X_3830_ net256 net187 _1548_ _1615_ VGND VGND VPWR VPWR _0255_ sky130_fd_sc_hd__o31ai_1
XFILLER_44_193 VGND VGND VPWR VPWR sky130_fd_sc_hd__decap_3
X_3761_ _1579_ _1578_ net255 VGND VGND VPWR VPWR _1580_ sky130_fd_sc_hd__mux2_1
X_2712_ net135 _0653_ net114 net229 VGND VGND VPWR VPWR _0655_ sky130_fd_sc_hd__a2bb2o_1
X_3692_ expmiddle\[5\] _1518_ _1513_ VGND VGND VPWR VPWR _1519_ sky130_fd_sc_hd__o21ai_1
X_2643_ _1625_ _0580_ _0585_ _1626_ VGND VGND VPWR VPWR _0586_ sky130_fd_sc_hd__a22o_1
X_2574_ _0325_ net223 net224 VGND VGND VPWR VPWR _0517_ sky130_fd_sc_hd__or3b_1
XFILLER_59_208 VPWR VGND VPWR VGND sky130_ef_sc_hd__decap_12
XFILLER_67_230 VPWR VGND VPWR VGND sky130_ef_sc_hd__decap_12
X_3126_ mantisaBshift\[32\] mantisaBshift\[33\] _1005_ net242 VGND VGND VPWR VPWR
+ _1024_ sky130_fd_sc_hd__o31a_1
XFILLER_55_425 VPWR VGND VPWR VGND sky130_ef_sc_hd__decap_12
XFILLER_67_263 VGND VGND VPWR VPWR sky130_fd_sc_hd__fill_1
XTAP_TAPCELL_ROW_78_792 VGND VPWR sky130_fd_sc_hd__tapvpwrvgnd_1
X_3057_ net387 net233 _0967_ _0968_ VGND VGND VPWR VPWR _0129_ sky130_fd_sc_hd__a22o_1
XFILLER_23_322 VGND VGND VPWR VPWR sky130_fd_sc_hd__decap_6
X_2008_ net48 net47 net50 net49 VGND VGND VPWR VPWR _1703_ sky130_fd_sc_hd__or4_1
XFILLER_35_193 VGND VGND VPWR VPWR sky130_fd_sc_hd__decap_3
XFILLER_50_141 VGND VGND VPWR VPWR sky130_fd_sc_hd__fill_2
XFILLER_23_399 VGND VGND VPWR VPWR sky130_fd_sc_hd__decap_8
X_3959_ clknet_leaf_7_clk _0082_ VGND VGND VPWR VPWR mantisaB0\[10\] sky130_fd_sc_hd__dfxtp_1
XFILLER_46_469 VGND VGND VPWR VPWR sky130_fd_sc_hd__decap_4
XFILLER_26_171 VGND VGND VPWR VPWR sky130_fd_sc_hd__decap_8
XFILLER_25_61 VGND VGND VPWR VPWR sky130_fd_sc_hd__decap_3
XTAP_TAPCELL_ROW_24_361 VGND VPWR sky130_fd_sc_hd__tapvpwrvgnd_1
XFILLER_41_196 VGND VGND VPWR VPWR sky130_fd_sc_hd__decap_3
X_2290_ net53 net168 VGND VGND VPWR VPWR _1915_ sky130_fd_sc_hd__and2_1
XTAP_TAPCELL_ROW_67_707 VGND VPWR sky130_fd_sc_hd__tapvpwrvgnd_1
XFILLER_2_65 VPWR VGND VPWR VGND sky130_ef_sc_hd__decap_12
XFILLER_37_447 VGND VGND VPWR VPWR sky130_fd_sc_hd__fill_1
XFILLER_64_222 VPWR VGND VPWR VGND sky130_ef_sc_hd__decap_12
XTAP_TAPCELL_ROW_75_773 VGND VPWR sky130_fd_sc_hd__tapvpwrvgnd_1
XFILLER_17_160 VGND VGND VPWR VPWR sky130_fd_sc_hd__decap_4
XFILLER_64_288 VGND VGND VPWR VPWR sky130_fd_sc_hd__decap_6
XPHY_EDGE_ROW_25_Left_105 VGND VGND VPWR VPWR sky130_fd_sc_hd__decap_3
X_3813_ net191 _1588_ VGND VGND VPWR VPWR _0247_ sky130_fd_sc_hd__nor2_1
X_3744_ net263 _1565_ VGND VGND VPWR VPWR _1566_ sky130_fd_sc_hd__or2_1
X_3675_ _1438_ net184 _1503_ _1418_ VGND VGND VPWR VPWR _0212_ sky130_fd_sc_hd__a22o_1
X_2626_ _0445_ _0567_ VGND VGND VPWR VPWR _0569_ sky130_fd_sc_hd__or2_1
X_2557_ _0324_ _0329_ _0449_ _0499_ VGND VGND VPWR VPWR _0500_ sky130_fd_sc_hd__or4_1
XPHY_EDGE_ROW_34_Left_114 VGND VGND VPWR VPWR sky130_fd_sc_hd__decap_3
X_2488_ _0347_ net181 VGND VGND VPWR VPWR _0431_ sky130_fd_sc_hd__nand2_2
XFILLER_28_403 VPWR VGND VPWR VGND sky130_ef_sc_hd__decap_12
XFILLER_55_222 VGND VGND VPWR VPWR sky130_fd_sc_hd__fill_2
X_4158_ clknet_leaf_10_clk _0265_ VGND VGND VPWR VPWR mantisaBshift\[55\] sky130_fd_sc_hd__dfxtp_1
X_4089_ clknet_leaf_26_clk _0198_ VGND VGND VPWR VPWR expmiddlec\[4\] sky130_fd_sc_hd__dfxtp_1
X_3109_ mantisaBshift\[33\] _1008_ VGND VGND VPWR VPWR _1009_ sky130_fd_sc_hd__xnor2_1
XTAP_TAPCELL_ROW_38_475 VGND VPWR sky130_fd_sc_hd__tapvpwrvgnd_1
XFILLER_55_299 VGND VGND VPWR VPWR sky130_fd_sc_hd__fill_1
XPHY_EDGE_ROW_43_Left_123 VGND VGND VPWR VPWR sky130_fd_sc_hd__decap_3
XFILLER_62_26 VGND VGND VPWR VPWR sky130_fd_sc_hd__fill_2
XFILLER_11_303 VGND VGND VPWR VPWR sky130_fd_sc_hd__fill_2
XFILLER_7_307 VGND VGND VPWR VPWR sky130_fd_sc_hd__fill_2
XTAP_TAPCELL_ROW_21_342 VGND VPWR sky130_fd_sc_hd__tapvpwrvgnd_1
XFILLER_11_74 VPWR VGND VPWR VGND sky130_ef_sc_hd__decap_12
XPHY_EDGE_ROW_52_Left_132 VGND VGND VPWR VPWR sky130_fd_sc_hd__decap_3
XFILLER_2_3 VPWR VGND VPWR VGND sky130_ef_sc_hd__decap_12
XFILLER_19_447 VGND VGND VPWR VPWR sky130_fd_sc_hd__fill_1
XFILLER_46_233 VPWR VGND VPWR VGND sky130_ef_sc_hd__decap_12
XPHY_EDGE_ROW_61_Left_141 VGND VGND VPWR VPWR sky130_fd_sc_hd__decap_3
XFILLER_46_277 VPWR VGND VPWR VGND sky130_ef_sc_hd__decap_12
XFILLER_61_225 VGND VGND VPWR VPWR sky130_fd_sc_hd__decap_8
Xinput13 expb[4] VGND VGND VPWR VPWR net13 sky130_fd_sc_hd__buf_1
XFILLER_52_70 VPWR VGND VPWR VGND sky130_ef_sc_hd__decap_12
Xinput24 mantisaA[16] VGND VGND VPWR VPWR net24 sky130_fd_sc_hd__buf_1
Xinput35 mantisaA[5] VGND VGND VPWR VPWR net35 sky130_fd_sc_hd__buf_1
Xinput46 mantisaB[15] VGND VGND VPWR VPWR net46 sky130_fd_sc_hd__buf_1
XFILLER_6_362 VGND VGND VPWR VPWR sky130_fd_sc_hd__fill_2
Xinput57 mantisaB[4] VGND VGND VPWR VPWR net57 sky130_fd_sc_hd__buf_1
XPHY_EDGE_ROW_70_Left_150 VGND VGND VPWR VPWR sky130_fd_sc_hd__decap_3
X_3460_ net375 net214 net166 _1304_ VGND VGND VPWR VPWR _0185_ sky130_fd_sc_hd__a22o_1
XFILLER_6_373 VGND VGND VPWR VPWR sky130_fd_sc_hd__fill_1
X_2411_ mantisaresult\[25\] mantisaresult\[24\] VGND VGND VPWR VPWR _0354_ sky130_fd_sc_hd__or2_1
X_3391_ mantisaBshift\[59\] mantisaAshift\[59\] VGND VGND VPWR VPWR _1261_ sky130_fd_sc_hd__and2b_1
X_2342_ net390 net168 _1758_ VGND VGND VPWR VPWR _0095_ sky130_fd_sc_hd__mux2_1
XFILLER_35_3 VGND VGND VPWR VPWR sky130_fd_sc_hd__fill_2
XFILLER_69_347 VGND VGND VPWR VPWR sky130_fd_sc_hd__fill_1
X_4012_ clknet_leaf_24_clk _0123_ VGND VGND VPWR VPWR mantisaresult\[16\] sky130_fd_sc_hd__dfxtp_2
X_2273_ net23 _1903_ net103 VGND VGND VPWR VPWR _1904_ sky130_fd_sc_hd__mux2_1
XFILLER_77_391 VGND VGND VPWR VPWR sky130_fd_sc_hd__fill_1
XFILLER_37_233 VPWR VGND VPWR VGND sky130_ef_sc_hd__decap_12
XFILLER_37_277 VGND VGND VPWR VPWR sky130_fd_sc_hd__decap_3
XFILLER_37_299 VGND VGND VPWR VPWR sky130_fd_sc_hd__decap_4
XFILLER_52_247 VGND VGND VPWR VPWR sky130_fd_sc_hd__decap_4
XFILLER_32_29 VGND VGND VPWR VPWR sky130_fd_sc_hd__decap_4
X_3727_ net262 _1550_ VGND VGND VPWR VPWR _1551_ sky130_fd_sc_hd__and2_1
X_1988_ mantisaBshift\[56\] VGND VGND VPWR VPWR _1683_ sky130_fd_sc_hd__inv_2
X_3658_ net274 net251 mantisaB0\[19\] VGND VGND VPWR VPWR _1488_ sky130_fd_sc_hd__or3b_1
X_3589_ net274 net251 VGND VGND VPWR VPWR _1420_ sky130_fd_sc_hd__nor2_1
X_2609_ _0472_ _0515_ _0549_ _0551_ VGND VGND VPWR VPWR _0552_ sky130_fd_sc_hd__or4bb_1
Xclkbuf_2_2__f_clk clknet_0_clk VGND VGND VPWR VPWR clknet_2_2__leaf_clk sky130_fd_sc_hd__clkbuf_16
XFILLER_16_417 VGND VGND VPWR VPWR sky130_fd_sc_hd__decap_3
XFILLER_28_277 VGND VGND VPWR VPWR sky130_fd_sc_hd__decap_8
XFILLER_28_299 VGND VGND VPWR VPWR sky130_fd_sc_hd__decap_8
XFILLER_3_310 VGND VGND VPWR VPWR sky130_fd_sc_hd__fill_1
XPHY_EDGE_ROW_5_Left_85 VGND VGND VPWR VPWR sky130_fd_sc_hd__decap_3
XFILLER_66_306 VGND VGND VPWR VPWR sky130_fd_sc_hd__fill_2
Xfanout190 net191 VGND VGND VPWR VPWR net190 sky130_fd_sc_hd__buf_2
XFILLER_15_461 VPWR VGND VPWR VGND sky130_ef_sc_hd__decap_12
XFILLER_22_409 VGND VGND VPWR VPWR sky130_fd_sc_hd__fill_1
XFILLER_34_269 VGND VGND VPWR VPWR sky130_fd_sc_hd__fill_1
X_2960_ net221 net198 net165 _0891_ VGND VGND VPWR VPWR _0892_ sky130_fd_sc_hd__a31o_1
X_2891_ _0672_ _0625_ net139 VGND VGND VPWR VPWR _0830_ sky130_fd_sc_hd__mux2_1
XTAP_TAPCELL_ROW_32_426 VGND VPWR sky130_fd_sc_hd__tapvpwrvgnd_1
XTAP_TAPCELL_ROW_40_492 VGND VPWR sky130_fd_sc_hd__tapvpwrvgnd_1
XFILLER_6_170 VPWR VGND VPWR VGND sky130_ef_sc_hd__decap_12
X_3512_ _1321_ _1349_ net119 VGND VGND VPWR VPWR _1350_ sky130_fd_sc_hd__mux2_1
X_3443_ net359 net214 _1304_ expmiddlec\[3\] VGND VGND VPWR VPWR _0179_ sky130_fd_sc_hd__a22o_1
X_3374_ net247 _1243_ _1245_ VGND VGND VPWR VPWR _1246_ sky130_fd_sc_hd__a21oi_1
X_2325_ _0279_ mantisaB0\[14\] net173 VGND VGND VPWR VPWR _0086_ sky130_fd_sc_hd__mux2_1
X_2256_ _1892_ net282 net174 VGND VGND VPWR VPWR _0058_ sky130_fd_sc_hd__mux2_1
XFILLER_72_309 VPWR VGND VPWR VGND sky130_ef_sc_hd__decap_12
X_2187_ _1790_ _1845_ net98 VGND VGND VPWR VPWR _1846_ sky130_fd_sc_hd__mux2_1
XFILLER_68_14 VGND VGND VPWR VPWR sky130_fd_sc_hd__fill_1
XFILLER_0_357 VGND VGND VPWR VPWR sky130_fd_sc_hd__decap_6
XFILLER_75_169 VGND VGND VPWR VPWR sky130_fd_sc_hd__decap_4
XTAP_TAPCELL_ROW_3_195 VGND VPWR sky130_fd_sc_hd__tapvpwrvgnd_1
XFILLER_16_225 VPWR VGND VPWR VGND sky130_ef_sc_hd__decap_12
XFILLER_17_95 VGND VGND VPWR VPWR sky130_fd_sc_hd__fill_1
XFILLER_16_269 VGND VGND VPWR VPWR sky130_fd_sc_hd__decap_6
XFILLER_8_457 VPWR VGND VPWR VGND sky130_ef_sc_hd__decap_12
X_2110_ net6 net14 VGND VGND VPWR VPWR _1771_ sky130_fd_sc_hd__nand2b_1
Xhold2 inf0 VGND VGND VPWR VPWR net276 sky130_fd_sc_hd__dlygate4sd3_1
X_3090_ net241 _0994_ mantisaBshift\[28\] VGND VGND VPWR VPWR _0995_ sky130_fd_sc_hd__a21oi_1
X_2041_ net212 _1731_ VGND VGND VPWR VPWR _0004_ sky130_fd_sc_hd__or2_1
XFILLER_54_309 VPWR VGND VPWR VGND sky130_ef_sc_hd__decap_12
XFILLER_74_191 VGND VGND VPWR VPWR sky130_fd_sc_hd__decap_4
X_3992_ clknet_leaf_29_clk net276 VGND VGND VPWR VPWR inf1 sky130_fd_sc_hd__dfxtp_1
XFILLER_62_353 VGND VGND VPWR VPWR sky130_fd_sc_hd__fill_1
X_2943_ _0873_ _0874_ net123 VGND VGND VPWR VPWR _0875_ sky130_fd_sc_hd__mux2_1
X_2874_ _0808_ _0813_ net124 VGND VGND VPWR VPWR _0814_ sky130_fd_sc_hd__mux2_1
X_3426_ mantisaresult\[50\] net113 _1291_ net134 VGND VGND VPWR VPWR _1292_ sky130_fd_sc_hd__o2bb2a_1
X_3357_ mantisaAshift\[57\] mantisaBshift\[57\] VGND VGND VPWR VPWR _1230_ sky130_fd_sc_hd__and2_1
X_2308_ _1885_ net36 net104 VGND VGND VPWR VPWR _1925_ sky130_fd_sc_hd__mux2_1
XFILLER_57_169 VPWR VGND VPWR VGND sky130_ef_sc_hd__decap_12
X_3288_ _1166_ VGND VGND VPWR VPWR _1167_ sky130_fd_sc_hd__inv_2
X_2239_ net57 net169 VGND VGND VPWR VPWR _1881_ sky130_fd_sc_hd__and2_1
XFILLER_54_27 VGND VGND VPWR VPWR sky130_fd_sc_hd__fill_1
XTAP_TAPCELL_ROW_0_165 VGND VPWR sky130_fd_sc_hd__tapvpwrvgnd_1
XFILLER_53_353 VGND VGND VPWR VPWR sky130_fd_sc_hd__decap_4
XFILLER_53_386 VGND VGND VPWR VPWR sky130_fd_sc_hd__fill_1
XFILLER_21_250 VPWR VGND VPWR VGND sky130_ef_sc_hd__decap_12
XTAP_TAPCELL_ROW_51_576 VGND VPWR sky130_fd_sc_hd__tapvpwrvgnd_1
XFILLER_5_449 VPWR VGND VPWR VGND sky130_ef_sc_hd__decap_12
XFILLER_79_57 VPWR VGND VPWR VGND sky130_ef_sc_hd__decap_12
XFILLER_79_46 VGND VGND VPWR VPWR sky130_fd_sc_hd__decap_8
XTAP_TAPCELL_ROW_8_232 VGND VPWR sky130_fd_sc_hd__tapvpwrvgnd_1
XFILLER_0_110 VGND VGND VPWR VPWR sky130_fd_sc_hd__fill_2
XFILLER_76_401 VPWR VGND VPWR VGND sky130_ef_sc_hd__decap_12
XFILLER_0_165 VGND VGND VPWR VPWR sky130_fd_sc_hd__decap_3
XFILLER_76_445 VPWR VGND VPWR VGND sky130_ef_sc_hd__decap_12
XFILLER_36_309 VGND VGND VPWR VPWR sky130_fd_sc_hd__fill_2
XTAP_TAPCELL_ROW_59_643 VGND VPWR sky130_fd_sc_hd__tapvpwrvgnd_1
XFILLER_63_128 VGND VGND VPWR VPWR sky130_fd_sc_hd__decap_3
XFILLER_56_191 VGND VGND VPWR VPWR sky130_fd_sc_hd__decap_4
XFILLER_63_139 VPWR VGND VPWR VGND sky130_ef_sc_hd__decap_12
XTAP_TAPCELL_ROW_42_510 VGND VPWR sky130_fd_sc_hd__tapvpwrvgnd_1
XFILLER_12_250 VGND VGND VPWR VPWR sky130_fd_sc_hd__fill_2
XFILLER_8_265 VGND VGND VPWR VPWR sky130_fd_sc_hd__decap_4
XFILLER_67_6 VGND VGND VPWR VPWR sky130_fd_sc_hd__fill_1
X_2590_ _0373_ _0532_ _0531_ _0510_ _0501_ VGND VGND VPWR VPWR _0533_ sky130_fd_sc_hd__o2111a_1
XFILLER_5_54 VGND VGND VPWR VPWR sky130_fd_sc_hd__fill_2
X_3211_ mantisaAshift\[45\] mantisaBshift\[45\] VGND VGND VPWR VPWR _1097_ sky130_fd_sc_hd__nand2_1
XFILLER_39_125 VGND VGND VPWR VPWR sky130_fd_sc_hd__fill_1
X_3142_ mantisaBshift\[38\] _1035_ VGND VGND VPWR VPWR _1036_ sky130_fd_sc_hd__xor2_1
X_3073_ net220 net195 net164 _0982_ VGND VGND VPWR VPWR _0983_ sky130_fd_sc_hd__a31o_1
X_2024_ _1701_ _1714_ _1717_ _1718_ VGND VGND VPWR VPWR _1719_ sky130_fd_sc_hd__and4b_1
X_3975_ clknet_leaf_28_clk _0097_ VGND VGND VPWR VPWR signB0 sky130_fd_sc_hd__dfxtp_1
XFILLER_10_209 VGND VGND VPWR VPWR sky130_fd_sc_hd__decap_3
X_2926_ net157 _0853_ _0863_ VGND VGND VPWR VPWR _0864_ sky130_fd_sc_hd__and3_1
X_2857_ net115 _0746_ VGND VGND VPWR VPWR _0797_ sky130_fd_sc_hd__nand2_1
XFILLER_40_29 VGND VGND VPWR VPWR sky130_fd_sc_hd__decap_3
X_2788_ _0728_ _0729_ net121 VGND VGND VPWR VPWR _0730_ sky130_fd_sc_hd__mux2_1
XFILLER_2_419 VGND VGND VPWR VPWR sky130_fd_sc_hd__fill_1
X_3409_ _1275_ _1276_ VGND VGND VPWR VPWR _1277_ sky130_fd_sc_hd__and2_1
XTAP_TAPCELL_ROW_5_213 VGND VPWR sky130_fd_sc_hd__tapvpwrvgnd_1
XFILLER_18_309 VPWR VGND VPWR VGND sky130_ef_sc_hd__decap_12
XFILLER_38_191 VGND VGND VPWR VPWR sky130_fd_sc_hd__decap_4
XFILLER_53_150 VPWR VGND VPWR VGND sky130_ef_sc_hd__decap_12
XFILLER_14_52 VPWR VGND VPWR VGND sky130_ef_sc_hd__decap_12
XFILLER_14_41 VGND VGND VPWR VPWR sky130_fd_sc_hd__decap_8
XTAP_TAPCELL_ROW_11_259 VGND VPWR sky130_fd_sc_hd__tapvpwrvgnd_1
XFILLER_1_441 VGND VGND VPWR VPWR sky130_fd_sc_hd__decap_6
XFILLER_76_242 VGND VGND VPWR VPWR sky130_fd_sc_hd__decap_8
XFILLER_39_82 VGND VGND VPWR VPWR sky130_fd_sc_hd__decap_3
XFILLER_76_253 VPWR VGND VPWR VGND sky130_ef_sc_hd__decap_12
XTAP_TAPCELL_ROW_19_326 VGND VPWR sky130_fd_sc_hd__tapvpwrvgnd_1
XFILLER_64_437 VGND VGND VPWR VPWR sky130_fd_sc_hd__decap_3
XFILLER_32_345 VPWR VGND VPWR VGND sky130_ef_sc_hd__decap_12
X_3760_ _1517_ _1508_ net261 VGND VGND VPWR VPWR _1579_ sky130_fd_sc_hd__mux2_1
X_2711_ _0653_ VGND VGND VPWR VPWR _0654_ sky130_fd_sc_hd__inv_2
X_3691_ net265 _1516_ VGND VGND VPWR VPWR _1518_ sky130_fd_sc_hd__nand2_1
X_2642_ _0470_ _0575_ VGND VGND VPWR VPWR _0585_ sky130_fd_sc_hd__xnor2_1
X_2573_ _0298_ _0299_ VGND VGND VPWR VPWR _0516_ sky130_fd_sc_hd__and2b_1
X_3125_ net335 net206 _1021_ _1023_ VGND VGND VPWR VPWR _0142_ sky130_fd_sc_hd__o22a_1
XTAP_TAPCELL_ROW_78_793 VGND VPWR sky130_fd_sc_hd__tapvpwrvgnd_1
X_3056_ mantisaBshift\[22\] _0966_ net233 VGND VGND VPWR VPWR _0968_ sky130_fd_sc_hd__a21oi_1
X_2007_ net53 net52 net54 net9 VGND VGND VPWR VPWR _1702_ sky130_fd_sc_hd__or4b_1
XFILLER_50_131 VGND VGND VPWR VPWR sky130_fd_sc_hd__decap_8
XTAP_TAPCELL_ROW_61_660 VGND VPWR sky130_fd_sc_hd__tapvpwrvgnd_1
XFILLER_50_197 VPWR VGND VPWR VGND sky130_ef_sc_hd__decap_12
X_3958_ clknet_leaf_7_clk _0081_ VGND VGND VPWR VPWR mantisaB0\[9\] sky130_fd_sc_hd__dfxtp_1
X_3889_ clknet_leaf_17_clk _0012_ VGND VGND VPWR VPWR net89 sky130_fd_sc_hd__dfxtp_1
X_2909_ net223 net198 net164 _0847_ VGND VGND VPWR VPWR _0848_ sky130_fd_sc_hd__a31o_1
XFILLER_76_25 VGND VGND VPWR VPWR sky130_fd_sc_hd__decap_3
XFILLER_18_106 VGND VGND VPWR VPWR sky130_fd_sc_hd__fill_1
XFILLER_58_253 VGND VGND VPWR VPWR sky130_fd_sc_hd__decap_8
XFILLER_58_286 VGND VGND VPWR VPWR sky130_fd_sc_hd__decap_8
XFILLER_73_223 VGND VGND VPWR VPWR sky130_fd_sc_hd__fill_1
XFILLER_33_109 VGND VGND VPWR VPWR sky130_fd_sc_hd__decap_3
XTAP_TAPCELL_ROW_24_362 VGND VPWR sky130_fd_sc_hd__tapvpwrvgnd_1
XFILLER_49_242 VPWR VGND VPWR VGND sky130_ef_sc_hd__decap_12
XFILLER_2_77 VGND VGND VPWR VPWR sky130_fd_sc_hd__decap_6
XTAP_TAPCELL_ROW_67_708 VGND VPWR sky130_fd_sc_hd__tapvpwrvgnd_1
XFILLER_64_234 VPWR VGND VPWR VGND sky130_ef_sc_hd__decap_12
XTAP_TAPCELL_ROW_75_774 VGND VPWR sky130_fd_sc_hd__tapvpwrvgnd_1
XFILLER_20_304 VGND VGND VPWR VPWR sky130_fd_sc_hd__fill_1
X_3812_ net190 _1584_ VGND VGND VPWR VPWR _0246_ sky130_fd_sc_hd__nor2_1
X_3743_ _1521_ _1528_ net267 VGND VGND VPWR VPWR _1565_ sky130_fd_sc_hd__mux2_1
X_3674_ net252 _1461_ VGND VGND VPWR VPWR _1503_ sky130_fd_sc_hd__nor2_1
X_2625_ _0445_ _0567_ VGND VGND VPWR VPWR _0568_ sky130_fd_sc_hd__nor2_1
X_2556_ _1631_ _0292_ VGND VGND VPWR VPWR _0499_ sky130_fd_sc_hd__or2_1
X_2487_ mantisaresult\[16\] _0367_ VGND VGND VPWR VPWR _0430_ sky130_fd_sc_hd__nor2_1
X_4157_ clknet_leaf_9_clk _0264_ VGND VGND VPWR VPWR mantisaBshift\[56\] sky130_fd_sc_hd__dfxtp_1
X_3108_ mantisaBshift\[32\] _1005_ net242 VGND VGND VPWR VPWR _1008_ sky130_fd_sc_hd__o21ai_1
X_4088_ clknet_leaf_25_clk _0197_ VGND VGND VPWR VPWR expmiddlec\[3\] sky130_fd_sc_hd__dfxtp_1
X_3039_ mantisaBshift\[16\] mantisaBshift\[17\] VGND VGND VPWR VPWR _0955_ sky130_fd_sc_hd__or2_1
XTAP_TAPCELL_ROW_38_476 VGND VPWR sky130_fd_sc_hd__tapvpwrvgnd_1
XFILLER_70_226 VGND VGND VPWR VPWR sky130_fd_sc_hd__fill_2
XFILLER_23_142 VGND VGND VPWR VPWR sky130_fd_sc_hd__decap_4
XTAP_TAPCELL_ROW_21_343 VGND VPWR sky130_fd_sc_hd__tapvpwrvgnd_1
XFILLER_11_42 VGND VGND VPWR VPWR sky130_fd_sc_hd__fill_1
XFILLER_11_31 VGND VGND VPWR VPWR sky130_fd_sc_hd__fill_1
XFILLER_11_86 VPWR VGND VPWR VGND sky130_ef_sc_hd__decap_12
XFILLER_46_245 VGND VGND VPWR VPWR sky130_fd_sc_hd__decap_6
XFILLER_34_429 VPWR VGND VPWR VGND sky130_ef_sc_hd__decap_12
XFILLER_46_289 VPWR VGND VPWR VGND sky130_ef_sc_hd__decap_12
XTAP_TAPCELL_ROW_72_744 VGND VPWR sky130_fd_sc_hd__tapvpwrvgnd_1
XFILLER_52_82 VGND VGND VPWR VPWR sky130_fd_sc_hd__fill_2
Xinput14 expb[5] VGND VGND VPWR VPWR net14 sky130_fd_sc_hd__buf_1
Xinput25 mantisaA[17] VGND VGND VPWR VPWR net25 sky130_fd_sc_hd__buf_1
Xinput36 mantisaA[6] VGND VGND VPWR VPWR net36 sky130_fd_sc_hd__clkbuf_1
Xinput47 mantisaB[16] VGND VGND VPWR VPWR net47 sky130_fd_sc_hd__buf_1
Xinput58 mantisaB[5] VGND VGND VPWR VPWR net58 sky130_fd_sc_hd__buf_1
X_2410_ _0295_ net182 VGND VGND VPWR VPWR _0353_ sky130_fd_sc_hd__nand2_1
X_3390_ _1239_ _1248_ VGND VGND VPWR VPWR _1260_ sky130_fd_sc_hd__nand2_1
X_2341_ _0287_ net373 net171 VGND VGND VPWR VPWR _0094_ sky130_fd_sc_hd__mux2_1
X_2272_ net46 net170 VGND VGND VPWR VPWR _1903_ sky130_fd_sc_hd__and2_1
X_4011_ clknet_leaf_29_clk _0122_ VGND VGND VPWR VPWR mantisaresult\[15\] sky130_fd_sc_hd__dfxtp_2
XFILLER_28_3 VGND VGND VPWR VPWR sky130_fd_sc_hd__decap_6
XFILLER_37_245 VPWR VGND VPWR VGND sky130_ef_sc_hd__decap_12
XFILLER_33_440 VGND VGND VPWR VPWR sky130_fd_sc_hd__fill_2
X_1987_ mantisaBshift\[52\] VGND VGND VPWR VPWR _1682_ sky130_fd_sc_hd__inv_2
X_3726_ _1463_ _1467_ net267 VGND VGND VPWR VPWR _1550_ sky130_fd_sc_hd__mux2_1
X_3657_ mantisaB0\[18\] net185 _1486_ VGND VGND VPWR VPWR _1487_ sky130_fd_sc_hd__a21boi_1
X_3588_ _1673_ expmiddle\[5\] VGND VGND VPWR VPWR _1419_ sky130_fd_sc_hd__nand2_1
X_2608_ _0371_ _0372_ _0550_ VGND VGND VPWR VPWR _0551_ sky130_fd_sc_hd__or3_1
X_2539_ _0382_ _0388_ _0480_ _0481_ VGND VGND VPWR VPWR _0482_ sky130_fd_sc_hd__or4_1
XFILLER_28_223 VPWR VGND VPWR VGND sky130_ef_sc_hd__decap_12
XFILLER_51_281 VPWR VGND VPWR VGND sky130_ef_sc_hd__decap_12
XFILLER_11_134 VGND VGND VPWR VPWR sky130_fd_sc_hd__fill_1
XFILLER_22_85 VGND VGND VPWR VPWR sky130_fd_sc_hd__decap_4
XFILLER_3_366 VPWR VGND VPWR VGND sky130_ef_sc_hd__decap_12
XFILLER_78_189 VGND VGND VPWR VPWR sky130_fd_sc_hd__decap_6
XFILLER_19_223 VGND VGND VPWR VPWR sky130_fd_sc_hd__fill_1
Xfanout191 _1500_ VGND VGND VPWR VPWR net191 sky130_fd_sc_hd__buf_2
XFILLER_59_381 VGND VGND VPWR VPWR sky130_fd_sc_hd__fill_1
XFILLER_34_237 VGND VGND VPWR VPWR sky130_fd_sc_hd__decap_6
X_2890_ net138 _0618_ VGND VGND VPWR VPWR _0829_ sky130_fd_sc_hd__nor2_1
XFILLER_30_410 VGND VGND VPWR VPWR sky130_fd_sc_hd__decap_4
XFILLER_30_421 VPWR VGND VPWR VGND sky130_ef_sc_hd__decap_12
XTAP_TAPCELL_ROW_32_427 VGND VPWR sky130_fd_sc_hd__tapvpwrvgnd_1
XFILLER_8_10 VGND VGND VPWR VPWR sky130_fd_sc_hd__fill_1
XTAP_TAPCELL_ROW_40_493 VGND VPWR sky130_fd_sc_hd__tapvpwrvgnd_1
X_3511_ mantisaresult\[55\] net109 _1348_ VGND VGND VPWR VPWR _1349_ sky130_fd_sc_hd__a21o_1
X_3442_ net355 net214 _1304_ expmiddlec\[2\] VGND VGND VPWR VPWR _0178_ sky130_fd_sc_hd__a22o_1
XFILLER_6_182 VPWR VGND VPWR VGND sky130_ef_sc_hd__decap_12
X_3373_ net247 _1244_ VGND VGND VPWR VPWR _1245_ sky130_fd_sc_hd__nor2_1
X_2324_ _1901_ net22 net103 VGND VGND VPWR VPWR _0279_ sky130_fd_sc_hd__mux2_1
XFILLER_57_318 VGND VGND VPWR VPWR sky130_fd_sc_hd__decap_3
XFILLER_69_167 VGND VGND VPWR VPWR sky130_fd_sc_hd__fill_1
X_2255_ net39 _1891_ net104 VGND VGND VPWR VPWR _1892_ sky130_fd_sc_hd__mux2_1
X_2186_ _1786_ _1841_ VGND VGND VPWR VPWR _1845_ sky130_fd_sc_hd__nor2_1
XFILLER_43_29 VPWR VGND VPWR VGND sky130_ef_sc_hd__decap_12
X_3709_ _1534_ VGND VGND VPWR VPWR _1535_ sky130_fd_sc_hd__inv_2
XTAP_TAPCELL_ROW_3_196 VGND VPWR sky130_fd_sc_hd__tapvpwrvgnd_1
XFILLER_16_237 VPWR VGND VPWR VGND sky130_ef_sc_hd__decap_12
XFILLER_56_384 VGND VGND VPWR VPWR sky130_fd_sc_hd__decap_6
XFILLER_12_421 VPWR VGND VPWR VGND sky130_ef_sc_hd__decap_12
XFILLER_12_410 VGND VGND VPWR VPWR sky130_fd_sc_hd__decap_8
XFILLER_8_469 VGND VGND VPWR VPWR sky130_fd_sc_hd__decap_4
XFILLER_79_421 VPWR VGND VPWR VGND sky130_ef_sc_hd__decap_12
Xhold3 signA1 VGND VGND VPWR VPWR net277 sky130_fd_sc_hd__dlygate4sd3_1
X_2040_ _1729_ _1730_ VGND VGND VPWR VPWR _1731_ sky130_fd_sc_hd__xnor2_1
XFILLER_66_137 VGND VGND VPWR VPWR sky130_fd_sc_hd__decap_3
X_3991_ clknet_leaf_28_clk net306 VGND VGND VPWR VPWR signA1 sky130_fd_sc_hd__dfxtp_1
XTAP_TAPCELL_ROW_45_530 VGND VPWR sky130_fd_sc_hd__tapvpwrvgnd_1
XFILLER_62_365 VPWR VGND VPWR VGND sky130_ef_sc_hd__decap_12
XFILLER_22_229 VGND VGND VPWR VPWR sky130_fd_sc_hd__fill_2
X_2942_ _0764_ _0789_ net138 VGND VGND VPWR VPWR _0874_ sky130_fd_sc_hd__mux2_1
XFILLER_30_251 VGND VGND VPWR VPWR sky130_fd_sc_hd__fill_1
X_2873_ _0812_ _0809_ net146 VGND VGND VPWR VPWR _0813_ sky130_fd_sc_hd__mux2_1
X_3425_ _1290_ VGND VGND VPWR VPWR _1291_ sky130_fd_sc_hd__inv_2
X_3356_ mantisaresult\[56\] _1229_ net203 VGND VGND VPWR VPWR _0167_ sky130_fd_sc_hd__mux2_1
XFILLER_38_29 VPWR VGND VPWR VGND sky130_ef_sc_hd__decap_12
X_2307_ _1924_ net348 net172 VGND VGND VPWR VPWR _0077_ sky130_fd_sc_hd__mux2_1
X_3287_ _1681_ mantisaBshift\[51\] _1165_ VGND VGND VPWR VPWR _1166_ sky130_fd_sc_hd__o21a_1
X_2238_ _1880_ net286 net175 VGND VGND VPWR VPWR _0052_ sky130_fd_sc_hd__mux2_1
X_2169_ _1653_ net53 net54 _1655_ _1829_ VGND VGND VPWR VPWR _1830_ sky130_fd_sc_hd__o221a_1
XFILLER_54_39 VGND VGND VPWR VPWR sky130_fd_sc_hd__fill_1
XFILLER_65_192 VGND VGND VPWR VPWR sky130_fd_sc_hd__fill_2
XTAP_TAPCELL_ROW_0_166 VGND VPWR sky130_fd_sc_hd__tapvpwrvgnd_1
XTAP_TAPCELL_ROW_51_577 VGND VPWR sky130_fd_sc_hd__tapvpwrvgnd_1
XFILLER_79_69 VPWR VGND VPWR VGND sky130_ef_sc_hd__decap_12
XTAP_TAPCELL_ROW_8_233 VGND VPWR sky130_fd_sc_hd__tapvpwrvgnd_1
XFILLER_76_413 VGND VGND VPWR VPWR sky130_fd_sc_hd__decap_6
XFILLER_76_457 VPWR VGND VPWR VGND sky130_ef_sc_hd__decap_12
XTAP_TAPCELL_ROW_59_644 VGND VPWR sky130_fd_sc_hd__tapvpwrvgnd_1
XFILLER_44_332 VGND VGND VPWR VPWR sky130_fd_sc_hd__fill_2
XFILLER_44_365 VPWR VGND VPWR VGND sky130_ef_sc_hd__decap_12
XTAP_TAPCELL_ROW_42_511 VGND VPWR sky130_fd_sc_hd__tapvpwrvgnd_1
X_3210_ mantisaAshift\[45\] mantisaBshift\[45\] VGND VGND VPWR VPWR _1096_ sky130_fd_sc_hd__nor2_1
X_3141_ mantisaBshift\[36\] mantisaBshift\[37\] _1030_ net244 VGND VGND VPWR VPWR
+ _1035_ sky130_fd_sc_hd__o31a_1
X_3072_ mantisaresult\[47\] net195 net160 net215 VGND VGND VPWR VPWR _0982_ sky130_fd_sc_hd__a31o_1
X_2023_ net64 _1716_ VGND VGND VPWR VPWR _1718_ sky130_fd_sc_hd__nand2_1
X_3974_ clknet_leaf_29_clk _0000_ VGND VGND VPWR VPWR inf0 sky130_fd_sc_hd__dfxtp_1
X_2925_ _0633_ _0859_ _0862_ net126 VGND VGND VPWR VPWR _0863_ sky130_fd_sc_hd__o22a_1
X_2856_ net275 net208 _0794_ _0796_ VGND VGND VPWR VPWR _0100_ sky130_fd_sc_hd__o22a_1
X_2787_ mantisaresult\[32\] net108 _0645_ _0611_ VGND VGND VPWR VPWR _0729_ sky130_fd_sc_hd__a22o_1
X_3408_ mantisaAshift\[62\] mantisaBshift\[62\] VGND VGND VPWR VPWR _1276_ sky130_fd_sc_hd__nand2_1
XTAP_TAPCELL_ROW_5_214 VGND VPWR sky130_fd_sc_hd__tapvpwrvgnd_1
XFILLER_58_402 VGND VGND VPWR VPWR sky130_fd_sc_hd__decap_8
X_3339_ _1199_ _1204_ _1211_ net246 _1213_ VGND VGND VPWR VPWR _1214_ sky130_fd_sc_hd__o221a_1
XFILLER_73_405 VPWR VGND VPWR VGND sky130_ef_sc_hd__decap_12
XFILLER_73_449 VPWR VGND VPWR VGND sky130_ef_sc_hd__decap_12
XFILLER_26_365 VPWR VGND VPWR VGND sky130_ef_sc_hd__decap_12
XFILLER_26_387 VGND VGND VPWR VPWR sky130_fd_sc_hd__fill_1
XFILLER_53_162 VGND VGND VPWR VPWR sky130_fd_sc_hd__decap_6
XFILLER_53_184 VGND VGND VPWR VPWR sky130_fd_sc_hd__fill_2
XTAP_TAPCELL_ROW_64_680 VGND VPWR sky130_fd_sc_hd__tapvpwrvgnd_1
XFILLER_41_335 VGND VGND VPWR VPWR sky130_fd_sc_hd__fill_1
XFILLER_14_64 VGND VGND VPWR VPWR sky130_fd_sc_hd__decap_4
XFILLER_5_225 VPWR VGND VPWR VGND sky130_ef_sc_hd__decap_12
XFILLER_30_41 VGND VGND VPWR VPWR sky130_fd_sc_hd__fill_1
XFILLER_76_265 VPWR VGND VPWR VGND sky130_ef_sc_hd__decap_12
XTAP_TAPCELL_ROW_19_327 VGND VPWR sky130_fd_sc_hd__tapvpwrvgnd_1
XFILLER_29_181 VGND VGND VPWR VPWR sky130_fd_sc_hd__fill_1
XFILLER_32_357 VGND VGND VPWR VPWR sky130_fd_sc_hd__decap_6
X_2710_ mantisaresult\[35\] net156 VGND VGND VPWR VPWR _0653_ sky130_fd_sc_hd__nand2_1
XFILLER_71_92 VGND VGND VPWR VPWR sky130_fd_sc_hd__decap_4
X_3690_ _1516_ VGND VGND VPWR VPWR _1517_ sky130_fd_sc_hd__inv_2
X_2641_ expmiddlec\[5\] _0582_ VGND VGND VPWR VPWR _0584_ sky130_fd_sc_hd__nand2_1
X_2572_ _0338_ _0348_ _0357_ _0514_ VGND VGND VPWR VPWR _0515_ sky130_fd_sc_hd__nor4_1
X_3124_ mantisaresult\[49\] net194 net165 _1022_ VGND VGND VPWR VPWR _1023_ sky130_fd_sc_hd__a31o_1
XTAP_TAPCELL_ROW_78_794 VGND VPWR sky130_fd_sc_hd__tapvpwrvgnd_1
X_3055_ mantisaBshift\[22\] _0966_ VGND VGND VPWR VPWR _0967_ sky130_fd_sc_hd__or2_1
X_2006_ _1694_ _1697_ _1699_ _1700_ VGND VGND VPWR VPWR _1701_ sky130_fd_sc_hd__nand4_2
XFILLER_35_151 VGND VGND VPWR VPWR sky130_fd_sc_hd__fill_1
XFILLER_70_419 VGND VGND VPWR VPWR sky130_fd_sc_hd__fill_1
XFILLER_50_154 VGND VGND VPWR VPWR sky130_fd_sc_hd__fill_2
XTAP_TAPCELL_ROW_61_661 VGND VPWR sky130_fd_sc_hd__tapvpwrvgnd_1
X_3957_ clknet_leaf_6_clk _0080_ VGND VGND VPWR VPWR mantisaB0\[8\] sky130_fd_sc_hd__dfxtp_1
X_2908_ mantisaresult\[43\] net198 net160 net215 VGND VGND VPWR VPWR _0847_ sky130_fd_sc_hd__a31o_1
X_3888_ clknet_leaf_19_clk _0011_ VGND VGND VPWR VPWR net85 sky130_fd_sc_hd__dfxtp_1
XFILLER_31_390 VGND VGND VPWR VPWR sky130_fd_sc_hd__fill_2
X_2839_ net144 _0779_ VGND VGND VPWR VPWR _0780_ sky130_fd_sc_hd__nand2_1
XFILLER_46_449 VGND VGND VPWR VPWR sky130_fd_sc_hd__fill_2
XFILLER_41_165 VGND VGND VPWR VPWR sky130_fd_sc_hd__decap_3
XTAP_TAPCELL_ROW_24_363 VGND VPWR sky130_fd_sc_hd__tapvpwrvgnd_1
XFILLER_41_40 VGND VGND VPWR VPWR sky130_fd_sc_hd__fill_1
XFILLER_41_84 VGND VGND VPWR VPWR sky130_fd_sc_hd__fill_1
XFILLER_1_261 VPWR VGND VPWR VGND sky130_ef_sc_hd__decap_12
XFILLER_49_254 VPWR VGND VPWR VGND sky130_ef_sc_hd__decap_12
XTAP_TAPCELL_ROW_67_709 VGND VPWR sky130_fd_sc_hd__tapvpwrvgnd_1
XFILLER_37_449 VGND VGND VPWR VPWR sky130_fd_sc_hd__decap_4
Xclkbuf_leaf_29_clk clknet_2_0__leaf_clk VGND VGND VPWR VPWR clknet_leaf_29_clk sky130_fd_sc_hd__clkbuf_8
XFILLER_52_408 VGND VGND VPWR VPWR sky130_fd_sc_hd__fill_2
XFILLER_64_246 VGND VGND VPWR VPWR sky130_fd_sc_hd__decap_6
XTAP_TAPCELL_ROW_75_775 VGND VPWR sky130_fd_sc_hd__tapvpwrvgnd_1
XFILLER_52_419 VGND VGND VPWR VPWR sky130_fd_sc_hd__fill_1
XFILLER_60_430 VGND VGND VPWR VPWR sky130_fd_sc_hd__decap_6
X_3811_ net191 _1580_ VGND VGND VPWR VPWR _0245_ sky130_fd_sc_hd__nor2_1
X_3742_ _1562_ _1563_ net263 VGND VGND VPWR VPWR _1564_ sky130_fd_sc_hd__mux2_1
X_3673_ net184 VGND VGND VPWR VPWR _1502_ sky130_fd_sc_hd__inv_2
X_2624_ _0494_ _0566_ _0498_ _0438_ VGND VGND VPWR VPWR _0567_ sky130_fd_sc_hd__or4bb_2
X_2555_ _0315_ _0431_ _0434_ _0497_ VGND VGND VPWR VPWR _0498_ sky130_fd_sc_hd__or4_1
X_2486_ _0338_ _0363_ _0377_ _0428_ VGND VGND VPWR VPWR _0429_ sky130_fd_sc_hd__nor4_1
X_4156_ clknet_leaf_11_clk _0263_ VGND VGND VPWR VPWR mantisaBshift\[59\] sky130_fd_sc_hd__dfxtp_1
X_3107_ mantisaresult\[32\] net205 _1006_ _1007_ VGND VGND VPWR VPWR _0140_ sky130_fd_sc_hd__o22a_1
XFILLER_55_202 VGND VGND VPWR VPWR sky130_fd_sc_hd__decap_4
X_4087_ clknet_leaf_26_clk _0196_ VGND VGND VPWR VPWR expmiddlec\[2\] sky130_fd_sc_hd__dfxtp_1
X_3038_ mantisaresult\[17\] _0954_ net201 VGND VGND VPWR VPWR _0124_ sky130_fd_sc_hd__mux2_1
XTAP_TAPCELL_ROW_38_477 VGND VPWR sky130_fd_sc_hd__tapvpwrvgnd_1
XFILLER_55_279 VGND VGND VPWR VPWR sky130_fd_sc_hd__fill_1
XFILLER_23_154 VPWR VGND VPWR VGND sky130_ef_sc_hd__decap_12
XFILLER_11_65 VGND VGND VPWR VPWR sky130_fd_sc_hd__decap_3
XFILLER_11_98 VGND VGND VPWR VPWR sky130_fd_sc_hd__fill_1
XTAP_TAPCELL_ROW_29_400 VGND VPWR sky130_fd_sc_hd__tapvpwrvgnd_1
XFILLER_19_449 VPWR VGND VPWR VGND sky130_ef_sc_hd__decap_12
XFILLER_42_430 VPWR VGND VPWR VGND sky130_ef_sc_hd__decap_12
XTAP_TAPCELL_ROW_72_745 VGND VPWR sky130_fd_sc_hd__tapvpwrvgnd_1
Xinput15 expb[6] VGND VGND VPWR VPWR net15 sky130_fd_sc_hd__buf_1
Xinput26 mantisaA[18] VGND VGND VPWR VPWR net26 sky130_fd_sc_hd__buf_1
Xinput37 mantisaA[7] VGND VGND VPWR VPWR net37 sky130_fd_sc_hd__buf_1
Xinput48 mantisaB[17] VGND VGND VPWR VPWR net48 sky130_fd_sc_hd__buf_1
Xinput59 mantisaB[6] VGND VGND VPWR VPWR net59 sky130_fd_sc_hd__buf_1
XFILLER_42_6 VGND VGND VPWR VPWR sky130_fd_sc_hd__fill_2
X_2340_ _1917_ net31 net100 VGND VGND VPWR VPWR _0287_ sky130_fd_sc_hd__mux2_1
X_2271_ _1902_ net280 net173 VGND VGND VPWR VPWR _0063_ sky130_fd_sc_hd__mux2_1
X_4010_ clknet_leaf_23_clk _0121_ VGND VGND VPWR VPWR mantisaresult\[14\] sky130_fd_sc_hd__dfxtp_1
XFILLER_77_393 VPWR VGND VPWR VGND sky130_ef_sc_hd__decap_12
XFILLER_37_257 VPWR VGND VPWR VGND sky130_ef_sc_hd__decap_12
XFILLER_33_452 VGND VGND VPWR VPWR sky130_fd_sc_hd__decap_4
X_1986_ mantisaAshift\[51\] VGND VGND VPWR VPWR _1681_ sky130_fd_sc_hd__inv_2
X_3725_ _1546_ _1548_ net257 VGND VGND VPWR VPWR _1549_ sky130_fd_sc_hd__mux2_1
Xclkbuf_leaf_9_clk clknet_2_1__leaf_clk VGND VGND VPWR VPWR clknet_leaf_9_clk sky130_fd_sc_hd__clkbuf_8
X_3656_ net273 net250 mantisaB0\[17\] VGND VGND VPWR VPWR _1486_ sky130_fd_sc_hd__or3b_1
X_3587_ _1673_ expmiddle\[5\] VGND VGND VPWR VPWR _1418_ sky130_fd_sc_hd__and2_2
X_2607_ _0314_ mantisaresult\[31\] mantisaresult\[30\] VGND VGND VPWR VPWR _0550_
+ sky130_fd_sc_hd__or3b_1
X_2538_ mantisaresult\[33\] _0320_ _0330_ _0399_ VGND VGND VPWR VPWR _0481_ sky130_fd_sc_hd__a31o_1
X_2469_ _1646_ _0338_ _0348_ _0404_ _0411_ VGND VGND VPWR VPWR _0412_ sky130_fd_sc_hd__o311a_1
XFILLER_28_235 VPWR VGND VPWR VGND sky130_ef_sc_hd__decap_12
X_4139_ clknet_leaf_3_clk _0246_ VGND VGND VPWR VPWR mantisaBshift\[38\] sky130_fd_sc_hd__dfxtp_1
XFILLER_51_293 VPWR VGND VPWR VGND sky130_ef_sc_hd__decap_12
XFILLER_22_97 VPWR VGND VPWR VGND sky130_ef_sc_hd__decap_12
XFILLER_3_378 VGND VGND VPWR VPWR sky130_fd_sc_hd__decap_6
XFILLER_3_389 VGND VGND VPWR VPWR sky130_fd_sc_hd__decap_3
Xfanout170 _1872_ VGND VGND VPWR VPWR net170 sky130_fd_sc_hd__clkbuf_2
Xfanout192 _1499_ VGND VGND VPWR VPWR net192 sky130_fd_sc_hd__clkbuf_2
XFILLER_59_393 VGND VGND VPWR VPWR sky130_fd_sc_hd__fill_2
XFILLER_19_279 VGND VGND VPWR VPWR sky130_fd_sc_hd__fill_1
XFILLER_74_363 VGND VGND VPWR VPWR sky130_fd_sc_hd__fill_1
XFILLER_15_441 VGND VGND VPWR VPWR sky130_fd_sc_hd__decap_6
XFILLER_27_290 VGND VGND VPWR VPWR sky130_fd_sc_hd__fill_2
XTAP_TAPCELL_ROW_32_428 VGND VPWR sky130_fd_sc_hd__tapvpwrvgnd_1
XFILLER_30_433 VPWR VGND VPWR VGND sky130_ef_sc_hd__decap_12
XTAP_TAPCELL_ROW_40_494 VGND VPWR sky130_fd_sc_hd__tapvpwrvgnd_1
X_3510_ mantisaresult\[54\] net155 net133 VGND VGND VPWR VPWR _1348_ sky130_fd_sc_hd__and3_1
X_3441_ net357 net213 _1304_ expmiddlec\[1\] VGND VGND VPWR VPWR _0177_ sky130_fd_sc_hd__a22o_1
XFILLER_6_194 VGND VGND VPWR VPWR sky130_fd_sc_hd__fill_2
X_3372_ _1230_ _1234_ _1231_ VGND VGND VPWR VPWR _1244_ sky130_fd_sc_hd__o21a_1
X_2323_ _0278_ net380 net173 VGND VGND VPWR VPWR _0085_ sky130_fd_sc_hd__mux2_1
X_2254_ net62 net169 VGND VGND VPWR VPWR _1891_ sky130_fd_sc_hd__and2_1
X_2185_ net269 _1844_ net177 VGND VGND VPWR VPWR _0035_ sky130_fd_sc_hd__mux2_1
XFILLER_65_341 VGND VGND VPWR VPWR sky130_fd_sc_hd__decap_3
X_1969_ net62 VGND VGND VPWR VPWR _1664_ sky130_fd_sc_hd__inv_2
XFILLER_4_109 VPWR VGND VPWR VGND sky130_ef_sc_hd__decap_12
X_3708_ _1466_ _1468_ net272 VGND VGND VPWR VPWR _1534_ sky130_fd_sc_hd__mux2_1
X_3639_ _1686_ _1430_ _1457_ mantisaB0\[8\] VGND VGND VPWR VPWR _1469_ sky130_fd_sc_hd__a22oi_2
XFILLER_0_337 VPWR VGND VPWR VGND sky130_ef_sc_hd__decap_12
XFILLER_68_27 VGND VGND VPWR VPWR sky130_fd_sc_hd__fill_1
XFILLER_75_105 VGND VGND VPWR VPWR sky130_fd_sc_hd__decap_6
XFILLER_68_190 VGND VGND VPWR VPWR sky130_fd_sc_hd__decap_6
XFILLER_56_363 VGND VGND VPWR VPWR sky130_fd_sc_hd__fill_1
XTAP_TAPCELL_ROW_3_197 VGND VPWR sky130_fd_sc_hd__tapvpwrvgnd_1
XFILLER_12_433 VPWR VGND VPWR VGND sky130_ef_sc_hd__decap_12
XFILLER_79_433 VPWR VGND VPWR VGND sky130_ef_sc_hd__decap_12
Xhold4 signA2 VGND VGND VPWR VPWR net278 sky130_fd_sc_hd__dlygate4sd3_1
XFILLER_66_105 VPWR VGND VPWR VGND sky130_ef_sc_hd__decap_12
XFILLER_47_341 VPWR VGND VPWR VGND sky130_ef_sc_hd__decap_12
X_3990_ clknet_leaf_26_clk _0001_ VGND VGND VPWR VPWR sub sky130_fd_sc_hd__dfxtp_1
XTAP_TAPCELL_ROW_45_531 VGND VPWR sky130_fd_sc_hd__tapvpwrvgnd_1
X_2941_ _0788_ _0791_ net139 VGND VGND VPWR VPWR _0873_ sky130_fd_sc_hd__mux2_1
X_2872_ _0737_ _0811_ net120 VGND VGND VPWR VPWR _0812_ sky130_fd_sc_hd__mux2_1
Xmax_cap167 _0446_ VGND VGND VPWR VPWR net167 sky130_fd_sc_hd__clkbuf_1
X_3424_ mantisaresult\[51\] net155 VGND VGND VPWR VPWR _1290_ sky130_fd_sc_hd__and2_1
X_3355_ _1218_ _1228_ VGND VGND VPWR VPWR _1229_ sky130_fd_sc_hd__xnor2_1
X_2306_ _1883_ net35 net105 VGND VGND VPWR VPWR _1924_ sky130_fd_sc_hd__mux2_1
X_3286_ mantisaBshift\[50\] _1156_ mantisaAshift\[50\] VGND VGND VPWR VPWR _1165_
+ sky130_fd_sc_hd__or3b_1
X_2237_ net33 _1879_ net102 VGND VGND VPWR VPWR _1880_ sky130_fd_sc_hd__mux2_1
XFILLER_72_108 VGND VGND VPWR VPWR sky130_fd_sc_hd__decap_6
X_2168_ _1653_ net53 net52 _1654_ _1828_ VGND VGND VPWR VPWR _1829_ sky130_fd_sc_hd__a221o_1
XTAP_TAPCELL_ROW_0_167 VGND VPWR sky130_fd_sc_hd__tapvpwrvgnd_1
X_2099_ _1707_ _1710_ _1713_ VGND VGND VPWR VPWR _1761_ sky130_fd_sc_hd__and3_1
XFILLER_13_208 VGND VGND VPWR VPWR sky130_fd_sc_hd__decap_6
XTAP_TAPCELL_ROW_51_578 VGND VPWR sky130_fd_sc_hd__tapvpwrvgnd_1
XPHY_EDGE_ROW_17_Right_17 VGND VGND VPWR VPWR sky130_fd_sc_hd__decap_3
XFILLER_21_285 VPWR VGND VPWR VGND sky130_ef_sc_hd__decap_12
XFILLER_79_37 VGND VGND VPWR VPWR sky130_fd_sc_hd__fill_1
XTAP_TAPCELL_ROW_8_234 VGND VPWR sky130_fd_sc_hd__tapvpwrvgnd_1
XPHY_EDGE_ROW_26_Right_26 VGND VGND VPWR VPWR sky130_fd_sc_hd__decap_3
XTAP_TAPCELL_ROW_59_645 VGND VPWR sky130_fd_sc_hd__tapvpwrvgnd_1
XFILLER_76_469 VGND VGND VPWR VPWR sky130_fd_sc_hd__decap_4
XFILLER_29_352 VGND VGND VPWR VPWR sky130_fd_sc_hd__fill_2
XFILLER_63_119 VGND VGND VPWR VPWR sky130_fd_sc_hd__fill_1
XFILLER_28_85 VGND VGND VPWR VPWR sky130_fd_sc_hd__decap_8
XFILLER_44_344 VGND VGND VPWR VPWR sky130_fd_sc_hd__fill_1
XFILLER_44_377 VGND VGND VPWR VPWR sky130_fd_sc_hd__decap_8
XFILLER_71_185 VGND VGND VPWR VPWR sky130_fd_sc_hd__fill_1
XFILLER_44_73 VGND VGND VPWR VPWR sky130_fd_sc_hd__decap_8
XFILLER_12_241 VGND VGND VPWR VPWR sky130_fd_sc_hd__fill_1
XPHY_EDGE_ROW_35_Right_35 VGND VGND VPWR VPWR sky130_fd_sc_hd__decap_3
XFILLER_60_83 VGND VGND VPWR VPWR sky130_fd_sc_hd__fill_1
XFILLER_8_289 VPWR VGND VPWR VGND sky130_ef_sc_hd__decap_12
XPHY_EDGE_ROW_44_Right_44 VGND VGND VPWR VPWR sky130_fd_sc_hd__decap_3
X_3140_ mantisaresult\[37\] _1034_ net205 VGND VGND VPWR VPWR _0146_ sky130_fd_sc_hd__mux2_1
XFILLER_39_138 VPWR VGND VPWR VGND sky130_ef_sc_hd__decap_12
X_3071_ net158 _0980_ VGND VGND VPWR VPWR _0981_ sky130_fd_sc_hd__and2_1
X_2022_ net64 _1716_ VGND VGND VPWR VPWR _1717_ sky130_fd_sc_hd__or2_1
XFILLER_50_314 VGND VGND VPWR VPWR sky130_fd_sc_hd__fill_1
XFILLER_62_174 VGND VGND VPWR VPWR sky130_fd_sc_hd__decap_4
X_3973_ clknet_leaf_28_clk _0096_ VGND VGND VPWR VPWR signA0 sky130_fd_sc_hd__dfxtp_1
XPHY_EDGE_ROW_53_Right_53 VGND VGND VPWR VPWR sky130_fd_sc_hd__decap_3
X_2924_ _0860_ _0861_ net122 VGND VGND VPWR VPWR _0862_ sky130_fd_sc_hd__mux2_1
X_2855_ net225 net194 net166 _0795_ VGND VGND VPWR VPWR _0796_ sky130_fd_sc_hd__a31o_1
X_2786_ mantisaresult\[30\] net108 _0642_ net132 VGND VGND VPWR VPWR _0728_ sky130_fd_sc_hd__a22o_1
XPHY_EDGE_ROW_62_Right_62 VGND VGND VPWR VPWR sky130_fd_sc_hd__decap_3
X_3407_ mantisaAshift\[62\] mantisaBshift\[62\] VGND VGND VPWR VPWR _1275_ sky130_fd_sc_hd__or2_1
X_3338_ mantisaBshift\[54\] mantisaAshift\[54\] net246 VGND VGND VPWR VPWR _1213_
+ sky130_fd_sc_hd__nand3b_1
XTAP_TAPCELL_ROW_5_215 VGND VPWR sky130_fd_sc_hd__tapvpwrvgnd_1
X_3269_ net245 _1149_ VGND VGND VPWR VPWR _1150_ sky130_fd_sc_hd__nand2_1
XFILLER_73_417 VPWR VGND VPWR VGND sky130_ef_sc_hd__decap_12
XFILLER_45_119 VGND VGND VPWR VPWR sky130_fd_sc_hd__fill_1
XFILLER_26_377 VGND VGND VPWR VPWR sky130_fd_sc_hd__fill_1
XPHY_EDGE_ROW_71_Right_71 VGND VGND VPWR VPWR sky130_fd_sc_hd__decap_3
XTAP_TAPCELL_ROW_64_681 VGND VPWR sky130_fd_sc_hd__tapvpwrvgnd_1
XFILLER_5_237 VPWR VGND VPWR VGND sky130_ef_sc_hd__decap_12
XFILLER_39_51 VGND VGND VPWR VPWR sky130_fd_sc_hd__fill_1
XFILLER_49_447 VGND VGND VPWR VPWR sky130_fd_sc_hd__fill_1
XFILLER_76_277 VPWR VGND VPWR VGND sky130_ef_sc_hd__decap_12
XFILLER_29_160 VGND VGND VPWR VPWR sky130_fd_sc_hd__decap_8
XFILLER_44_141 VGND VGND VPWR VPWR sky130_fd_sc_hd__decap_3
X_2640_ _0582_ VGND VGND VPWR VPWR _0583_ sky130_fd_sc_hd__inv_2
XTAP_TAPCELL_ROW_10_250 VGND VPWR sky130_fd_sc_hd__tapvpwrvgnd_1
X_2571_ mantisaresult\[30\] mantisaresult\[29\] mantisaresult\[28\] mantisaresult\[27\]
+ VGND VGND VPWR VPWR _0514_ sky130_fd_sc_hd__or4b_1
XFILLER_67_200 VGND VGND VPWR VPWR sky130_fd_sc_hd__fill_1
X_3123_ mantisaresult\[48\] net194 net162 net216 VGND VGND VPWR VPWR _1022_ sky130_fd_sc_hd__a31o_1
XTAP_TAPCELL_ROW_78_795 VGND VPWR sky130_fd_sc_hd__tapvpwrvgnd_1
X_3054_ mantisaBshift\[20\] mantisaBshift\[21\] _0961_ net240 VGND VGND VPWR VPWR
+ _0966_ sky130_fd_sc_hd__o31a_1
XFILLER_55_417 VGND VGND VPWR VPWR sky130_fd_sc_hd__fill_1
X_2005_ net1 net3 net2 net5 VGND VGND VPWR VPWR _1700_ sky130_fd_sc_hd__and4_1
XFILLER_23_369 VGND VGND VPWR VPWR sky130_fd_sc_hd__fill_1
X_3956_ clknet_leaf_7_clk _0079_ VGND VGND VPWR VPWR mantisaB0\[7\] sky130_fd_sc_hd__dfxtp_1
XTAP_TAPCELL_ROW_61_662 VGND VPWR sky130_fd_sc_hd__tapvpwrvgnd_1
X_2907_ net125 _0845_ _0841_ _0832_ VGND VGND VPWR VPWR _0846_ sky130_fd_sc_hd__o211a_1
X_3887_ clknet_leaf_17_clk _0010_ VGND VGND VPWR VPWR net74 sky130_fd_sc_hd__dfxtp_1
X_2838_ _0655_ _0659_ net120 VGND VGND VPWR VPWR _0779_ sky130_fd_sc_hd__mux2_1
X_2769_ net141 _0706_ _0710_ VGND VGND VPWR VPWR _0711_ sky130_fd_sc_hd__a21oi_1
XFILLER_46_439 VGND VGND VPWR VPWR sky130_fd_sc_hd__fill_2
XFILLER_73_225 VPWR VGND VPWR VGND sky130_ef_sc_hd__decap_12
XFILLER_61_409 VPWR VGND VPWR VGND sky130_ef_sc_hd__decap_12
XFILLER_14_303 VGND VGND VPWR VPWR sky130_fd_sc_hd__decap_4
XFILLER_26_141 VGND VGND VPWR VPWR sky130_fd_sc_hd__decap_3
XTAP_TAPCELL_ROW_24_364 VGND VPWR sky130_fd_sc_hd__tapvpwrvgnd_1
XFILLER_41_52 VGND VGND VPWR VPWR sky130_fd_sc_hd__decap_4
XFILLER_1_273 VGND VGND VPWR VPWR sky130_fd_sc_hd__decap_6
XFILLER_49_222 VGND VGND VPWR VPWR sky130_fd_sc_hd__fill_2
XFILLER_66_82 VGND VGND VPWR VPWR sky130_fd_sc_hd__fill_2
XFILLER_64_269 VPWR VGND VPWR VGND sky130_ef_sc_hd__decap_12
XFILLER_17_185 VGND VGND VPWR VPWR sky130_fd_sc_hd__fill_1
X_3810_ net189 _1576_ VGND VGND VPWR VPWR _0244_ sky130_fd_sc_hd__nor2_1
X_3741_ _1524_ _1520_ net266 VGND VGND VPWR VPWR _1563_ sky130_fd_sc_hd__mux2_1
XFILLER_13_391 VGND VGND VPWR VPWR sky130_fd_sc_hd__fill_1
X_3672_ net254 net192 VGND VGND VPWR VPWR _1501_ sky130_fd_sc_hd__and2_1
X_2623_ _0545_ _0564_ _0565_ _0368_ VGND VGND VPWR VPWR _0566_ sky130_fd_sc_hd__or4b_1
X_2554_ _1631_ mantisaresult\[12\] VGND VGND VPWR VPWR _0497_ sky130_fd_sc_hd__nand2_1
X_2485_ mantisaresult\[16\] mantisaresult\[18\] mantisaresult\[17\] VGND VGND VPWR
+ VPWR _0428_ sky130_fd_sc_hd__or3_2
X_4155_ clknet_leaf_11_clk _0262_ VGND VGND VPWR VPWR mantisaBshift\[60\] sky130_fd_sc_hd__dfxtp_1
X_3106_ net242 _1676_ _1005_ net235 VGND VGND VPWR VPWR _1007_ sky130_fd_sc_hd__a31o_1
XFILLER_55_225 VPWR VGND VPWR VGND sky130_ef_sc_hd__decap_12
X_4086_ clknet_leaf_15_clk _0195_ VGND VGND VPWR VPWR four_man\[53\] sky130_fd_sc_hd__dfxtp_1
X_3037_ mantisaBshift\[17\] _0953_ VGND VGND VPWR VPWR _0954_ sky130_fd_sc_hd__xnor2_1
XTAP_TAPCELL_ROW_38_478 VGND VPWR sky130_fd_sc_hd__tapvpwrvgnd_1
XFILLER_23_166 VGND VGND VPWR VPWR sky130_fd_sc_hd__fill_2
X_3939_ clknet_leaf_8_clk _0062_ VGND VGND VPWR VPWR mantisaA0\[13\] sky130_fd_sc_hd__dfxtp_1
XFILLER_11_55 VGND VGND VPWR VPWR sky130_fd_sc_hd__fill_1
XPHY_EDGE_ROW_21_Left_101 VGND VGND VPWR VPWR sky130_fd_sc_hd__decap_3
XFILLER_19_439 VGND VGND VPWR VPWR sky130_fd_sc_hd__fill_2
XTAP_TAPCELL_ROW_29_401 VGND VPWR sky130_fd_sc_hd__tapvpwrvgnd_1
XFILLER_27_461 VPWR VGND VPWR VGND sky130_ef_sc_hd__decap_12
XFILLER_14_111 VGND VGND VPWR VPWR sky130_fd_sc_hd__decap_4
XFILLER_36_85 VPWR VGND VPWR VGND sky130_ef_sc_hd__decap_12
XTAP_TAPCELL_ROW_72_746 VGND VPWR sky130_fd_sc_hd__tapvpwrvgnd_1
XFILLER_42_442 VGND VGND VPWR VPWR sky130_fd_sc_hd__decap_4
XPHY_EDGE_ROW_30_Left_110 VGND VGND VPWR VPWR sky130_fd_sc_hd__decap_3
Xinput16 expb[7] VGND VGND VPWR VPWR net16 sky130_fd_sc_hd__buf_1
XFILLER_10_361 VGND VGND VPWR VPWR sky130_fd_sc_hd__decap_3
Xinput27 mantisaA[19] VGND VGND VPWR VPWR net27 sky130_fd_sc_hd__clkbuf_1
XFILLER_10_394 VPWR VGND VPWR VGND sky130_ef_sc_hd__decap_12
XFILLER_6_332 VGND VGND VPWR VPWR sky130_fd_sc_hd__fill_1
Xinput49 mantisaB[18] VGND VGND VPWR VPWR net49 sky130_fd_sc_hd__buf_1
Xinput38 mantisaA[8] VGND VGND VPWR VPWR net38 sky130_fd_sc_hd__clkbuf_1
X_2270_ net22 _1901_ net103 VGND VGND VPWR VPWR _1902_ sky130_fd_sc_hd__mux2_1
XFILLER_77_361 VPWR VGND VPWR VGND sky130_ef_sc_hd__decap_12
XFILLER_37_269 VGND VGND VPWR VPWR sky130_fd_sc_hd__decap_8
XFILLER_52_206 VGND VGND VPWR VPWR sky130_fd_sc_hd__decap_4
XFILLER_18_472 VGND VGND VPWR VPWR sky130_fd_sc_hd__fill_1
XFILLER_33_420 VPWR VGND VPWR VGND sky130_ef_sc_hd__decap_12
XTAP_TAPCELL_ROW_35_448 VGND VPWR sky130_fd_sc_hd__tapvpwrvgnd_1
XFILLER_60_261 VGND VGND VPWR VPWR sky130_fd_sc_hd__decap_4
X_1985_ mantisaBshift\[49\] VGND VGND VPWR VPWR _1680_ sky130_fd_sc_hd__inv_2
X_3724_ net262 _1547_ VGND VGND VPWR VPWR _1548_ sky130_fd_sc_hd__or2_1
XFILLER_9_181 VPWR VGND VPWR VGND sky130_ef_sc_hd__decap_12
X_3655_ _1478_ _1484_ net266 VGND VGND VPWR VPWR _1485_ sky130_fd_sc_hd__mux2_1
X_2606_ _0342_ _0547_ _0548_ VGND VGND VPWR VPWR _0549_ sky130_fd_sc_hd__or3_1
X_3586_ net323 _1417_ net207 VGND VGND VPWR VPWR _0209_ sky130_fd_sc_hd__mux2_1
X_2537_ net228 _0311_ _0326_ _0300_ _0302_ VGND VGND VPWR VPWR _0480_ sky130_fd_sc_hd__a32o_1
X_2468_ _1634_ net188 _0312_ _0410_ VGND VGND VPWR VPWR _0411_ sky130_fd_sc_hd__or4_1
XFILLER_75_309 VPWR VGND VPWR VGND sky130_ef_sc_hd__decap_12
X_2399_ _0333_ _0341_ VGND VGND VPWR VPWR _0342_ sky130_fd_sc_hd__or2_1
XFILLER_28_247 VGND VGND VPWR VPWR sky130_fd_sc_hd__decap_4
X_4138_ clknet_leaf_3_clk _0245_ VGND VGND VPWR VPWR mantisaBshift\[39\] sky130_fd_sc_hd__dfxtp_1
X_4069_ clknet_leaf_20_clk _0178_ VGND VGND VPWR VPWR expmiddled\[2\] sky130_fd_sc_hd__dfxtp_1
XFILLER_43_228 VGND VGND VPWR VPWR sky130_fd_sc_hd__decap_4
XFILLER_24_453 VGND VGND VPWR VPWR sky130_fd_sc_hd__decap_4
XFILLER_51_272 VGND VGND VPWR VPWR sky130_fd_sc_hd__decap_8
XFILLER_11_169 VGND VGND VPWR VPWR sky130_fd_sc_hd__decap_3
XFILLER_3_324 VGND VGND VPWR VPWR sky130_fd_sc_hd__decap_6
XFILLER_3_335 VGND VGND VPWR VPWR sky130_fd_sc_hd__fill_1
XFILLER_0_3 VPWR VGND VPWR VGND sky130_ef_sc_hd__decap_12
XFILLER_78_169 VGND VGND VPWR VPWR sky130_fd_sc_hd__fill_1
XFILLER_66_309 VPWR VGND VPWR VGND sky130_ef_sc_hd__decap_12
Xfanout171 net176 VGND VGND VPWR VPWR net171 sky130_fd_sc_hd__clkbuf_4
Xfanout160 net162 VGND VGND VPWR VPWR net160 sky130_fd_sc_hd__buf_2
XFILLER_19_225 VGND VGND VPWR VPWR sky130_fd_sc_hd__decap_6
Xfanout193 _1420_ VGND VGND VPWR VPWR net193 sky130_fd_sc_hd__buf_2
XFILLER_19_258 VGND VGND VPWR VPWR sky130_fd_sc_hd__fill_2
XTAP_TAPCELL_ROW_32_429 VGND VPWR sky130_fd_sc_hd__tapvpwrvgnd_1
XFILLER_42_250 VGND VGND VPWR VPWR sky130_fd_sc_hd__fill_2
XFILLER_30_445 VGND VGND VPWR VPWR sky130_fd_sc_hd__fill_1
XFILLER_42_283 VPWR VGND VPWR VGND sky130_ef_sc_hd__decap_12
XTAP_TAPCELL_ROW_40_495 VGND VPWR sky130_fd_sc_hd__tapvpwrvgnd_1
X_3440_ net369 net214 _1304_ expmiddlec\[0\] VGND VGND VPWR VPWR _0176_ sky130_fd_sc_hd__a22o_1
X_3371_ _1218_ _1225_ _1232_ _1242_ VGND VGND VPWR VPWR _1243_ sky130_fd_sc_hd__a31o_1
XFILLER_33_3 VGND VGND VPWR VPWR sky130_fd_sc_hd__fill_1
X_2322_ _1899_ net21 net103 VGND VGND VPWR VPWR _0278_ sky130_fd_sc_hd__mux2_1
XFILLER_57_309 VGND VGND VPWR VPWR sky130_fd_sc_hd__fill_1
XFILLER_69_147 VGND VGND VPWR VPWR sky130_fd_sc_hd__fill_1
X_2253_ _1890_ net295 net174 VGND VGND VPWR VPWR _0057_ sky130_fd_sc_hd__mux2_1
X_2184_ _1840_ _1843_ VGND VGND VPWR VPWR _1844_ sky130_fd_sc_hd__xnor2_1
XFILLER_65_320 VGND VGND VPWR VPWR sky130_fd_sc_hd__decap_6
XFILLER_33_250 VGND VGND VPWR VPWR sky130_fd_sc_hd__fill_1
XFILLER_21_445 VGND VGND VPWR VPWR sky130_fd_sc_hd__decap_3
X_1968_ net59 VGND VGND VPWR VPWR _1663_ sky130_fd_sc_hd__inv_2
X_3707_ _1685_ mantisaB0\[0\] net185 _1532_ VGND VGND VPWR VPWR _1533_ sky130_fd_sc_hd__a31o_1
X_3638_ _1686_ _1427_ net185 mantisaB0\[6\] VGND VGND VPWR VPWR _1468_ sky130_fd_sc_hd__a22o_1
X_3569_ net118 _1380_ _1401_ VGND VGND VPWR VPWR _1402_ sky130_fd_sc_hd__o21a_1
XFILLER_0_349 VGND VGND VPWR VPWR sky130_fd_sc_hd__decap_4
XFILLER_48_309 VGND VGND VPWR VPWR sky130_fd_sc_hd__decap_6
XTAP_TAPCELL_ROW_3_198 VGND VPWR sky130_fd_sc_hd__tapvpwrvgnd_1
XPHY_EDGE_ROW_9_Left_89 VGND VGND VPWR VPWR sky130_fd_sc_hd__decap_3
XFILLER_71_389 VGND VGND VPWR VPWR sky130_fd_sc_hd__decap_3
XFILLER_12_445 VPWR VGND VPWR VGND sky130_ef_sc_hd__decap_12
XFILLER_79_445 VGND VGND VPWR VPWR sky130_fd_sc_hd__decap_3
XFILLER_58_50 VGND VGND VPWR VPWR sky130_fd_sc_hd__fill_2
XFILLER_66_117 VPWR VGND VPWR VGND sky130_ef_sc_hd__decap_12
Xhold5 signA3 VGND VGND VPWR VPWR net279 sky130_fd_sc_hd__dlygate4sd3_1
XFILLER_47_353 VGND VGND VPWR VPWR sky130_fd_sc_hd__decap_6
XFILLER_74_161 VPWR VGND VPWR VGND sky130_ef_sc_hd__decap_12
XTAP_TAPCELL_ROW_45_532 VGND VPWR sky130_fd_sc_hd__tapvpwrvgnd_1
X_2940_ mantisaresult\[3\] _0872_ net201 VGND VGND VPWR VPWR _0108_ sky130_fd_sc_hd__mux2_1
X_2871_ net225 net110 _0810_ VGND VGND VPWR VPWR _0811_ sky130_fd_sc_hd__a21o_1
XFILLER_30_253 VGND VGND VPWR VPWR sky130_fd_sc_hd__decap_3
XFILLER_30_297 VGND VGND VPWR VPWR sky130_fd_sc_hd__decap_8
X_3423_ _0839_ _0922_ net126 VGND VGND VPWR VPWR _1289_ sky130_fd_sc_hd__o21ai_1
Xmax_cap179 net180 VGND VGND VPWR VPWR net179 sky130_fd_sc_hd__clkbuf_1
X_3354_ net246 _1227_ _1226_ VGND VGND VPWR VPWR _1228_ sky130_fd_sc_hd__o21a_1
X_3285_ _1163_ VGND VGND VPWR VPWR _1164_ sky130_fd_sc_hd__inv_2
X_2305_ _1923_ net376 net172 VGND VGND VPWR VPWR _0076_ sky130_fd_sc_hd__mux2_1
XFILLER_57_117 VGND VGND VPWR VPWR sky130_fd_sc_hd__fill_1
XFILLER_38_320 VGND VGND VPWR VPWR sky130_fd_sc_hd__decap_6
XFILLER_38_331 VGND VGND VPWR VPWR sky130_fd_sc_hd__decap_6
X_2236_ net56 net169 VGND VGND VPWR VPWR _1879_ sky130_fd_sc_hd__and2_1
X_2167_ _1654_ net52 _1826_ _1827_ VGND VGND VPWR VPWR _1828_ sky130_fd_sc_hd__o22a_1
XTAP_TAPCELL_ROW_0_168 VGND VPWR sky130_fd_sc_hd__tapvpwrvgnd_1
X_2098_ _1694_ _1697_ _1699_ _1700_ VGND VGND VPWR VPWR _1760_ sky130_fd_sc_hd__and4_1
XFILLER_0_90 VPWR VGND VPWR VGND sky130_ef_sc_hd__decap_12
XFILLER_21_231 VGND VGND VPWR VPWR sky130_fd_sc_hd__fill_1
XTAP_TAPCELL_ROW_51_579 VGND VPWR sky130_fd_sc_hd__tapvpwrvgnd_1
XFILLER_70_29 VGND VGND VPWR VPWR sky130_fd_sc_hd__fill_1
XFILLER_79_27 VGND VGND VPWR VPWR sky130_fd_sc_hd__fill_1
XTAP_TAPCELL_ROW_8_235 VGND VPWR sky130_fd_sc_hd__tapvpwrvgnd_1
XFILLER_0_102 VGND VGND VPWR VPWR sky130_fd_sc_hd__decap_8
XFILLER_0_113 VPWR VGND VPWR VGND sky130_ef_sc_hd__decap_12
XTAP_TAPCELL_ROW_59_646 VGND VPWR sky130_fd_sc_hd__tapvpwrvgnd_1
XFILLER_44_389 VPWR VGND VPWR VGND sky130_ef_sc_hd__decap_12
XFILLER_71_197 VGND VGND VPWR VPWR sky130_fd_sc_hd__fill_1
XFILLER_12_253 VPWR VGND VPWR VGND sky130_ef_sc_hd__decap_12
XFILLER_12_297 VGND VGND VPWR VPWR sky130_fd_sc_hd__decap_8
XFILLER_8_235 VGND VGND VPWR VPWR sky130_fd_sc_hd__decap_4
XFILLER_60_62 VGND VGND VPWR VPWR sky130_fd_sc_hd__fill_1
XFILLER_5_57 VPWR VGND VPWR VGND sky130_ef_sc_hd__decap_12
XFILLER_79_253 VPWR VGND VPWR VGND sky130_ef_sc_hd__decap_12
X_3070_ _0649_ _0938_ _0940_ _0697_ _0979_ VGND VGND VPWR VPWR _0980_ sky130_fd_sc_hd__a221o_1
X_2021_ net65 net63 VGND VGND VPWR VPWR _1716_ sky130_fd_sc_hd__xor2_1
XPHY_EDGE_ROW_59_Left_139 VGND VGND VPWR VPWR sky130_fd_sc_hd__decap_3
X_3972_ clknet_leaf_29_clk _0095_ VGND VGND VPWR VPWR mantisaA0\[23\] sky130_fd_sc_hd__dfxtp_1
X_2923_ _0727_ _0718_ net143 VGND VGND VPWR VPWR _0861_ sky130_fd_sc_hd__mux2_1
XFILLER_50_359 VGND VGND VPWR VPWR sky130_fd_sc_hd__decap_4
X_2854_ net226 net194 net163 net217 VGND VGND VPWR VPWR _0795_ sky130_fd_sc_hd__a31o_1
X_2785_ _0725_ _0726_ net117 VGND VGND VPWR VPWR _0727_ sky130_fd_sc_hd__mux2_1
XPHY_EDGE_ROW_68_Left_148 VGND VGND VPWR VPWR sky130_fd_sc_hd__decap_3
X_3406_ mantisaresult\[61\] _1274_ net204 VGND VGND VPWR VPWR _0172_ sky130_fd_sc_hd__mux2_1
X_3337_ mantisaBshift\[54\] mantisaAshift\[54\] VGND VGND VPWR VPWR _1212_ sky130_fd_sc_hd__and2b_1
XFILLER_58_448 VGND VGND VPWR VPWR sky130_fd_sc_hd__fill_1
X_3268_ _1127_ _1146_ _1148_ VGND VGND VPWR VPWR _1149_ sky130_fd_sc_hd__a21o_1
X_2219_ net6 net14 net98 VGND VGND VPWR VPWR _1868_ sky130_fd_sc_hd__mux2_1
XTAP_TAPCELL_ROW_56_616 VGND VPWR sky130_fd_sc_hd__tapvpwrvgnd_1
X_3199_ mantisaresult\[49\] net196 net161 net215 VGND VGND VPWR VPWR _1087_ sky130_fd_sc_hd__a31o_1
XFILLER_73_429 VPWR VGND VPWR VGND sky130_ef_sc_hd__decap_12
XPHY_EDGE_ROW_77_Left_157 VGND VGND VPWR VPWR sky130_fd_sc_hd__decap_3
XFILLER_26_334 VGND VGND VPWR VPWR sky130_fd_sc_hd__decap_6
XFILLER_41_304 VGND VGND VPWR VPWR sky130_fd_sc_hd__decap_3
XFILLER_41_315 VGND VGND VPWR VPWR sky130_fd_sc_hd__decap_4
XTAP_TAPCELL_ROW_64_682 VGND VPWR sky130_fd_sc_hd__tapvpwrvgnd_1
XFILLER_5_205 VPWR VGND VPWR VGND sky130_ef_sc_hd__decap_12
XFILLER_5_249 VPWR VGND VPWR VGND sky130_ef_sc_hd__decap_12
XFILLER_76_289 VPWR VGND VPWR VGND sky130_ef_sc_hd__decap_12
XFILLER_36_109 VGND VGND VPWR VPWR sky130_fd_sc_hd__decap_4
XFILLER_64_429 VGND VGND VPWR VPWR sky130_fd_sc_hd__fill_2
XFILLER_17_367 VGND VGND VPWR VPWR sky130_fd_sc_hd__fill_2
XFILLER_55_73 VGND VGND VPWR VPWR sky130_fd_sc_hd__fill_1
XTAP_TAPCELL_ROW_27_384 VGND VPWR sky130_fd_sc_hd__tapvpwrvgnd_1
XTAP_TAPCELL_ROW_10_251 VGND VPWR sky130_fd_sc_hd__tapvpwrvgnd_1
X_2570_ _0371_ _0372_ _0512_ VGND VGND VPWR VPWR _0513_ sky130_fd_sc_hd__or3_1
X_3122_ _1012_ _1018_ _1020_ VGND VGND VPWR VPWR _1021_ sky130_fd_sc_hd__nor3_1
XTAP_TAPCELL_ROW_78_796 VGND VPWR sky130_fd_sc_hd__tapvpwrvgnd_1
X_3053_ mantisaresult\[21\] _0965_ net202 VGND VGND VPWR VPWR _0128_ sky130_fd_sc_hd__mux2_1
X_2004_ net4 net7 net6 net8 VGND VGND VPWR VPWR _1699_ sky130_fd_sc_hd__and4_1
XFILLER_23_337 VGND VGND VPWR VPWR sky130_fd_sc_hd__decap_4
XFILLER_23_359 VGND VGND VPWR VPWR sky130_fd_sc_hd__fill_1
X_3955_ clknet_leaf_6_clk _0078_ VGND VGND VPWR VPWR mantisaB0\[6\] sky130_fd_sc_hd__dfxtp_1
XTAP_TAPCELL_ROW_61_663 VGND VPWR sky130_fd_sc_hd__tapvpwrvgnd_1
X_2906_ _0842_ _0844_ net122 VGND VGND VPWR VPWR _0845_ sky130_fd_sc_hd__mux2_1
XFILLER_31_370 VPWR VGND VPWR VGND sky130_ef_sc_hd__decap_12
X_3886_ clknet_leaf_21_clk _0009_ VGND VGND VPWR VPWR net73 sky130_fd_sc_hd__dfxtp_1
X_2837_ _0777_ _0775_ net140 VGND VGND VPWR VPWR _0778_ sky130_fd_sc_hd__mux2_1
X_2768_ net141 _0709_ VGND VGND VPWR VPWR _0710_ sky130_fd_sc_hd__nor2_1
X_2699_ _0641_ VGND VGND VPWR VPWR _0642_ sky130_fd_sc_hd__inv_2
XFILLER_58_234 VPWR VGND VPWR VGND sky130_ef_sc_hd__decap_12
XFILLER_58_267 VGND VGND VPWR VPWR sky130_fd_sc_hd__decap_3
XFILLER_46_418 VGND VGND VPWR VPWR sky130_fd_sc_hd__fill_2
XFILLER_73_237 VGND VGND VPWR VPWR sky130_fd_sc_hd__decap_6
XFILLER_25_10 VGND VGND VPWR VPWR sky130_fd_sc_hd__fill_1
XFILLER_14_337 VPWR VGND VPWR VGND sky130_ef_sc_hd__decap_12
XFILLER_25_54 VGND VGND VPWR VPWR sky130_fd_sc_hd__fill_2
XFILLER_26_197 VGND VGND VPWR VPWR sky130_fd_sc_hd__decap_8
XFILLER_41_123 VPWR VGND VPWR VGND sky130_ef_sc_hd__decap_12
XTAP_TAPCELL_ROW_24_365 VGND VPWR sky130_fd_sc_hd__tapvpwrvgnd_1
XFILLER_41_97 VGND VGND VPWR VPWR sky130_fd_sc_hd__fill_2
XFILLER_37_429 VPWR VGND VPWR VGND sky130_ef_sc_hd__decap_12
XFILLER_66_50 VGND VGND VPWR VPWR sky130_fd_sc_hd__decap_8
XFILLER_66_94 VGND VGND VPWR VPWR sky130_fd_sc_hd__decap_3
XFILLER_60_421 VGND VGND VPWR VPWR sky130_fd_sc_hd__fill_2
X_3740_ _1535_ _1523_ net267 VGND VGND VPWR VPWR _1562_ sky130_fd_sc_hd__mux2_1
XFILLER_9_374 VGND VGND VPWR VPWR sky130_fd_sc_hd__fill_2
X_3671_ expmiddle\[6\] expmiddle\[5\] VGND VGND VPWR VPWR _1500_ sky130_fd_sc_hd__or2_1
X_2622_ _0383_ _0400_ _0476_ _0535_ VGND VGND VPWR VPWR _0565_ sky130_fd_sc_hd__or4_1
XFILLER_63_3 VGND VGND VPWR VPWR sky130_fd_sc_hd__decap_3
X_2553_ _0328_ _0366_ _0495_ _0494_ VGND VGND VPWR VPWR _0496_ sky130_fd_sc_hd__a31oi_2
X_2484_ _0370_ _0380_ _0413_ _0420_ VGND VGND VPWR VPWR _0427_ sky130_fd_sc_hd__and4bb_1
X_4154_ clknet_leaf_11_clk _0261_ VGND VGND VPWR VPWR mantisaBshift\[61\] sky130_fd_sc_hd__dfxtp_1
X_4085_ clknet_leaf_26_clk _0194_ VGND VGND VPWR VPWR expmiddlec\[1\] sky130_fd_sc_hd__dfxtp_1
X_3105_ net242 _1005_ _1676_ VGND VGND VPWR VPWR _1006_ sky130_fd_sc_hd__a21oi_1
XTAP_TAPCELL_ROW_66_700 VGND VPWR sky130_fd_sc_hd__tapvpwrvgnd_1
X_3036_ mantisaBshift\[16\] _0950_ net237 VGND VGND VPWR VPWR _0953_ sky130_fd_sc_hd__o21ai_1
XFILLER_55_237 VPWR VGND VPWR VGND sky130_ef_sc_hd__decap_12
XTAP_TAPCELL_ROW_38_479 VGND VPWR sky130_fd_sc_hd__tapvpwrvgnd_1
XFILLER_23_189 VGND VGND VPWR VPWR sky130_fd_sc_hd__fill_2
X_3938_ clknet_leaf_8_clk _0061_ VGND VGND VPWR VPWR mantisaA0\[12\] sky130_fd_sc_hd__dfxtp_1
X_3869_ clknet_leaf_8_clk net292 VGND VGND VPWR VPWR mantisaAshift\[54\] sky130_fd_sc_hd__dfxtp_1
XFILLER_78_307 VGND VGND VPWR VPWR sky130_fd_sc_hd__fill_1
XTAP_TAPCELL_ROW_29_402 VGND VPWR sky130_fd_sc_hd__tapvpwrvgnd_1
XFILLER_54_281 VPWR VGND VPWR VGND sky130_ef_sc_hd__decap_12
XFILLER_61_218 VGND VGND VPWR VPWR sky130_fd_sc_hd__decap_6
XTAP_TAPCELL_ROW_72_747 VGND VPWR sky130_fd_sc_hd__tapvpwrvgnd_1
XFILLER_14_123 VGND VGND VPWR VPWR sky130_fd_sc_hd__fill_1
Xinput17 mantisaA[0] VGND VGND VPWR VPWR net17 sky130_fd_sc_hd__buf_1
Xinput28 mantisaA[1] VGND VGND VPWR VPWR net28 sky130_fd_sc_hd__buf_1
XFILLER_10_373 VGND VGND VPWR VPWR sky130_fd_sc_hd__fill_2
Xinput39 mantisaA[9] VGND VGND VPWR VPWR net39 sky130_fd_sc_hd__buf_1
XFILLER_69_307 VPWR VGND VPWR VGND sky130_ef_sc_hd__decap_12
XFILLER_77_373 VPWR VGND VPWR VGND sky130_ef_sc_hd__decap_12
XFILLER_77_93 VGND VGND VPWR VPWR sky130_fd_sc_hd__fill_2
XFILLER_33_432 VGND VGND VPWR VPWR sky130_fd_sc_hd__decap_8
XTAP_TAPCELL_ROW_35_449 VGND VPWR sky130_fd_sc_hd__tapvpwrvgnd_1
XFILLER_45_292 VGND VGND VPWR VPWR sky130_fd_sc_hd__fill_1
XFILLER_20_137 VGND VGND VPWR VPWR sky130_fd_sc_hd__decap_3
X_1984_ mantisaBshift\[39\] VGND VGND VPWR VPWR _1679_ sky130_fd_sc_hd__inv_2
X_3723_ net266 _1494_ VGND VGND VPWR VPWR _1547_ sky130_fd_sc_hd__or2_1
XFILLER_9_193 VPWR VGND VPWR VGND sky130_ef_sc_hd__decap_12
X_3654_ _1481_ _1483_ net271 VGND VGND VPWR VPWR _1484_ sky130_fd_sc_hd__mux2_1
X_2605_ _0298_ _0299_ _0337_ _0338_ VGND VGND VPWR VPWR _0548_ sky130_fd_sc_hd__or4_1
X_3585_ mantisaresult\[62\] net164 _0701_ mantisaresult\[61\] _1416_ VGND VGND VPWR
+ VPWR _1417_ sky130_fd_sc_hd__a221o_1
X_2536_ mantisaresult\[29\] _0349_ _0351_ _0477_ _0478_ VGND VGND VPWR VPWR _0479_
+ sky130_fd_sc_hd__a311o_1
X_2467_ _0315_ _0317_ _0321_ _0409_ VGND VGND VPWR VPWR _0410_ sky130_fd_sc_hd__or4_1
X_2398_ net218 net219 mantisaresult\[51\] mantisaresult\[50\] VGND VGND VPWR VPWR
+ _0341_ sky130_fd_sc_hd__or4_1
X_4137_ clknet_leaf_12_clk _0244_ VGND VGND VPWR VPWR mantisaBshift\[40\] sky130_fd_sc_hd__dfxtp_1
X_4068_ clknet_leaf_20_clk _0177_ VGND VGND VPWR VPWR expmiddled\[1\] sky130_fd_sc_hd__dfxtp_1
X_3019_ net125 _0922_ VGND VGND VPWR VPWR _0940_ sky130_fd_sc_hd__nor2_1
XFILLER_22_55 VGND VGND VPWR VPWR sky130_fd_sc_hd__decap_4
XFILLER_3_314 VGND VGND VPWR VPWR sky130_fd_sc_hd__decap_4
XFILLER_78_104 VPWR VGND VPWR VGND sky130_ef_sc_hd__decap_12
Xfanout150 _0603_ VGND VGND VPWR VPWR net150 sky130_fd_sc_hd__buf_4
Xfanout172 net175 VGND VGND VPWR VPWR net172 sky130_fd_sc_hd__clkbuf_4
XFILLER_59_351 VGND VGND VPWR VPWR sky130_fd_sc_hd__fill_1
Xfanout161 net162 VGND VGND VPWR VPWR net161 sky130_fd_sc_hd__buf_1
Xfanout194 net200 VGND VGND VPWR VPWR net194 sky130_fd_sc_hd__buf_2
XFILLER_74_321 VPWR VGND VPWR VGND sky130_ef_sc_hd__decap_12
XFILLER_74_365 VPWR VGND VPWR VGND sky130_ef_sc_hd__decap_12
XFILLER_27_281 VGND VGND VPWR VPWR sky130_fd_sc_hd__decap_3
XFILLER_42_295 VGND VGND VPWR VPWR sky130_fd_sc_hd__decap_6
XFILLER_8_46 VGND VGND VPWR VPWR sky130_fd_sc_hd__decap_6
XFILLER_6_141 VGND VGND VPWR VPWR sky130_fd_sc_hd__fill_1
X_3370_ mantisaAshift\[56\] _1683_ _1232_ _1241_ VGND VGND VPWR VPWR _1242_ sky130_fd_sc_hd__a31o_1
X_2321_ _0277_ net381 net173 VGND VGND VPWR VPWR _0084_ sky130_fd_sc_hd__mux2_1
X_2252_ net38 _1889_ net104 VGND VGND VPWR VPWR _1890_ sky130_fd_sc_hd__mux2_1
X_2183_ _1841_ _1842_ VGND VGND VPWR VPWR _1843_ sky130_fd_sc_hd__nor2_1
XTAP_TAPCELL_ROW_48_552 VGND VPWR sky130_fd_sc_hd__tapvpwrvgnd_1
X_3706_ net271 _1465_ VGND VGND VPWR VPWR _1532_ sky130_fd_sc_hd__and2_1
X_1967_ net60 VGND VGND VPWR VPWR _1662_ sky130_fd_sc_hd__inv_2
X_3637_ _1465_ _1466_ net271 VGND VGND VPWR VPWR _1467_ sky130_fd_sc_hd__mux2_1
X_3568_ mantisaresult\[59\] net114 net109 mantisaresult\[60\] net137 VGND VGND VPWR
+ VPWR _1401_ sky130_fd_sc_hd__a221o_1
X_2519_ _0292_ _0361_ _0439_ _0440_ _0461_ VGND VGND VPWR VPWR _0462_ sky130_fd_sc_hd__o41a_1
X_3499_ net146 _1185_ _1337_ _0926_ VGND VGND VPWR VPWR _1338_ sky130_fd_sc_hd__a211o_1
XFILLER_75_129 VGND VGND VPWR VPWR sky130_fd_sc_hd__fill_1
XFILLER_56_343 VGND VGND VPWR VPWR sky130_fd_sc_hd__fill_1
XFILLER_56_365 VGND VGND VPWR VPWR sky130_fd_sc_hd__fill_1
XFILLER_17_55 VGND VGND VPWR VPWR sky130_fd_sc_hd__fill_1
XTAP_TAPCELL_ROW_3_199 VGND VPWR sky130_fd_sc_hd__tapvpwrvgnd_1
XFILLER_71_335 VGND VGND VPWR VPWR sky130_fd_sc_hd__fill_1
XFILLER_24_251 VGND VGND VPWR VPWR sky130_fd_sc_hd__fill_1
XFILLER_24_284 VPWR VGND VPWR VGND sky130_ef_sc_hd__decap_12
XFILLER_12_457 VPWR VGND VPWR VGND sky130_ef_sc_hd__decap_12
XFILLER_3_111 VGND VGND VPWR VPWR sky130_fd_sc_hd__fill_1
Xhold6 mantisaA0\[14\] VGND VGND VPWR VPWR net280 sky130_fd_sc_hd__dlygate4sd3_1
XFILLER_12_9 VGND VGND VPWR VPWR sky130_fd_sc_hd__decap_3
XFILLER_66_129 VGND VGND VPWR VPWR sky130_fd_sc_hd__decap_8
XFILLER_47_365 VPWR VGND VPWR VGND sky130_ef_sc_hd__decap_12
XFILLER_74_173 VGND VGND VPWR VPWR sky130_fd_sc_hd__fill_2
XTAP_TAPCELL_ROW_45_533 VGND VPWR sky130_fd_sc_hd__tapvpwrvgnd_1
XFILLER_74_195 VGND VGND VPWR VPWR sky130_fd_sc_hd__fill_1
X_2870_ net226 net156 net135 VGND VGND VPWR VPWR _0810_ sky130_fd_sc_hd__and3_1
Xclkbuf_leaf_10_clk clknet_2_1__leaf_clk VGND VGND VPWR VPWR clknet_leaf_10_clk sky130_fd_sc_hd__clkbuf_8
XFILLER_7_461 VGND VGND VPWR VPWR sky130_fd_sc_hd__decap_8
X_3422_ _1285_ _1287_ _1288_ net204 mantisaresult\[63\] VGND VGND VPWR VPWR _0174_
+ sky130_fd_sc_hd__o32a_1
X_3353_ _1208_ _1211_ _1209_ VGND VGND VPWR VPWR _1227_ sky130_fd_sc_hd__o21a_1
X_3284_ _1161_ _1162_ VGND VGND VPWR VPWR _1163_ sky130_fd_sc_hd__nand2b_1
X_2304_ _1881_ net34 net105 VGND VGND VPWR VPWR _1923_ sky130_fd_sc_hd__mux2_1
X_2235_ _1878_ net304 net172 VGND VGND VPWR VPWR _0051_ sky130_fd_sc_hd__mux2_1
X_2166_ _1821_ _1822_ _1823_ _1819_ _1818_ VGND VGND VPWR VPWR _1827_ sky130_fd_sc_hd__a32o_1
XFILLER_38_365 VPWR VGND VPWR VGND sky130_ef_sc_hd__decap_12
XFILLER_65_151 VGND VGND VPWR VPWR sky130_fd_sc_hd__decap_8
X_2097_ net177 VGND VGND VPWR VPWR _1759_ sky130_fd_sc_hd__inv_2
XTAP_TAPCELL_ROW_0_169 VGND VPWR sky130_fd_sc_hd__tapvpwrvgnd_1
XFILLER_65_184 VGND VGND VPWR VPWR sky130_fd_sc_hd__decap_8
XFILLER_21_221 VGND VGND VPWR VPWR sky130_fd_sc_hd__decap_3
XPHY_EDGE_ROW_3_Right_3 VGND VGND VPWR VPWR sky130_fd_sc_hd__decap_3
X_2999_ _0816_ _0801_ net142 VGND VGND VPWR VPWR _0920_ sky130_fd_sc_hd__mux2_1
XTAP_TAPCELL_ROW_8_236 VGND VPWR sky130_fd_sc_hd__tapvpwrvgnd_1
XFILLER_0_125 VPWR VGND VPWR VGND sky130_ef_sc_hd__decap_12
XFILLER_0_169 VPWR VGND VPWR VGND sky130_ef_sc_hd__decap_12
XTAP_TAPCELL_ROW_59_647 VGND VPWR sky130_fd_sc_hd__tapvpwrvgnd_1
XFILLER_28_43 VGND VGND VPWR VPWR sky130_fd_sc_hd__decap_4
XFILLER_28_65 VGND VGND VPWR VPWR sky130_fd_sc_hd__decap_3
XFILLER_28_98 VGND VGND VPWR VPWR sky130_fd_sc_hd__fill_1
XFILLER_29_376 VPWR VGND VPWR VGND sky130_ef_sc_hd__decap_12
XFILLER_56_151 VGND VGND VPWR VPWR sky130_fd_sc_hd__decap_4
XFILLER_44_324 VGND VGND VPWR VPWR sky130_fd_sc_hd__decap_8
XFILLER_56_195 VGND VGND VPWR VPWR sky130_fd_sc_hd__fill_1
XFILLER_71_121 VGND VGND VPWR VPWR sky130_fd_sc_hd__decap_3
XFILLER_71_165 VGND VGND VPWR VPWR sky130_fd_sc_hd__decap_3
XFILLER_12_265 VPWR VGND VPWR VGND sky130_ef_sc_hd__decap_12
XFILLER_8_269 VGND VGND VPWR VPWR sky130_fd_sc_hd__fill_1
XFILLER_60_85 VGND VGND VPWR VPWR sky130_fd_sc_hd__fill_2
XFILLER_5_69 VPWR VGND VPWR VGND sky130_ef_sc_hd__decap_12
XFILLER_79_221 VGND VGND VPWR VPWR sky130_fd_sc_hd__decap_3
XFILLER_79_265 VPWR VGND VPWR VGND sky130_ef_sc_hd__decap_12
XFILLER_39_118 VGND VGND VPWR VPWR sky130_fd_sc_hd__fill_2
X_2020_ _1714_ VGND VGND VPWR VPWR _1715_ sky130_fd_sc_hd__inv_2
XFILLER_35_346 VPWR VGND VPWR VGND sky130_ef_sc_hd__decap_12
X_3971_ clknet_leaf_29_clk _0094_ VGND VGND VPWR VPWR mantisaB0\[22\] sky130_fd_sc_hd__dfxtp_1
X_2922_ _0714_ _0709_ net141 VGND VGND VPWR VPWR _0860_ sky130_fd_sc_hd__mux2_1
X_2853_ net158 _0773_ _0787_ _0793_ VGND VGND VPWR VPWR _0794_ sky130_fd_sc_hd__and4_1
X_2784_ mantisaresult\[27\] net112 net108 mantisaresult\[28\] VGND VGND VPWR VPWR
+ _0726_ sky130_fd_sc_hd__a22o_1
X_3405_ _1268_ _1273_ VGND VGND VPWR VPWR _1274_ sky130_fd_sc_hd__xor2_1
X_3336_ _1196_ _1205_ _1197_ VGND VGND VPWR VPWR _1211_ sky130_fd_sc_hd__o21a_1
X_3267_ mantisaAshift\[49\] _1680_ _1147_ mantisaAshift\[48\] VGND VGND VPWR VPWR
+ _1148_ sky130_fd_sc_hd__a22o_1
X_2218_ net308 net178 _1867_ VGND VGND VPWR VPWR _0045_ sky130_fd_sc_hd__o21a_1
X_3198_ _1081_ _1084_ _1085_ net159 VGND VGND VPWR VPWR _1086_ sky130_fd_sc_hd__o31a_1
XFILLER_38_162 VPWR VGND VPWR VGND sky130_ef_sc_hd__decap_12
XTAP_TAPCELL_ROW_56_617 VGND VPWR sky130_fd_sc_hd__tapvpwrvgnd_1
XFILLER_38_195 VGND VGND VPWR VPWR sky130_fd_sc_hd__fill_1
XFILLER_53_110 VGND VGND VPWR VPWR sky130_fd_sc_hd__fill_2
X_2149_ net23 _1670_ _1671_ net22 VGND VGND VPWR VPWR _1810_ sky130_fd_sc_hd__o22a_1
XTAP_TAPCELL_ROW_64_683 VGND VPWR sky130_fd_sc_hd__tapvpwrvgnd_1
XPHY_EDGE_ROW_12_Left_92 VGND VGND VPWR VPWR sky130_fd_sc_hd__decap_3
XFILLER_5_217 VGND VGND VPWR VPWR sky130_fd_sc_hd__decap_6
XFILLER_49_427 VGND VGND VPWR VPWR sky130_fd_sc_hd__decap_6
XFILLER_39_97 VGND VGND VPWR VPWR sky130_fd_sc_hd__fill_1
XFILLER_64_419 VGND VGND VPWR VPWR sky130_fd_sc_hd__fill_1
XFILLER_29_195 VGND VGND VPWR VPWR sky130_fd_sc_hd__fill_1
XTAP_TAPCELL_ROW_27_385 VGND VPWR sky130_fd_sc_hd__tapvpwrvgnd_1
XTAP_TAPCELL_ROW_10_252 VGND VPWR sky130_fd_sc_hd__tapvpwrvgnd_1
XFILLER_58_6 VGND VGND VPWR VPWR sky130_fd_sc_hd__decap_3
XFILLER_4_294 VGND VGND VPWR VPWR sky130_fd_sc_hd__decap_3
X_3121_ net129 _0720_ _0921_ _1019_ VGND VGND VPWR VPWR _1020_ sky130_fd_sc_hd__a31o_1
XTAP_TAPCELL_ROW_78_797 VGND VPWR sky130_fd_sc_hd__tapvpwrvgnd_1
X_3052_ mantisaBshift\[21\] _0964_ VGND VGND VPWR VPWR _0965_ sky130_fd_sc_hd__xnor2_1
X_2003_ _1697_ VGND VGND VPWR VPWR _1698_ sky130_fd_sc_hd__inv_2
XFILLER_63_430 VGND VGND VPWR VPWR sky130_fd_sc_hd__fill_1
XFILLER_35_165 VGND VGND VPWR VPWR sky130_fd_sc_hd__decap_3
X_3954_ clknet_leaf_6_clk _0077_ VGND VGND VPWR VPWR mantisaB0\[5\] sky130_fd_sc_hd__dfxtp_1
X_3885_ clknet_leaf_21_clk _0008_ VGND VGND VPWR VPWR net72 sky130_fd_sc_hd__dfxtp_1
X_2905_ net140 _0696_ _0843_ VGND VGND VPWR VPWR _0844_ sky130_fd_sc_hd__a21oi_1
XFILLER_31_382 VGND VGND VPWR VPWR sky130_fd_sc_hd__decap_8
XFILLER_31_393 VGND VGND VPWR VPWR sky130_fd_sc_hd__decap_4
X_2836_ net117 _0652_ _0776_ VGND VGND VPWR VPWR _0777_ sky130_fd_sc_hd__a21oi_1
X_2767_ _0707_ _0708_ net116 VGND VGND VPWR VPWR _0709_ sky130_fd_sc_hd__mux2_1
XFILLER_2_209 VPWR VGND VPWR VGND sky130_ef_sc_hd__decap_12
X_2698_ mantisaresult\[29\] net154 VGND VGND VPWR VPWR _0641_ sky130_fd_sc_hd__nand2_1
XFILLER_76_29 VGND VGND VPWR VPWR sky130_fd_sc_hd__fill_2
XTAP_TAPCELL_ROW_69_720 VGND VPWR sky130_fd_sc_hd__tapvpwrvgnd_1
XFILLER_58_246 VGND VGND VPWR VPWR sky130_fd_sc_hd__decap_6
X_3319_ net324 net206 _1193_ _1195_ VGND VGND VPWR VPWR _0164_ sky130_fd_sc_hd__o22a_1
XFILLER_41_135 VPWR VGND VPWR VGND sky130_ef_sc_hd__decap_12
XTAP_TAPCELL_ROW_24_366 VGND VPWR sky130_fd_sc_hd__tapvpwrvgnd_1
XFILLER_41_21 VGND VGND VPWR VPWR sky130_fd_sc_hd__decap_4
XFILLER_2_15 VPWR VGND VPWR VGND sky130_ef_sc_hd__decap_12
XFILLER_49_202 VGND VGND VPWR VPWR sky130_fd_sc_hd__decap_4
XFILLER_17_110 VGND VGND VPWR VPWR sky130_fd_sc_hd__fill_2
XFILLER_60_411 VGND VGND VPWR VPWR sky130_fd_sc_hd__decap_8
XFILLER_32_135 VGND VGND VPWR VPWR sky130_fd_sc_hd__fill_2
XFILLER_60_444 VGND VGND VPWR VPWR sky130_fd_sc_hd__fill_1
XFILLER_13_393 VPWR VGND VPWR VGND sky130_ef_sc_hd__decap_12
X_3670_ expmiddle\[6\] expmiddle\[5\] VGND VGND VPWR VPWR _1499_ sky130_fd_sc_hd__nor2_1
X_2621_ _1635_ _0361_ _0556_ _0562_ _0563_ VGND VGND VPWR VPWR _0564_ sky130_fd_sc_hd__o2111ai_1
X_2552_ _1633_ _0433_ _0449_ VGND VGND VPWR VPWR _0495_ sky130_fd_sc_hd__nor3_1
X_2483_ _0368_ _0369_ _0422_ _0425_ VGND VGND VPWR VPWR _0426_ sky130_fd_sc_hd__nand4_1
X_4153_ clknet_leaf_11_clk _0260_ VGND VGND VPWR VPWR mantisaBshift\[62\] sky130_fd_sc_hd__dfxtp_1
X_4084_ clknet_leaf_25_clk _0193_ VGND VGND VPWR VPWR expmiddlec\[0\] sky130_fd_sc_hd__dfxtp_1
XFILLER_28_419 VGND VGND VPWR VPWR sky130_fd_sc_hd__fill_1
X_3104_ mantisaBshift\[29\] mantisaBshift\[30\] mantisaBshift\[31\] _0997_ VGND VGND
+ VPWR VPWR _1005_ sky130_fd_sc_hd__or4_4
XTAP_TAPCELL_ROW_66_701 VGND VPWR sky130_fd_sc_hd__tapvpwrvgnd_1
X_3035_ _0951_ _0952_ mantisaresult\[16\] net234 VGND VGND VPWR VPWR _0123_ sky130_fd_sc_hd__a2bb2o_1
XFILLER_55_249 VPWR VGND VPWR VGND sky130_ef_sc_hd__decap_12
XFILLER_23_113 VGND VGND VPWR VPWR sky130_fd_sc_hd__fill_2
XFILLER_51_422 VGND VGND VPWR VPWR sky130_fd_sc_hd__decap_6
XFILLER_51_455 VGND VGND VPWR VPWR sky130_fd_sc_hd__fill_2
X_3937_ clknet_leaf_8_clk _0060_ VGND VGND VPWR VPWR mantisaA0\[11\] sky130_fd_sc_hd__dfxtp_1
XTAP_TAPCELL_ROW_21_336 VGND VPWR sky130_fd_sc_hd__tapvpwrvgnd_1
X_3868_ clknet_leaf_8_clk net280 VGND VGND VPWR VPWR mantisaAshift\[53\] sky130_fd_sc_hd__dfxtp_1
XFILLER_11_13 VGND VGND VPWR VPWR sky130_fd_sc_hd__fill_1
X_3799_ net255 net186 _1597_ _1596_ _1502_ VGND VGND VPWR VPWR _1606_ sky130_fd_sc_hd__o32a_1
X_2819_ net226 net200 net163 VGND VGND VPWR VPWR _0761_ sky130_fd_sc_hd__a21o_1
XTAP_TAPCELL_ROW_29_403 VGND VPWR sky130_fd_sc_hd__tapvpwrvgnd_1
XFILLER_27_430 VGND VGND VPWR VPWR sky130_fd_sc_hd__decap_8
XFILLER_61_208 VGND VGND VPWR VPWR sky130_fd_sc_hd__fill_2
XFILLER_54_271 VGND VGND VPWR VPWR sky130_fd_sc_hd__decap_4
XFILLER_54_293 VGND VGND VPWR VPWR sky130_fd_sc_hd__decap_8
XTAP_TAPCELL_ROW_72_748 VGND VPWR sky130_fd_sc_hd__tapvpwrvgnd_1
XFILLER_52_53 VGND VGND VPWR VPWR sky130_fd_sc_hd__fill_1
Xinput18 mantisaA[10] VGND VGND VPWR VPWR net18 sky130_fd_sc_hd__dlymetal6s2s_1
Xinput29 mantisaA[20] VGND VGND VPWR VPWR net29 sky130_fd_sc_hd__buf_1
XFILLER_69_319 VPWR VGND VPWR VGND sky130_ef_sc_hd__decap_12
XFILLER_77_385 VGND VGND VPWR VPWR sky130_fd_sc_hd__decap_6
XFILLER_18_430 VPWR VGND VPWR VGND sky130_ef_sc_hd__decap_12
XFILLER_45_260 VGND VGND VPWR VPWR sky130_fd_sc_hd__fill_2
XFILLER_60_230 VGND VGND VPWR VPWR sky130_fd_sc_hd__decap_6
X_1983_ mantisaAshift\[39\] VGND VGND VPWR VPWR _1678_ sky130_fd_sc_hd__inv_2
X_3722_ _1472_ _1478_ _1484_ _1490_ net266 net262 VGND VGND VPWR VPWR _1546_ sky130_fd_sc_hd__mux4_1
X_3653_ mantisaB0\[16\] net185 _1482_ VGND VGND VPWR VPWR _1483_ sky130_fd_sc_hd__a21boi_1
X_2604_ _0303_ _0314_ _0334_ _0546_ VGND VGND VPWR VPWR _0547_ sky130_fd_sc_hd__or4_1
X_3584_ _1410_ _1415_ net157 VGND VGND VPWR VPWR _1416_ sky130_fd_sc_hd__o21a_1
X_2535_ _0293_ mantisaresult\[29\] mantisaresult\[28\] net183 VGND VGND VPWR VPWR
+ _0478_ sky130_fd_sc_hd__and4bb_1
X_2466_ mantisaresult\[35\] net229 mantisaresult\[33\] VGND VGND VPWR VPWR _0409_
+ sky130_fd_sc_hd__or3_1
X_4136_ clknet_leaf_3_clk _0243_ VGND VGND VPWR VPWR mantisaBshift\[41\] sky130_fd_sc_hd__dfxtp_1
X_2397_ _0334_ _0337_ VGND VGND VPWR VPWR _0340_ sky130_fd_sc_hd__or2_1
X_4067_ clknet_leaf_20_clk _0176_ VGND VGND VPWR VPWR expmiddled\[0\] sky130_fd_sc_hd__dfxtp_1
X_3018_ _0820_ _0817_ net142 VGND VGND VPWR VPWR _0939_ sky130_fd_sc_hd__mux2_1
XFILLER_11_105 VGND VGND VPWR VPWR sky130_fd_sc_hd__fill_1
XFILLER_51_252 VGND VGND VPWR VPWR sky130_fd_sc_hd__fill_1
XFILLER_22_67 VGND VGND VPWR VPWR sky130_fd_sc_hd__fill_1
XFILLER_3_348 VGND VGND VPWR VPWR sky130_fd_sc_hd__decap_3
XFILLER_78_116 VPWR VGND VPWR VGND sky130_ef_sc_hd__decap_12
Xfanout140 net148 VGND VGND VPWR VPWR net140 sky130_fd_sc_hd__buf_2
Xfanout173 net175 VGND VGND VPWR VPWR net173 sky130_fd_sc_hd__clkbuf_4
XFILLER_19_205 VGND VGND VPWR VPWR sky130_fd_sc_hd__decap_3
Xfanout151 _0602_ VGND VGND VPWR VPWR net151 sky130_fd_sc_hd__clkbuf_4
Xfanout162 net163 VGND VGND VPWR VPWR net162 sky130_fd_sc_hd__dlymetal6s2s_1
Xfanout184 _1501_ VGND VGND VPWR VPWR net184 sky130_fd_sc_hd__buf_2
XFILLER_47_64 VGND VGND VPWR VPWR sky130_fd_sc_hd__fill_1
Xfanout195 net196 VGND VGND VPWR VPWR net195 sky130_fd_sc_hd__clkbuf_2
XFILLER_74_333 VPWR VGND VPWR VGND sky130_ef_sc_hd__decap_12
XFILLER_47_97 VGND VGND VPWR VPWR sky130_fd_sc_hd__fill_1
XFILLER_74_377 VPWR VGND VPWR VGND sky130_ef_sc_hd__decap_12
XFILLER_63_52 VGND VGND VPWR VPWR sky130_fd_sc_hd__decap_4
XFILLER_8_36 VGND VGND VPWR VPWR sky130_fd_sc_hd__decap_4
XFILLER_6_197 VPWR VGND VPWR VGND sky130_ef_sc_hd__decap_12
X_2320_ _1897_ net20 net103 VGND VGND VPWR VPWR _0277_ sky130_fd_sc_hd__mux2_1
XPHY_EDGE_ROW_0_Left_80 VGND VGND VPWR VPWR sky130_fd_sc_hd__decap_3
X_2251_ net61 net169 VGND VGND VPWR VPWR _1889_ sky130_fd_sc_hd__and2_1
X_2182_ _1777_ _1779_ _1787_ VGND VGND VPWR VPWR _1842_ sky130_fd_sc_hd__and3_1
XTAP_TAPCELL_ROW_48_553 VGND VPWR sky130_fd_sc_hd__tapvpwrvgnd_1
XFILLER_18_282 VGND VGND VPWR VPWR sky130_fd_sc_hd__fill_1
XTAP_TAPCELL_ROW_31_420 VGND VPWR sky130_fd_sc_hd__tapvpwrvgnd_1
X_1966_ net57 VGND VGND VPWR VPWR _1661_ sky130_fd_sc_hd__inv_2
X_3705_ _1527_ _1530_ net259 VGND VGND VPWR VPWR _1531_ sky130_fd_sc_hd__mux2_1
X_3636_ _1686_ _1425_ net185 mantisaB0\[4\] VGND VGND VPWR VPWR _1466_ sky130_fd_sc_hd__a22o_1
X_3567_ net128 _0852_ VGND VGND VPWR VPWR _1400_ sky130_fd_sc_hd__nand2_1
X_2518_ _1627_ _0431_ _0435_ _0437_ VGND VGND VPWR VPWR _0461_ sky130_fd_sc_hd__or4_1
XFILLER_0_329 VGND VGND VPWR VPWR sky130_fd_sc_hd__decap_3
X_3498_ net146 _1336_ VGND VGND VPWR VPWR _1337_ sky130_fd_sc_hd__and2b_1
X_2449_ mantisaresult\[55\] mantisaresult\[54\] net218 _0300_ _0301_ VGND VGND VPWR
+ VPWR _0392_ sky130_fd_sc_hd__o311a_1
X_4119_ clknet_leaf_26_clk _0226_ VGND VGND VPWR VPWR mantisaBshift\[3\] sky130_fd_sc_hd__dfxtp_1
XFILLER_12_469 VGND VGND VPWR VPWR sky130_fd_sc_hd__decap_4
XFILLER_8_418 VGND VGND VPWR VPWR sky130_fd_sc_hd__fill_2
XFILLER_33_44 VGND VGND VPWR VPWR sky130_fd_sc_hd__decap_6
XFILLER_3_167 VGND VGND VPWR VPWR sky130_fd_sc_hd__fill_1
Xhold7 mantisaA0\[0\] VGND VGND VPWR VPWR net281 sky130_fd_sc_hd__dlygate4sd3_1
XFILLER_58_85 VPWR VGND VPWR VGND sky130_ef_sc_hd__decap_12
XFILLER_47_377 VGND VGND VPWR VPWR sky130_fd_sc_hd__fill_2
XFILLER_62_314 VGND VGND VPWR VPWR sky130_fd_sc_hd__decap_3
XTAP_TAPCELL_ROW_45_534 VGND VPWR sky130_fd_sc_hd__tapvpwrvgnd_1
XFILLER_62_347 VGND VGND VPWR VPWR sky130_fd_sc_hd__decap_6
XFILLER_15_241 VPWR VGND VPWR VGND sky130_ef_sc_hd__decap_12
XFILLER_15_296 VGND VGND VPWR VPWR sky130_fd_sc_hd__fill_1
XFILLER_15_263 VPWR VGND VPWR VGND sky130_ef_sc_hd__decap_12
X_3421_ _1268_ _1270_ _1277_ net236 VGND VGND VPWR VPWR _1288_ sky130_fd_sc_hd__a31o_1
X_3352_ net246 _1225_ VGND VGND VPWR VPWR _1226_ sky130_fd_sc_hd__nand2_1
X_2303_ _1922_ net344 net172 VGND VGND VPWR VPWR _0075_ sky130_fd_sc_hd__mux2_1
X_3283_ mantisaAshift\[52\] mantisaBshift\[52\] VGND VGND VPWR VPWR _1162_ sky130_fd_sc_hd__or2_1
X_2234_ net32 _1877_ net102 VGND VGND VPWR VPWR _1878_ sky130_fd_sc_hd__mux2_1
X_2165_ _1817_ _1823_ _1825_ VGND VGND VPWR VPWR _1826_ sky130_fd_sc_hd__and3b_1
XFILLER_38_377 VGND VGND VPWR VPWR sky130_fd_sc_hd__decap_4
X_2096_ _1701_ _1714_ VGND VGND VPWR VPWR _1758_ sky130_fd_sc_hd__xor2_2
XFILLER_61_391 VGND VGND VPWR VPWR sky130_fd_sc_hd__fill_1
X_2998_ _0918_ _0919_ mantisaresult\[13\] net230 VGND VGND VPWR VPWR _0119_ sky130_fd_sc_hd__a2bb2o_1
X_1949_ net223 VGND VGND VPWR VPWR _1644_ sky130_fd_sc_hd__inv_2
XFILLER_79_29 VGND VGND VPWR VPWR sky130_fd_sc_hd__decap_8
X_3619_ _1447_ _1449_ net270 VGND VGND VPWR VPWR _1450_ sky130_fd_sc_hd__mux2_1
XTAP_TAPCELL_ROW_8_237 VGND VPWR sky130_fd_sc_hd__tapvpwrvgnd_1
XFILLER_0_137 VGND VGND VPWR VPWR sky130_fd_sc_hd__decap_3
XFILLER_29_388 VGND VGND VPWR VPWR sky130_fd_sc_hd__decap_4
XFILLER_56_141 VGND VGND VPWR VPWR sky130_fd_sc_hd__fill_1
XFILLER_71_133 VGND VGND VPWR VPWR sky130_fd_sc_hd__fill_1
XTAP_TAPCELL_ROW_42_504 VGND VPWR sky130_fd_sc_hd__tapvpwrvgnd_1
XFILLER_12_277 VGND VGND VPWR VPWR sky130_fd_sc_hd__fill_2
XTAP_TAPCELL_ROW_50_570 VGND VPWR sky130_fd_sc_hd__tapvpwrvgnd_1
XFILLER_4_421 VPWR VGND VPWR VGND sky130_ef_sc_hd__decap_12
XFILLER_79_277 VGND VGND VPWR VPWR sky130_fd_sc_hd__decap_3
XPHY_EDGE_ROW_13_Right_13 VGND VGND VPWR VPWR sky130_fd_sc_hd__decap_3
XFILLER_75_461 VPWR VGND VPWR VGND sky130_ef_sc_hd__decap_12
XFILLER_62_122 VGND VGND VPWR VPWR sky130_fd_sc_hd__fill_1
X_3970_ clknet_leaf_0_clk _0093_ VGND VGND VPWR VPWR mantisaB0\[21\] sky130_fd_sc_hd__dfxtp_1
X_2921_ _0854_ _0858_ net124 VGND VGND VPWR VPWR _0859_ sky130_fd_sc_hd__mux2_1
X_2852_ _0744_ _0790_ _0792_ _0757_ VGND VGND VPWR VPWR _0793_ sky130_fd_sc_hd__o22a_1
XTAP_TAPCELL_ROW_13_272 VGND VPWR sky130_fd_sc_hd__tapvpwrvgnd_1
XPHY_EDGE_ROW_22_Right_22 VGND VGND VPWR VPWR sky130_fd_sc_hd__decap_3
X_2783_ _0724_ VGND VGND VPWR VPWR _0725_ sky130_fd_sc_hd__inv_2
X_3404_ net247 _1271_ _1272_ _1270_ VGND VGND VPWR VPWR _1273_ sky130_fd_sc_hd__a31o_1
X_3335_ _1208_ _1209_ VGND VGND VPWR VPWR _1210_ sky130_fd_sc_hd__nand2b_1
XPHY_EDGE_ROW_31_Right_31 VGND VGND VPWR VPWR sky130_fd_sc_hd__decap_3
XFILLER_58_439 VGND VGND VPWR VPWR sky130_fd_sc_hd__decap_4
X_3266_ mantisaBshift\[48\] _1135_ VGND VGND VPWR VPWR _1147_ sky130_fd_sc_hd__nor2_1
X_2217_ net5 net13 net98 VGND VGND VPWR VPWR _1867_ sky130_fd_sc_hd__mux2_1
X_3197_ net149 _0770_ _0936_ _1082_ VGND VGND VPWR VPWR _1085_ sky130_fd_sc_hd__a31o_1
XFILLER_38_141 VGND VGND VPWR VPWR sky130_fd_sc_hd__fill_1
XTAP_TAPCELL_ROW_56_618 VGND VPWR sky130_fd_sc_hd__tapvpwrvgnd_1
XFILLER_26_314 VGND VGND VPWR VPWR sky130_fd_sc_hd__fill_2
XFILLER_38_174 VGND VGND VPWR VPWR sky130_fd_sc_hd__fill_1
X_2148_ net21 _1668_ _1669_ net20 VGND VGND VPWR VPWR _1809_ sky130_fd_sc_hd__o22a_1
X_2079_ net209 net335 VGND VGND VPWR VPWR _0019_ sky130_fd_sc_hd__and2b_1
XTAP_TAPCELL_ROW_64_684 VGND VPWR sky130_fd_sc_hd__tapvpwrvgnd_1
XPHY_EDGE_ROW_40_Right_40 VGND VGND VPWR VPWR sky130_fd_sc_hd__decap_3
XFILLER_57_472 VGND VGND VPWR VPWR sky130_fd_sc_hd__fill_1
XFILLER_17_347 VPWR VGND VPWR VGND sky130_ef_sc_hd__decap_12
XTAP_TAPCELL_ROW_27_386 VGND VPWR sky130_fd_sc_hd__tapvpwrvgnd_1
XFILLER_44_166 VGND VGND VPWR VPWR sky130_fd_sc_hd__decap_4
XFILLER_71_74 VGND VGND VPWR VPWR sky130_fd_sc_hd__fill_2
XTAP_TAPCELL_ROW_10_253 VGND VPWR sky130_fd_sc_hd__tapvpwrvgnd_1
XFILLER_4_251 VGND VGND VPWR VPWR sky130_fd_sc_hd__fill_1
X_3120_ _0732_ _0938_ net159 VGND VGND VPWR VPWR _1019_ sky130_fd_sc_hd__a21bo_1
X_3051_ mantisaBshift\[20\] _0961_ net240 VGND VGND VPWR VPWR _0964_ sky130_fd_sc_hd__o21ai_1
XTAP_TAPCELL_ROW_78_798 VGND VPWR sky130_fd_sc_hd__tapvpwrvgnd_1
X_2002_ _1696_ _1655_ _1654_ _1653_ VGND VGND VPWR VPWR _1697_ sky130_fd_sc_hd__and4b_1
XFILLER_23_328 VGND VGND VPWR VPWR sky130_fd_sc_hd__fill_1
XFILLER_50_147 VGND VGND VPWR VPWR sky130_fd_sc_hd__decap_3
X_3953_ clknet_leaf_6_clk _0076_ VGND VGND VPWR VPWR mantisaB0\[4\] sky130_fd_sc_hd__dfxtp_1
X_3884_ clknet_leaf_21_clk _0007_ VGND VGND VPWR VPWR net71 sky130_fd_sc_hd__dfxtp_1
X_2904_ net140 _0640_ VGND VGND VPWR VPWR _0843_ sky130_fd_sc_hd__nor2_1
X_2835_ net117 _0646_ VGND VGND VPWR VPWR _0776_ sky130_fd_sc_hd__nor2_1
X_2766_ mantisaresult\[15\] net111 net107 mantisaresult\[16\] VGND VGND VPWR VPWR
+ _0708_ sky130_fd_sc_hd__a22o_1
X_2697_ _0636_ _0639_ net117 VGND VGND VPWR VPWR _0640_ sky130_fd_sc_hd__mux2_1
X_3318_ mantisaresult\[51\] net195 net165 _1194_ VGND VGND VPWR VPWR _1195_ sky130_fd_sc_hd__a31o_1
XTAP_TAPCELL_ROW_69_721 VGND VPWR sky130_fd_sc_hd__tapvpwrvgnd_1
X_3249_ net220 _1131_ net203 VGND VGND VPWR VPWR _0158_ sky130_fd_sc_hd__mux2_1
XFILLER_73_217 VGND VGND VPWR VPWR sky130_fd_sc_hd__decap_6
XFILLER_39_472 VGND VGND VPWR VPWR sky130_fd_sc_hd__fill_1
XFILLER_41_147 VGND VGND VPWR VPWR sky130_fd_sc_hd__decap_6
XFILLER_22_361 VGND VGND VPWR VPWR sky130_fd_sc_hd__decap_3
XTAP_TAPCELL_ROW_24_367 VGND VPWR sky130_fd_sc_hd__tapvpwrvgnd_1
XFILLER_41_169 VGND VGND VPWR VPWR sky130_fd_sc_hd__decap_4
XFILLER_2_27 VGND VGND VPWR VPWR sky130_fd_sc_hd__fill_1
XFILLER_45_420 VGND VGND VPWR VPWR sky130_fd_sc_hd__fill_1
XTAP_TAPCELL_ROW_75_768 VGND VPWR sky130_fd_sc_hd__tapvpwrvgnd_1
X_2620_ _0373_ _0448_ _0458_ _0551_ _0417_ VGND VGND VPWR VPWR _0563_ sky130_fd_sc_hd__o311a_1
XFILLER_70_6 VGND VGND VPWR VPWR sky130_fd_sc_hd__fill_2
X_2551_ mantisaresult\[8\] _0347_ _0429_ _0493_ VGND VGND VPWR VPWR _0494_ sky130_fd_sc_hd__and4_1
X_2482_ _1636_ _0338_ _0348_ _0424_ VGND VGND VPWR VPWR _0425_ sky130_fd_sc_hd__or4_1
XFILLER_49_3 VGND VGND VPWR VPWR sky130_fd_sc_hd__fill_1
X_4152_ clknet_leaf_9_clk _0259_ VGND VGND VPWR VPWR mantisaBshift\[57\] sky130_fd_sc_hd__dfxtp_1
X_4083_ clknet_leaf_21_clk _0192_ VGND VGND VPWR VPWR expadd\[7\] sky130_fd_sc_hd__dfxtp_1
X_3103_ _1003_ _1004_ mantisaresult\[31\] net235 VGND VGND VPWR VPWR _0139_ sky130_fd_sc_hd__a2bb2o_1
XTAP_TAPCELL_ROW_66_702 VGND VPWR sky130_fd_sc_hd__tapvpwrvgnd_1
X_3034_ net237 mantisaBshift\[16\] _0950_ net234 VGND VGND VPWR VPWR _0952_ sky130_fd_sc_hd__a31o_1
XFILLER_51_412 VGND VGND VPWR VPWR sky130_fd_sc_hd__fill_1
XFILLER_63_294 VGND VGND VPWR VPWR sky130_fd_sc_hd__decap_4
XFILLER_23_169 VPWR VGND VPWR VGND sky130_ef_sc_hd__decap_12
X_3936_ clknet_leaf_8_clk _0059_ VGND VGND VPWR VPWR mantisaA0\[10\] sky130_fd_sc_hd__dfxtp_1
X_3867_ clknet_leaf_8_clk net283 VGND VGND VPWR VPWR mantisaAshift\[52\] sky130_fd_sc_hd__dfxtp_1
XTAP_TAPCELL_ROW_21_337 VGND VPWR sky130_fd_sc_hd__tapvpwrvgnd_1
X_3798_ _1502_ _1593_ _1605_ _1418_ VGND VGND VPWR VPWR _0233_ sky130_fd_sc_hd__a2bb2o_1
X_2818_ net227 net200 _0591_ VGND VGND VPWR VPWR _0760_ sky130_fd_sc_hd__a21o_1
XFILLER_11_25 VGND VGND VPWR VPWR sky130_fd_sc_hd__decap_6
X_2749_ mantisaresult\[22\] net154 VGND VGND VPWR VPWR _0692_ sky130_fd_sc_hd__nand2_1
XFILLER_78_309 VPWR VGND VPWR VGND sky130_ef_sc_hd__decap_12
XTAP_TAPCELL_ROW_29_404 VGND VPWR sky130_fd_sc_hd__tapvpwrvgnd_1
XFILLER_46_217 VGND VGND VPWR VPWR sky130_fd_sc_hd__fill_1
XFILLER_42_401 VPWR VGND VPWR VGND sky130_ef_sc_hd__decap_12
XTAP_TAPCELL_ROW_37_470 VGND VPWR sky130_fd_sc_hd__tapvpwrvgnd_1
XTAP_TAPCELL_ROW_72_749 VGND VPWR sky130_fd_sc_hd__tapvpwrvgnd_1
Xinput19 mantisaA[11] VGND VGND VPWR VPWR net19 sky130_fd_sc_hd__dlymetal6s2s_1
XFILLER_18_442 VPWR VGND VPWR VGND sky130_ef_sc_hd__decap_12
XFILLER_33_401 VPWR VGND VPWR VGND sky130_ef_sc_hd__decap_12
XFILLER_33_445 VGND VGND VPWR VPWR sky130_fd_sc_hd__decap_3
XFILLER_60_253 VGND VGND VPWR VPWR sky130_fd_sc_hd__fill_2
XFILLER_20_106 VGND VGND VPWR VPWR sky130_fd_sc_hd__decap_8
X_1982_ mantisaBshift\[36\] VGND VGND VPWR VPWR _1677_ sky130_fd_sc_hd__inv_2
X_3721_ _1484_ _1490_ net266 VGND VGND VPWR VPWR _1545_ sky130_fd_sc_hd__mux2_1
X_3652_ net273 net250 mantisaB0\[15\] VGND VGND VPWR VPWR _1482_ sky130_fd_sc_hd__or3b_1
X_3583_ _0884_ _0936_ _1414_ _0632_ VGND VGND VPWR VPWR _1415_ sky130_fd_sc_hd__a22o_1
X_2603_ mantisaresult\[54\] net221 mantisaresult\[34\] mantisaresult\[31\] VGND VGND
+ VPWR VPWR _0546_ sky130_fd_sc_hd__or4b_1
X_2534_ mantisaresult\[45\] _0346_ _0474_ _0475_ net180 VGND VGND VPWR VPWR _0477_
+ sky130_fd_sc_hd__a2111o_1
X_2465_ net227 _0327_ _0407_ VGND VGND VPWR VPWR _0408_ sky130_fd_sc_hd__nor3_1
X_2396_ _0338_ VGND VGND VPWR VPWR _0339_ sky130_fd_sc_hd__inv_2
XFILLER_3_81 VPWR VGND VPWR VGND sky130_ef_sc_hd__decap_12
X_4135_ clknet_leaf_4_clk _0242_ VGND VGND VPWR VPWR mantisaBshift\[42\] sky130_fd_sc_hd__dfxtp_1
XFILLER_68_386 VGND VGND VPWR VPWR sky130_fd_sc_hd__fill_2
X_4066_ clknet_2_2__leaf_clk net231 VGND VGND VPWR VPWR inf2 sky130_fd_sc_hd__dfxtp_1
X_3017_ _0937_ VGND VGND VPWR VPWR _0938_ sky130_fd_sc_hd__inv_2
XTAP_TAPCELL_ROW_34_440 VGND VPWR sky130_fd_sc_hd__tapvpwrvgnd_1
X_3919_ clknet_leaf_26_clk _0042_ VGND VGND VPWR VPWR expmiddlea\[1\] sky130_fd_sc_hd__dfxtp_1
XFILLER_22_24 VGND VGND VPWR VPWR sky130_fd_sc_hd__decap_4
XFILLER_78_128 VPWR VGND VPWR VGND sky130_ef_sc_hd__decap_12
Xfanout130 net132 VGND VGND VPWR VPWR net130 sky130_fd_sc_hd__clkbuf_2
Xfanout152 net153 VGND VGND VPWR VPWR net152 sky130_fd_sc_hd__clkbuf_2
Xfanout141 net143 VGND VGND VPWR VPWR net141 sky130_fd_sc_hd__buf_2
Xfanout163 _0569_ VGND VGND VPWR VPWR net163 sky130_fd_sc_hd__clkbuf_2
Xfanout174 net175 VGND VGND VPWR VPWR net174 sky130_fd_sc_hd__clkbuf_4
XFILLER_19_217 VGND VGND VPWR VPWR sky130_fd_sc_hd__decap_6
Xfanout185 _1457_ VGND VGND VPWR VPWR net185 sky130_fd_sc_hd__buf_2
Xfanout196 net197 VGND VGND VPWR VPWR net196 sky130_fd_sc_hd__clkbuf_2
XFILLER_74_345 VPWR VGND VPWR VGND sky130_ef_sc_hd__decap_12
XFILLER_74_389 VPWR VGND VPWR VGND sky130_ef_sc_hd__decap_12
XFILLER_27_272 VGND VGND VPWR VPWR sky130_fd_sc_hd__decap_3
XFILLER_42_253 VGND VGND VPWR VPWR sky130_fd_sc_hd__fill_2
XPHY_EDGE_ROW_69_Right_69 VGND VGND VPWR VPWR sky130_fd_sc_hd__decap_3
XPHY_EDGE_ROW_78_Right_78 VGND VGND VPWR VPWR sky130_fd_sc_hd__decap_3
XFILLER_2_371 VPWR VGND VPWR VGND sky130_ef_sc_hd__decap_12
X_2250_ _1888_ net285 net172 VGND VGND VPWR VPWR _0056_ sky130_fd_sc_hd__mux2_1
XFILLER_69_139 VGND VGND VPWR VPWR sky130_fd_sc_hd__fill_2
X_2181_ _1777_ _1779_ _1787_ VGND VGND VPWR VPWR _1841_ sky130_fd_sc_hd__a21oi_1
XTAP_TAPCELL_ROW_48_554 VGND VPWR sky130_fd_sc_hd__tapvpwrvgnd_1
XFILLER_21_426 VPWR VGND VPWR VGND sky130_ef_sc_hd__decap_12
XFILLER_33_286 VPWR VGND VPWR VGND sky130_ef_sc_hd__decap_12
XTAP_TAPCELL_ROW_31_421 VGND VPWR sky130_fd_sc_hd__tapvpwrvgnd_1
X_1965_ net58 VGND VGND VPWR VPWR _1660_ sky130_fd_sc_hd__inv_2
X_3704_ net263 _1529_ VGND VGND VPWR VPWR _1530_ sky130_fd_sc_hd__or2_1
X_3635_ _1686_ _1421_ net185 mantisaB0\[2\] VGND VGND VPWR VPWR _1465_ sky130_fd_sc_hd__a22o_1
X_3566_ net128 _0862_ VGND VGND VPWR VPWR _1399_ sky130_fd_sc_hd__or2_1
X_2517_ _0457_ _0459_ _0441_ _0456_ VGND VGND VPWR VPWR _0460_ sky130_fd_sc_hd__and4b_1
X_3497_ _1305_ _1335_ net118 VGND VGND VPWR VPWR _1336_ sky130_fd_sc_hd__mux2_1
X_2448_ _1641_ _0298_ _0299_ _0303_ VGND VGND VPWR VPWR _0391_ sky130_fd_sc_hd__or4_1
X_2379_ _0315_ _0316_ _0317_ _0320_ VGND VGND VPWR VPWR _0322_ sky130_fd_sc_hd__or4b_1
X_4118_ clknet_leaf_24_clk _0225_ VGND VGND VPWR VPWR mantisaBshift\[4\] sky130_fd_sc_hd__dfxtp_1
X_4049_ clknet_leaf_14_clk _0160_ VGND VGND VPWR VPWR mantisaresult\[50\] sky130_fd_sc_hd__dfxtp_2
XFILLER_17_57 VGND VGND VPWR VPWR sky130_fd_sc_hd__decap_8
XFILLER_71_337 VPWR VGND VPWR VGND sky130_ef_sc_hd__decap_12
XFILLER_24_253 VGND VGND VPWR VPWR sky130_fd_sc_hd__decap_6
XFILLER_3_113 VPWR VGND VPWR VGND sky130_ef_sc_hd__decap_12
XFILLER_58_20 VGND VGND VPWR VPWR sky130_fd_sc_hd__decap_8
XFILLER_58_97 VGND VGND VPWR VPWR sky130_fd_sc_hd__fill_1
Xhold8 mantisaA0\[9\] VGND VGND VPWR VPWR net282 sky130_fd_sc_hd__dlygate4sd3_1
XTAP_TAPCELL_ROW_2_190 VGND VPWR sky130_fd_sc_hd__tapvpwrvgnd_1
XTAP_TAPCELL_ROW_45_535 VGND VPWR sky130_fd_sc_hd__tapvpwrvgnd_1
XFILLER_74_197 VGND VGND VPWR VPWR sky130_fd_sc_hd__decap_8
XFILLER_15_253 VGND VGND VPWR VPWR sky130_fd_sc_hd__decap_4
XFILLER_15_286 VGND VGND VPWR VPWR sky130_fd_sc_hd__fill_1
XFILLER_15_275 VGND VGND VPWR VPWR sky130_fd_sc_hd__decap_4
X_3420_ net244 _1275_ _1286_ VGND VGND VPWR VPWR _1287_ sky130_fd_sc_hd__and3b_1
X_3351_ _1222_ _1224_ VGND VGND VPWR VPWR _1225_ sky130_fd_sc_hd__nand2_1
X_2302_ _1879_ net33 net102 VGND VGND VPWR VPWR _1922_ sky130_fd_sc_hd__mux2_1
X_3282_ mantisaAshift\[52\] mantisaBshift\[52\] VGND VGND VPWR VPWR _1161_ sky130_fd_sc_hd__and2_1
X_2233_ net55 net168 VGND VGND VPWR VPWR _1877_ sky130_fd_sc_hd__and2_1
X_2164_ _1824_ _1822_ _1821_ VGND VGND VPWR VPWR _1825_ sky130_fd_sc_hd__nor3b_1
X_2095_ _1755_ _1756_ VGND VGND VPWR VPWR _1757_ sky130_fd_sc_hd__nand2_1
XFILLER_53_337 VGND VGND VPWR VPWR sky130_fd_sc_hd__decap_4
X_2997_ net237 mantisaBshift\[13\] _0917_ net230 VGND VGND VPWR VPWR _0919_ sky130_fd_sc_hd__a31o_1
X_1948_ net220 VGND VGND VPWR VPWR _1643_ sky130_fd_sc_hd__inv_2
XFILLER_79_19 VGND VGND VPWR VPWR sky130_fd_sc_hd__decap_8
X_3618_ mantisaB0\[16\] net193 _1448_ VGND VGND VPWR VPWR _1449_ sky130_fd_sc_hd__a21oi_1
XTAP_TAPCELL_ROW_8_238 VGND VPWR sky130_fd_sc_hd__tapvpwrvgnd_1
X_3549_ _0814_ _0936_ _1383_ _0632_ VGND VGND VPWR VPWR _1384_ sky130_fd_sc_hd__a22o_1
XFILLER_44_304 VGND VGND VPWR VPWR sky130_fd_sc_hd__decap_4
XFILLER_56_197 VGND VGND VPWR VPWR sky130_fd_sc_hd__decap_8
XTAP_TAPCELL_ROW_42_505 VGND VPWR sky130_fd_sc_hd__tapvpwrvgnd_1
XFILLER_8_249 VGND VGND VPWR VPWR sky130_fd_sc_hd__decap_3
XTAP_TAPCELL_ROW_50_571 VGND VPWR sky130_fd_sc_hd__tapvpwrvgnd_1
XFILLER_4_400 VGND VGND VPWR VPWR sky130_fd_sc_hd__fill_2
XFILLER_4_433 VPWR VGND VPWR VGND sky130_ef_sc_hd__decap_12
Xclkbuf_2_3__f_clk clknet_0_clk VGND VGND VPWR VPWR clknet_2_3__leaf_clk sky130_fd_sc_hd__clkbuf_16
XFILLER_62_156 VGND VGND VPWR VPWR sky130_fd_sc_hd__fill_2
XFILLER_43_370 VGND VGND VPWR VPWR sky130_fd_sc_hd__decap_6
X_2920_ _0857_ _0738_ net146 VGND VGND VPWR VPWR _0858_ sky130_fd_sc_hd__mux2_1
XFILLER_50_318 VPWR VGND VPWR VGND sky130_ef_sc_hd__decap_12
XFILLER_62_178 VGND VGND VPWR VPWR sky130_fd_sc_hd__fill_1
X_2851_ net139 _0791_ VGND VGND VPWR VPWR _0792_ sky130_fd_sc_hd__and2b_1
XPHY_EDGE_ROW_28_Left_108 VGND VGND VPWR VPWR sky130_fd_sc_hd__decap_3
XTAP_TAPCELL_ROW_13_273 VGND VPWR sky130_fd_sc_hd__tapvpwrvgnd_1
X_2782_ mantisaresult\[25\] net112 _0637_ net132 VGND VGND VPWR VPWR _0724_ sky130_fd_sc_hd__o2bb2a_1
X_3403_ mantisaBshift\[60\] mantisaAshift\[60\] VGND VGND VPWR VPWR _1272_ sky130_fd_sc_hd__nand2b_1
XTAP_TAPCELL_ROW_5_208 VGND VPWR sky130_fd_sc_hd__tapvpwrvgnd_1
XPHY_EDGE_ROW_37_Left_117 VGND VGND VPWR VPWR sky130_fd_sc_hd__decap_3
X_3334_ mantisaAshift\[55\] mantisaBshift\[55\] VGND VGND VPWR VPWR _1209_ sky130_fd_sc_hd__or2_1
X_3265_ _1125_ _1135_ VGND VGND VPWR VPWR _1146_ sky130_fd_sc_hd__nor2_1
X_2216_ net307 net178 _1866_ VGND VGND VPWR VPWR _0044_ sky130_fd_sc_hd__o21a_1
X_3196_ net129 net106 _0792_ VGND VGND VPWR VPWR _1084_ sky130_fd_sc_hd__and3_1
XTAP_TAPCELL_ROW_56_619 VGND VPWR sky130_fd_sc_hd__tapvpwrvgnd_1
X_2147_ net23 _1670_ VGND VGND VPWR VPWR _1808_ sky130_fd_sc_hd__and2_1
X_2078_ net209 net334 VGND VGND VPWR VPWR _0018_ sky130_fd_sc_hd__and2b_1
XFILLER_41_329 VGND VGND VPWR VPWR sky130_fd_sc_hd__decap_6
XFILLER_53_178 VGND VGND VPWR VPWR sky130_fd_sc_hd__decap_3
XTAP_TAPCELL_ROW_64_685 VGND VPWR sky130_fd_sc_hd__tapvpwrvgnd_1
XPHY_EDGE_ROW_46_Left_126 VGND VGND VPWR VPWR sky130_fd_sc_hd__decap_3
XPHY_EDGE_ROW_55_Left_135 VGND VGND VPWR VPWR sky130_fd_sc_hd__decap_3
XFILLER_1_447 VGND VGND VPWR VPWR sky130_fd_sc_hd__fill_1
XFILLER_39_44 VGND VGND VPWR VPWR sky130_fd_sc_hd__fill_1
XFILLER_49_407 VGND VGND VPWR VPWR sky130_fd_sc_hd__fill_2
XFILLER_17_304 VPWR VGND VPWR VGND sky130_ef_sc_hd__decap_12
XFILLER_72_421 VPWR VGND VPWR VGND sky130_ef_sc_hd__decap_12
XFILLER_17_359 VGND VGND VPWR VPWR sky130_fd_sc_hd__decap_8
XFILLER_32_307 VGND VGND VPWR VPWR sky130_fd_sc_hd__fill_1
XFILLER_55_98 VGND VGND VPWR VPWR sky130_fd_sc_hd__decap_6
XPHY_EDGE_ROW_64_Left_144 VGND VGND VPWR VPWR sky130_fd_sc_hd__decap_3
XTAP_TAPCELL_ROW_27_387 VGND VPWR sky130_fd_sc_hd__tapvpwrvgnd_1
XFILLER_40_351 VGND VGND VPWR VPWR sky130_fd_sc_hd__decap_3
XTAP_TAPCELL_ROW_10_254 VGND VPWR sky130_fd_sc_hd__tapvpwrvgnd_1
XPHY_EDGE_ROW_73_Left_153 VGND VGND VPWR VPWR sky130_fd_sc_hd__decap_3
X_3050_ _0962_ _0963_ mantisaresult\[20\] net233 VGND VGND VPWR VPWR _0127_ sky130_fd_sc_hd__a2bb2o_1
X_2001_ net25 net24 net27 net26 VGND VGND VPWR VPWR _1696_ sky130_fd_sc_hd__or4_1
XFILLER_67_259 VGND VGND VPWR VPWR sky130_fd_sc_hd__decap_4
XTAP_TAPCELL_ROW_78_799 VGND VPWR sky130_fd_sc_hd__tapvpwrvgnd_1
X_3952_ clknet_leaf_5_clk _0075_ VGND VGND VPWR VPWR mantisaB0\[3\] sky130_fd_sc_hd__dfxtp_1
X_3883_ clknet_leaf_21_clk _0006_ VGND VGND VPWR VPWR net70 sky130_fd_sc_hd__dfxtp_1
X_2903_ _0689_ _0679_ net138 VGND VGND VPWR VPWR _0842_ sky130_fd_sc_hd__mux2_1
XFILLER_50_159 VPWR VGND VPWR VGND sky130_ef_sc_hd__decap_12
X_2834_ net136 _0639_ _0774_ VGND VGND VPWR VPWR _0775_ sky130_fd_sc_hd__a21oi_1
X_2765_ net131 _0676_ net111 mantisaresult\[13\] VGND VGND VPWR VPWR _0707_ sky130_fd_sc_hd__a2bb2o_1
X_2696_ mantisaresult\[27\] net108 _0638_ net132 VGND VGND VPWR VPWR _0639_ sky130_fd_sc_hd__a22o_1
X_3317_ mantisaresult\[50\] net195 net161 net215 VGND VGND VPWR VPWR _1194_ sky130_fd_sc_hd__a31o_1
XTAP_TAPCELL_ROW_69_722 VGND VPWR sky130_fd_sc_hd__tapvpwrvgnd_1
X_3248_ _1125_ _1130_ VGND VGND VPWR VPWR _1131_ sky130_fd_sc_hd__xnor2_1
XFILLER_54_421 VGND VGND VPWR VPWR sky130_fd_sc_hd__fill_1
X_3179_ _1056_ _1059_ _1057_ VGND VGND VPWR VPWR _1068_ sky130_fd_sc_hd__o21a_1
XFILLER_14_307 VGND VGND VPWR VPWR sky130_fd_sc_hd__fill_1
XFILLER_41_104 VGND VGND VPWR VPWR sky130_fd_sc_hd__decap_8
XFILLER_41_34 VGND VGND VPWR VPWR sky130_fd_sc_hd__decap_6
XFILLER_41_78 VGND VGND VPWR VPWR sky130_fd_sc_hd__decap_6
XFILLER_9_3 VGND VGND VPWR VPWR sky130_fd_sc_hd__fill_1
XFILLER_57_281 VPWR VGND VPWR VGND sky130_ef_sc_hd__decap_12
XTAP_TAPCELL_ROW_75_769 VGND VPWR sky130_fd_sc_hd__tapvpwrvgnd_1
XFILLER_72_251 VGND VGND VPWR VPWR sky130_fd_sc_hd__fill_1
XFILLER_9_311 VGND VGND VPWR VPWR sky130_fd_sc_hd__fill_2
X_2550_ mantisaresult\[9\] _0433_ _0434_ VGND VGND VPWR VPWR _0493_ sky130_fd_sc_hd__nor3_1
X_2481_ _0357_ _0358_ _0423_ VGND VGND VPWR VPWR _0424_ sky130_fd_sc_hd__or3_1
X_4151_ clknet_leaf_1_clk _0258_ VGND VGND VPWR VPWR mantisaBshift\[25\] sky130_fd_sc_hd__dfxtp_1
X_4082_ clknet_leaf_21_clk _0191_ VGND VGND VPWR VPWR expadd\[6\] sky130_fd_sc_hd__dfxtp_1
X_3102_ net242 mantisaBshift\[31\] _1002_ net235 VGND VGND VPWR VPWR _1004_ sky130_fd_sc_hd__a31o_1
XTAP_TAPCELL_ROW_66_703 VGND VPWR sky130_fd_sc_hd__tapvpwrvgnd_1
X_3033_ net237 _0950_ mantisaBshift\[16\] VGND VGND VPWR VPWR _0951_ sky130_fd_sc_hd__a21oi_1
XFILLER_36_410 VGND VGND VPWR VPWR sky130_fd_sc_hd__decap_8
X_3935_ clknet_leaf_9_clk _0058_ VGND VGND VPWR VPWR mantisaA0\[9\] sky130_fd_sc_hd__dfxtp_1
XTAP_TAPCELL_ROW_21_338 VGND VPWR sky130_fd_sc_hd__tapvpwrvgnd_1
XFILLER_31_181 VGND VGND VPWR VPWR sky130_fd_sc_hd__decap_3
X_3866_ clknet_leaf_8_clk net290 VGND VGND VPWR VPWR mantisaAshift\[51\] sky130_fd_sc_hd__dfxtp_1
X_2817_ net159 _0723_ _0742_ _0758_ VGND VGND VPWR VPWR _0759_ sky130_fd_sc_hd__and4_1
X_3797_ net255 _1594_ VGND VGND VPWR VPWR _1605_ sky130_fd_sc_hd__nor2_1
XFILLER_11_48 VGND VGND VPWR VPWR sky130_fd_sc_hd__fill_2
XFILLER_11_37 VGND VGND VPWR VPWR sky130_fd_sc_hd__fill_2
X_2748_ mantisaresult\[20\] net112 _0615_ mantisaresult\[21\] VGND VGND VPWR VPWR
+ _0691_ sky130_fd_sc_hd__a22o_1
X_2679_ mantisaresult\[6\] net152 VGND VGND VPWR VPWR _0622_ sky130_fd_sc_hd__nand2_1
XFILLER_27_410 VGND VGND VPWR VPWR sky130_fd_sc_hd__decap_3
XTAP_TAPCELL_ROW_29_405 VGND VPWR sky130_fd_sc_hd__tapvpwrvgnd_1
XFILLER_39_281 VGND VGND VPWR VPWR sky130_fd_sc_hd__decap_3
XFILLER_36_56 VGND VGND VPWR VPWR sky130_fd_sc_hd__decap_3
XTAP_TAPCELL_ROW_37_471 VGND VPWR sky130_fd_sc_hd__tapvpwrvgnd_1
XFILLER_42_446 VGND VGND VPWR VPWR sky130_fd_sc_hd__fill_1
XFILLER_22_181 VGND VGND VPWR VPWR sky130_fd_sc_hd__decap_6
XFILLER_10_365 VGND VGND VPWR VPWR sky130_fd_sc_hd__decap_8
XFILLER_37_218 VGND VGND VPWR VPWR sky130_fd_sc_hd__decap_6
XFILLER_18_454 VPWR VGND VPWR VGND sky130_ef_sc_hd__decap_12
XFILLER_33_413 VGND VGND VPWR VPWR sky130_fd_sc_hd__decap_3
XFILLER_60_265 VGND VGND VPWR VPWR sky130_fd_sc_hd__fill_1
X_3720_ net186 _1542_ _1544_ net184 VGND VGND VPWR VPWR _0216_ sky130_fd_sc_hd__a2bb2o_1
X_1981_ mantisaBshift\[32\] VGND VGND VPWR VPWR _1676_ sky130_fd_sc_hd__inv_2
X_3651_ mantisaB0\[14\] _1457_ _1480_ VGND VGND VPWR VPWR _1481_ sky130_fd_sc_hd__a21boi_1
X_2602_ _0478_ _0513_ VGND VGND VPWR VPWR _0545_ sky130_fd_sc_hd__nand2b_1
X_3582_ _1324_ _1413_ net123 VGND VGND VPWR VPWR _1414_ sky130_fd_sc_hd__mux2_1
X_2533_ _1644_ _0309_ _0310_ _0325_ VGND VGND VPWR VPWR _0476_ sky130_fd_sc_hd__nor4_1
X_2464_ net219 mantisaresult\[39\] mantisaresult\[38\] _0310_ VGND VGND VPWR VPWR
+ _0407_ sky130_fd_sc_hd__or4_1
X_2395_ mantisaresult\[38\] mantisaresult\[37\] _0319_ VGND VGND VPWR VPWR _0338_
+ sky130_fd_sc_hd__or3_4
XFILLER_68_321 VGND VGND VPWR VPWR sky130_fd_sc_hd__decap_6
X_4134_ clknet_leaf_4_clk _0241_ VGND VGND VPWR VPWR mantisaBshift\[43\] sky130_fd_sc_hd__dfxtp_1
XFILLER_68_365 VGND VGND VPWR VPWR sky130_fd_sc_hd__decap_4
XFILLER_3_93 VPWR VGND VPWR VGND sky130_ef_sc_hd__decap_12
X_4065_ clknet_leaf_28_clk net277 VGND VGND VPWR VPWR signA2 sky130_fd_sc_hd__dfxtp_1
XFILLER_24_402 VPWR VGND VPWR VGND sky130_ef_sc_hd__decap_12
X_3016_ net129 _0925_ VGND VGND VPWR VPWR _0937_ sky130_fd_sc_hd__nand2_1
XFILLER_51_221 VGND VGND VPWR VPWR sky130_fd_sc_hd__decap_3
XTAP_TAPCELL_ROW_34_441 VGND VPWR sky130_fd_sc_hd__tapvpwrvgnd_1
X_3918_ clknet_leaf_26_clk _0041_ VGND VGND VPWR VPWR expmiddlea\[0\] sky130_fd_sc_hd__dfxtp_1
XFILLER_22_14 VGND VGND VPWR VPWR sky130_fd_sc_hd__fill_2
X_3849_ net192 _1604_ VGND VGND VPWR VPWR _0268_ sky130_fd_sc_hd__and2_1
Xfanout131 net132 VGND VGND VPWR VPWR net131 sky130_fd_sc_hd__clkbuf_2
Xfanout120 net121 VGND VGND VPWR VPWR net120 sky130_fd_sc_hd__buf_2
Xfanout153 net154 VGND VGND VPWR VPWR net153 sky130_fd_sc_hd__clkbuf_2
Xfanout142 net143 VGND VGND VPWR VPWR net142 sky130_fd_sc_hd__clkbuf_2
Xfanout164 net165 VGND VGND VPWR VPWR net164 sky130_fd_sc_hd__buf_2
Xfanout186 net187 VGND VGND VPWR VPWR net186 sky130_fd_sc_hd__buf_2
Xfanout175 net176 VGND VGND VPWR VPWR net175 sky130_fd_sc_hd__buf_2
Xfanout197 net198 VGND VGND VPWR VPWR net197 sky130_fd_sc_hd__buf_1
XFILLER_74_357 VGND VGND VPWR VPWR sky130_fd_sc_hd__decap_6
XFILLER_42_221 VPWR VGND VPWR VGND sky130_ef_sc_hd__decap_12
XFILLER_8_27 VGND VGND VPWR VPWR sky130_fd_sc_hd__fill_1
XTAP_TAPCELL_ROW_40_488 VGND VPWR sky130_fd_sc_hd__tapvpwrvgnd_1
XFILLER_2_383 VGND VGND VPWR VPWR sky130_fd_sc_hd__fill_2
X_2180_ _1780_ _1836_ VGND VGND VPWR VPWR _1840_ sky130_fd_sc_hd__nand2_1
XFILLER_26_6 VGND VGND VPWR VPWR sky130_fd_sc_hd__fill_1
XFILLER_18_251 VGND VGND VPWR VPWR sky130_fd_sc_hd__fill_1
XTAP_TAPCELL_ROW_48_555 VGND VPWR sky130_fd_sc_hd__tapvpwrvgnd_1
XFILLER_21_405 VGND VGND VPWR VPWR sky130_fd_sc_hd__decap_3
XFILLER_21_438 VGND VGND VPWR VPWR sky130_fd_sc_hd__decap_3
XFILLER_21_449 VPWR VGND VPWR VGND sky130_ef_sc_hd__decap_12
XTAP_TAPCELL_ROW_31_422 VGND VPWR sky130_fd_sc_hd__tapvpwrvgnd_1
XFILLER_33_298 VGND VGND VPWR VPWR sky130_fd_sc_hd__decap_6
Xclkbuf_leaf_13_clk clknet_2_2__leaf_clk VGND VGND VPWR VPWR clknet_leaf_13_clk sky130_fd_sc_hd__clkbuf_8
X_1964_ net55 VGND VGND VPWR VPWR _1659_ sky130_fd_sc_hd__inv_2
X_3703_ net267 _1528_ VGND VGND VPWR VPWR _1529_ sky130_fd_sc_hd__or2_1
X_3634_ net267 _1463_ net262 VGND VGND VPWR VPWR _1464_ sky130_fd_sc_hd__a21oi_1
X_3565_ net337 net207 _1396_ _1398_ VGND VGND VPWR VPWR _0207_ sky130_fd_sc_hd__o22a_1
X_2516_ _0373_ _0448_ _0458_ VGND VGND VPWR VPWR _0459_ sky130_fd_sc_hd__or3_1
XFILLER_0_309 VPWR VGND VPWR VGND sky130_ef_sc_hd__decap_12
X_3496_ net134 _1334_ net114 net218 VGND VGND VPWR VPWR _1335_ sky130_fd_sc_hd__a2bb2o_1
X_2447_ mantisaresult\[51\] mantisaresult\[50\] net188 VGND VGND VPWR VPWR _0390_
+ sky130_fd_sc_hd__o21ba_1
X_2378_ mantisaresult\[39\] mantisaresult\[38\] mantisaresult\[37\] mantisaresult\[36\]
+ VGND VGND VPWR VPWR _0321_ sky130_fd_sc_hd__or4_1
X_4117_ clknet_leaf_24_clk _0224_ VGND VGND VPWR VPWR mantisaBshift\[5\] sky130_fd_sc_hd__dfxtp_1
XFILLER_56_335 VGND VGND VPWR VPWR sky130_fd_sc_hd__decap_8
X_4048_ clknet_leaf_9_clk _0159_ VGND VGND VPWR VPWR mantisaresult\[49\] sky130_fd_sc_hd__dfxtp_2
XFILLER_71_305 VPWR VGND VPWR VGND sky130_ef_sc_hd__decap_12
XFILLER_71_349 VPWR VGND VPWR VGND sky130_ef_sc_hd__decap_12
XFILLER_24_232 VPWR VGND VPWR VGND sky130_ef_sc_hd__decap_12
XFILLER_33_57 VGND VGND VPWR VPWR sky130_fd_sc_hd__decap_3
XFILLER_20_471 VGND VGND VPWR VPWR sky130_fd_sc_hd__fill_2
XFILLER_3_125 VPWR VGND VPWR VGND sky130_ef_sc_hd__decap_12
XFILLER_79_405 VPWR VGND VPWR VGND sky130_ef_sc_hd__decap_12
XFILLER_3_169 VPWR VGND VPWR VGND sky130_ef_sc_hd__decap_12
XFILLER_79_449 VPWR VGND VPWR VGND sky130_ef_sc_hd__decap_12
Xhold9 mantisaA0\[13\] VGND VGND VPWR VPWR net283 sky130_fd_sc_hd__dlygate4sd3_1
XFILLER_47_302 VPWR VGND VPWR VGND sky130_ef_sc_hd__decap_12
XFILLER_59_140 VGND VGND VPWR VPWR sky130_fd_sc_hd__decap_8
XFILLER_47_335 VGND VGND VPWR VPWR sky130_fd_sc_hd__fill_1
XTAP_TAPCELL_ROW_2_191 VGND VPWR sky130_fd_sc_hd__tapvpwrvgnd_1
XFILLER_74_64 VGND VGND VPWR VPWR sky130_fd_sc_hd__fill_2
XFILLER_55_390 VGND VGND VPWR VPWR sky130_fd_sc_hd__fill_2
XFILLER_30_202 VGND VGND VPWR VPWR sky130_fd_sc_hd__fill_1
XFILLER_30_235 VGND VGND VPWR VPWR sky130_fd_sc_hd__fill_2
X_3350_ _1210_ _1223_ _1221_ VGND VGND VPWR VPWR _1224_ sky130_fd_sc_hd__a21oi_1
X_2301_ _1921_ net371 net176 VGND VGND VPWR VPWR _0074_ sky130_fd_sc_hd__mux2_1
X_3281_ mantisaresult\[51\] _1160_ net203 VGND VGND VPWR VPWR _0161_ sky130_fd_sc_hd__mux2_1
Xclkbuf_leaf_2_clk clknet_2_2__leaf_clk VGND VGND VPWR VPWR clknet_leaf_2_clk sky130_fd_sc_hd__clkbuf_8
X_2232_ _1876_ net301 net172 VGND VGND VPWR VPWR _0050_ sky130_fd_sc_hd__mux2_1
X_2163_ _1650_ net47 VGND VGND VPWR VPWR _1824_ sky130_fd_sc_hd__nor2_1
XFILLER_38_346 VPWR VGND VPWR VGND sky130_ef_sc_hd__decap_12
XFILLER_65_132 VGND VGND VPWR VPWR sky130_fd_sc_hd__fill_1
X_2094_ net1 net9 VGND VGND VPWR VPWR _1756_ sky130_fd_sc_hd__nand2b_1
XFILLER_53_316 VPWR VGND VPWR VGND sky130_ef_sc_hd__decap_12
XFILLER_0_83 VGND VGND VPWR VPWR sky130_fd_sc_hd__fill_1
XFILLER_21_213 VGND VGND VPWR VPWR sky130_fd_sc_hd__decap_8
X_2996_ net237 _0917_ mantisaBshift\[13\] VGND VGND VPWR VPWR _0918_ sky130_fd_sc_hd__a21oi_1
XFILLER_21_279 VGND VGND VPWR VPWR sky130_fd_sc_hd__fill_1
X_1947_ mantisaresult\[49\] VGND VGND VPWR VPWR _1642_ sky130_fd_sc_hd__inv_2
X_3617_ net250 mantisaB0\[17\] net273 VGND VGND VPWR VPWR _1448_ sky130_fd_sc_hd__and3b_1
X_3548_ _1186_ _1382_ net124 VGND VGND VPWR VPWR _1383_ sky130_fd_sc_hd__mux2_1
XTAP_TAPCELL_ROW_8_239 VGND VPWR sky130_fd_sc_hd__tapvpwrvgnd_1
X_3479_ _0887_ _0921_ _0925_ _0878_ VGND VGND VPWR VPWR _1325_ sky130_fd_sc_hd__a22o_1
XFILLER_76_419 VGND VGND VPWR VPWR sky130_fd_sc_hd__fill_1
XFILLER_44_338 VGND VGND VPWR VPWR sky130_fd_sc_hd__decap_6
XFILLER_44_349 VPWR VGND VPWR VGND sky130_ef_sc_hd__decap_12
XFILLER_71_157 VGND VGND VPWR VPWR sky130_fd_sc_hd__decap_8
XTAP_TAPCELL_ROW_42_506 VGND VPWR sky130_fd_sc_hd__tapvpwrvgnd_1
XFILLER_12_235 VGND VGND VPWR VPWR sky130_fd_sc_hd__decap_6
XFILLER_8_239 VGND VGND VPWR VPWR sky130_fd_sc_hd__fill_1
XTAP_TAPCELL_ROW_50_572 VGND VPWR sky130_fd_sc_hd__tapvpwrvgnd_1
XFILLER_4_445 VPWR VGND VPWR VGND sky130_ef_sc_hd__decap_12
XFILLER_47_121 VGND VGND VPWR VPWR sky130_fd_sc_hd__fill_1
XFILLER_75_441 VGND VGND VPWR VPWR sky130_fd_sc_hd__decap_6
XFILLER_35_305 VGND VGND VPWR VPWR sky130_fd_sc_hd__fill_2
XFILLER_47_165 VGND VGND VPWR VPWR sky130_fd_sc_hd__decap_3
X_2850_ net136 _0614_ VGND VGND VPWR VPWR _0791_ sky130_fd_sc_hd__nor2_1
XTAP_TAPCELL_ROW_13_274 VGND VPWR sky130_fd_sc_hd__tapvpwrvgnd_1
X_2781_ net151 _0722_ net125 VGND VGND VPWR VPWR _0723_ sky130_fd_sc_hd__a21o_1
X_3402_ _1262_ _1264_ _1257_ VGND VGND VPWR VPWR _1271_ sky130_fd_sc_hd__a21o_1
XTAP_TAPCELL_ROW_5_209 VGND VPWR sky130_fd_sc_hd__tapvpwrvgnd_1
X_3333_ mantisaAshift\[55\] mantisaBshift\[55\] VGND VGND VPWR VPWR _1208_ sky130_fd_sc_hd__and2_1
X_3264_ _1143_ _1144_ VGND VGND VPWR VPWR _1145_ sky130_fd_sc_hd__nor2_1
XPHY_EDGE_ROW_7_Right_7 VGND VGND VPWR VPWR sky130_fd_sc_hd__decap_3
XFILLER_58_419 VGND VGND VPWR VPWR sky130_fd_sc_hd__fill_1
X_2215_ net4 net12 net98 VGND VGND VPWR VPWR _1866_ sky130_fd_sc_hd__mux2_1
X_3195_ net129 net106 VGND VGND VPWR VPWR _1083_ sky130_fd_sc_hd__nand2_1
XFILLER_26_305 VGND VGND VPWR VPWR sky130_fd_sc_hd__decap_3
XFILLER_53_102 VGND VGND VPWR VPWR sky130_fd_sc_hd__decap_4
XFILLER_53_113 VGND VGND VPWR VPWR sky130_fd_sc_hd__decap_4
X_2146_ net19 _1666_ _1667_ net18 _1806_ VGND VGND VPWR VPWR _1807_ sky130_fd_sc_hd__o221a_1
XFILLER_26_349 VGND VGND VPWR VPWR sky130_fd_sc_hd__decap_4
X_2077_ net209 net322 VGND VGND VPWR VPWR _0017_ sky130_fd_sc_hd__and2b_1
XFILLER_41_319 VGND VGND VPWR VPWR sky130_fd_sc_hd__fill_1
XTAP_TAPCELL_ROW_64_686 VGND VPWR sky130_fd_sc_hd__tapvpwrvgnd_1
XFILLER_14_26 VGND VGND VPWR VPWR sky130_fd_sc_hd__fill_2
X_2979_ mantisaresult\[8\] _0905_ net201 VGND VGND VPWR VPWR _0114_ sky130_fd_sc_hd__mux2_1
XFILLER_29_121 VGND VGND VPWR VPWR sky130_fd_sc_hd__decap_8
XFILLER_17_316 VPWR VGND VPWR VGND sky130_ef_sc_hd__decap_12
XFILLER_72_433 VPWR VGND VPWR VGND sky130_ef_sc_hd__decap_12
XFILLER_25_393 VGND VGND VPWR VPWR sky130_fd_sc_hd__fill_1
XTAP_TAPCELL_ROW_27_388 VGND VPWR sky130_fd_sc_hd__tapvpwrvgnd_1
XFILLER_40_363 VGND VGND VPWR VPWR sky130_fd_sc_hd__fill_1
XFILLER_71_43 VGND VGND VPWR VPWR sky130_fd_sc_hd__decap_4
XTAP_TAPCELL_ROW_10_255 VGND VPWR sky130_fd_sc_hd__tapvpwrvgnd_1
XFILLER_4_253 VPWR VGND VPWR VGND sky130_ef_sc_hd__decap_12
XFILLER_67_205 VPWR VGND VPWR VGND sky130_ef_sc_hd__decap_12
X_2000_ _1694_ VGND VGND VPWR VPWR _1695_ sky130_fd_sc_hd__inv_2
XFILLER_75_260 VGND VGND VPWR VPWR sky130_fd_sc_hd__decap_8
XFILLER_35_102 VGND VGND VPWR VPWR sky130_fd_sc_hd__fill_1
XFILLER_35_113 VGND VGND VPWR VPWR sky130_fd_sc_hd__decap_4
XFILLER_63_400 VGND VGND VPWR VPWR sky130_fd_sc_hd__fill_2
XFILLER_35_135 VPWR VGND VPWR VGND sky130_ef_sc_hd__decap_12
XFILLER_16_360 VGND VGND VPWR VPWR sky130_fd_sc_hd__decap_4
XFILLER_35_157 VGND VGND VPWR VPWR sky130_fd_sc_hd__decap_8
X_3951_ clknet_leaf_5_clk _0074_ VGND VGND VPWR VPWR mantisaB0\[2\] sky130_fd_sc_hd__dfxtp_1
X_2902_ _0632_ _0840_ net157 VGND VGND VPWR VPWR _0841_ sky130_fd_sc_hd__a21boi_1
X_3882_ clknet_leaf_20_clk _0005_ VGND VGND VPWR VPWR net69 sky130_fd_sc_hd__dfxtp_1
XFILLER_43_190 VGND VGND VPWR VPWR sky130_fd_sc_hd__fill_2
XTAP_TAPCELL_ROW_61_656 VGND VPWR sky130_fd_sc_hd__tapvpwrvgnd_1
X_2833_ net136 _0643_ VGND VGND VPWR VPWR _0774_ sky130_fd_sc_hd__nor2_1
X_2764_ _0704_ _0705_ net116 VGND VGND VPWR VPWR _0706_ sky130_fd_sc_hd__mux2_1
X_2695_ _0637_ VGND VGND VPWR VPWR _0638_ sky130_fd_sc_hd__inv_2
X_3316_ net157 _1189_ _1192_ VGND VGND VPWR VPWR _1193_ sky130_fd_sc_hd__and3_1
XTAP_TAPCELL_ROW_69_723 VGND VPWR sky130_fd_sc_hd__tapvpwrvgnd_1
X_3247_ _1129_ _1127_ net245 VGND VGND VPWR VPWR _1130_ sky130_fd_sc_hd__mux2_1
XPHY_EDGE_ROW_16_Left_96 VGND VGND VPWR VPWR sky130_fd_sc_hd__decap_3
X_3178_ _1065_ _1066_ VGND VGND VPWR VPWR _1067_ sky130_fd_sc_hd__nand2b_1
X_2129_ _1786_ _1789_ VGND VGND VPWR VPWR _1790_ sky130_fd_sc_hd__nand2b_1
XFILLER_26_135 VGND VGND VPWR VPWR sky130_fd_sc_hd__decap_4
XFILLER_26_179 VGND VGND VPWR VPWR sky130_fd_sc_hd__fill_1
XFILLER_22_352 VGND VGND VPWR VPWR sky130_fd_sc_hd__decap_4
XFILLER_41_57 VGND VGND VPWR VPWR sky130_fd_sc_hd__fill_1
XFILLER_1_223 VGND VGND VPWR VPWR sky130_fd_sc_hd__fill_1
XFILLER_2_29 VPWR VGND VPWR VGND sky130_ef_sc_hd__decap_12
XFILLER_17_102 VGND VGND VPWR VPWR sky130_fd_sc_hd__decap_8
XFILLER_45_400 VPWR VGND VPWR VGND sky130_ef_sc_hd__decap_12
XFILLER_17_113 VPWR VGND VPWR VGND sky130_ef_sc_hd__decap_12
XFILLER_57_293 VGND VGND VPWR VPWR sky130_fd_sc_hd__fill_2
XFILLER_60_436 VGND VGND VPWR VPWR sky130_fd_sc_hd__fill_1
XFILLER_9_301 VGND VGND VPWR VPWR sky130_fd_sc_hd__decap_3
XFILLER_13_385 VGND VGND VPWR VPWR sky130_fd_sc_hd__decap_6
XFILLER_9_334 VGND VGND VPWR VPWR sky130_fd_sc_hd__fill_2
X_2480_ mantisaresult\[23\] mantisaresult\[22\] mantisaresult\[21\] mantisaresult\[20\]
+ VGND VGND VPWR VPWR _0423_ sky130_fd_sc_hd__or4_1
XFILLER_56_6 VGND VGND VPWR VPWR sky130_fd_sc_hd__fill_1
X_4150_ clknet_leaf_3_clk _0257_ VGND VGND VPWR VPWR mantisaBshift\[26\] sky130_fd_sc_hd__dfxtp_1
X_3101_ net242 _1002_ mantisaBshift\[31\] VGND VGND VPWR VPWR _1003_ sky130_fd_sc_hd__a21oi_1
Xoutput90 net90 VGND VGND VPWR VPWR mantisa[3] sky130_fd_sc_hd__buf_2
X_4081_ clknet_leaf_21_clk _0190_ VGND VGND VPWR VPWR expadd\[5\] sky130_fd_sc_hd__dfxtp_1
X_3032_ mantisaBshift\[13\] mantisaBshift\[14\] mantisaBshift\[15\] _0917_ VGND VGND
+ VPWR VPWR _0950_ sky130_fd_sc_hd__or4_2
XFILLER_48_260 VGND VGND VPWR VPWR sky130_fd_sc_hd__decap_6
XFILLER_36_433 VPWR VGND VPWR VGND sky130_ef_sc_hd__decap_12
XFILLER_23_105 VGND VGND VPWR VPWR sky130_fd_sc_hd__decap_3
XFILLER_51_436 VPWR VGND VPWR VGND sky130_ef_sc_hd__decap_12
XFILLER_63_274 VGND VGND VPWR VPWR sky130_fd_sc_hd__fill_2
X_3934_ clknet_leaf_6_clk _0057_ VGND VGND VPWR VPWR mantisaA0\[8\] sky130_fd_sc_hd__dfxtp_1
X_3865_ clknet_leaf_8_clk net284 VGND VGND VPWR VPWR mantisaAshift\[50\] sky130_fd_sc_hd__dfxtp_1
XTAP_TAPCELL_ROW_21_339 VGND VPWR sky130_fd_sc_hd__tapvpwrvgnd_1
X_2816_ _0744_ _0753_ _0755_ _0757_ VGND VGND VPWR VPWR _0758_ sky130_fd_sc_hd__o22a_1
X_3796_ net184 _1591_ _1604_ _1418_ VGND VGND VPWR VPWR _0232_ sky130_fd_sc_hd__a22o_1
X_2747_ net138 _0689_ VGND VGND VPWR VPWR _0690_ sky130_fd_sc_hd__nand2_1
X_2678_ mantisaresult\[5\] net107 _0620_ VGND VGND VPWR VPWR _0621_ sky130_fd_sc_hd__a21o_1
XTAP_TAPCELL_ROW_29_406 VGND VPWR sky130_fd_sc_hd__tapvpwrvgnd_1
XFILLER_36_13 VGND VGND VPWR VPWR sky130_fd_sc_hd__fill_1
XFILLER_36_68 VPWR VGND VPWR VGND sky130_ef_sc_hd__decap_12
XFILLER_54_241 VGND VGND VPWR VPWR sky130_fd_sc_hd__decap_8
XFILLER_14_149 VPWR VGND VPWR VGND sky130_ef_sc_hd__decap_12
XFILLER_42_469 VGND VGND VPWR VPWR sky130_fd_sc_hd__decap_4
XFILLER_18_400 VGND VGND VPWR VPWR sky130_fd_sc_hd__decap_3
XFILLER_18_466 VGND VGND VPWR VPWR sky130_fd_sc_hd__decap_6
XFILLER_45_252 VGND VGND VPWR VPWR sky130_fd_sc_hd__fill_2
XFILLER_45_274 VGND VGND VPWR VPWR sky130_fd_sc_hd__decap_6
XFILLER_60_211 VGND VGND VPWR VPWR sky130_fd_sc_hd__fill_2
X_1980_ mantisaBshift\[29\] VGND VGND VPWR VPWR _1675_ sky130_fd_sc_hd__inv_2
XTAP_TAPCELL_ROW_71_740 VGND VPWR sky130_fd_sc_hd__tapvpwrvgnd_1
XFILLER_60_277 VPWR VGND VPWR VGND sky130_ef_sc_hd__decap_12
X_3650_ net274 net250 mantisaB0\[13\] VGND VGND VPWR VPWR _1480_ sky130_fd_sc_hd__or3b_1
X_2601_ _0530_ _0543_ VGND VGND VPWR VPWR _0544_ sky130_fd_sc_hd__or2_1
X_3581_ _1412_ _1368_ net145 VGND VGND VPWR VPWR _1413_ sky130_fd_sc_hd__mux2_1
X_2532_ net199 _0297_ _0305_ net218 VGND VGND VPWR VPWR _0475_ sky130_fd_sc_hd__a2bb2o_1
X_2463_ mantisaresult\[36\] _0313_ _0318_ VGND VGND VPWR VPWR _0406_ sky130_fd_sc_hd__and3_1
X_2394_ net225 net226 net228 mantisaresult\[39\] VGND VGND VPWR VPWR _0337_ sky130_fd_sc_hd__or4_1
X_4133_ clknet_leaf_4_clk _0240_ VGND VGND VPWR VPWR mantisaBshift\[44\] sky130_fd_sc_hd__dfxtp_1
XFILLER_68_333 VGND VGND VPWR VPWR sky130_fd_sc_hd__decap_4
X_4064_ clknet_leaf_15_clk _0175_ VGND VGND VPWR VPWR four_man\[51\] sky130_fd_sc_hd__dfxtp_1
X_3015_ net150 net127 VGND VGND VPWR VPWR _0936_ sky130_fd_sc_hd__nor2_2
XFILLER_24_414 VGND VGND VPWR VPWR sky130_fd_sc_hd__fill_1
XTAP_TAPCELL_ROW_34_442 VGND VPWR sky130_fd_sc_hd__tapvpwrvgnd_1
X_3917_ clknet_leaf_29_clk _0040_ VGND VGND VPWR VPWR expmiddle\[7\] sky130_fd_sc_hd__dfxtp_1
X_3848_ net192 _1603_ VGND VGND VPWR VPWR _0267_ sky130_fd_sc_hd__and2_1
XFILLER_22_59 VGND VGND VPWR VPWR sky130_fd_sc_hd__fill_1
X_3779_ _1555_ _1557_ net261 VGND VGND VPWR VPWR _1594_ sky130_fd_sc_hd__mux2_1
XFILLER_3_318 VGND VGND VPWR VPWR sky130_fd_sc_hd__fill_1
Xfanout121 _0608_ VGND VGND VPWR VPWR net121 sky130_fd_sc_hd__clkbuf_2
Xfanout110 _0615_ VGND VGND VPWR VPWR net110 sky130_fd_sc_hd__clkbuf_2
Xfanout154 _0609_ VGND VGND VPWR VPWR net154 sky130_fd_sc_hd__clkbuf_2
Xfanout132 _0611_ VGND VGND VPWR VPWR net132 sky130_fd_sc_hd__buf_2
Xfanout143 net148 VGND VGND VPWR VPWR net143 sky130_fd_sc_hd__clkbuf_4
Xfanout165 net166 VGND VGND VPWR VPWR net165 sky130_fd_sc_hd__clkbuf_2
Xfanout176 _1762_ VGND VGND VPWR VPWR net176 sky130_fd_sc_hd__clkbuf_2
Xfanout187 _1419_ VGND VGND VPWR VPWR net187 sky130_fd_sc_hd__buf_2
XFILLER_59_377 VGND VGND VPWR VPWR sky130_fd_sc_hd__decap_4
Xfanout198 net199 VGND VGND VPWR VPWR net198 sky130_fd_sc_hd__dlymetal6s2s_1
XFILLER_74_303 VGND VGND VPWR VPWR sky130_fd_sc_hd__decap_4
XFILLER_27_241 VGND VGND VPWR VPWR sky130_fd_sc_hd__decap_6
XFILLER_27_252 VGND VGND VPWR VPWR sky130_fd_sc_hd__fill_2
XFILLER_15_447 VGND VGND VPWR VPWR sky130_fd_sc_hd__fill_1
XFILLER_42_233 VGND VGND VPWR VPWR sky130_fd_sc_hd__fill_1
XFILLER_63_66 VGND VGND VPWR VPWR sky130_fd_sc_hd__decap_4
XFILLER_42_277 VGND VGND VPWR VPWR sky130_fd_sc_hd__decap_3
XTAP_TAPCELL_ROW_40_489 VGND VPWR sky130_fd_sc_hd__tapvpwrvgnd_1
XFILLER_69_108 VGND VGND VPWR VPWR sky130_fd_sc_hd__decap_4
XTAP_TAPCELL_ROW_48_556 VGND VPWR sky130_fd_sc_hd__tapvpwrvgnd_1
XFILLER_18_274 VGND VGND VPWR VPWR sky130_fd_sc_hd__decap_8
XFILLER_73_391 VGND VGND VPWR VPWR sky130_fd_sc_hd__fill_1
XFILLER_33_277 VGND VGND VPWR VPWR sky130_fd_sc_hd__decap_3
XTAP_TAPCELL_ROW_31_423 VGND VPWR sky130_fd_sc_hd__tapvpwrvgnd_1
X_1963_ net56 VGND VGND VPWR VPWR _1658_ sky130_fd_sc_hd__inv_2
X_3702_ net271 _1491_ VGND VGND VPWR VPWR _1528_ sky130_fd_sc_hd__or2_1
X_3633_ net271 mantisaB0\[0\] net185 VGND VGND VPWR VPWR _1463_ sky130_fd_sc_hd__and3_1
X_3564_ mantisaresult\[60\] net199 net164 _1397_ VGND VGND VPWR VPWR _1398_ sky130_fd_sc_hd__a31o_1
X_2515_ mantisaresult\[7\] _1628_ _0450_ VGND VGND VPWR VPWR _0458_ sky130_fd_sc_hd__or3_1
X_3495_ mantisaresult\[54\] net155 VGND VGND VPWR VPWR _1334_ sky130_fd_sc_hd__nand2_1
X_2446_ _0382_ _0388_ VGND VGND VPWR VPWR _0389_ sky130_fd_sc_hd__nor2_1
X_4116_ clknet_leaf_24_clk _0223_ VGND VGND VPWR VPWR mantisaBshift\[6\] sky130_fd_sc_hd__dfxtp_1
X_2377_ mantisaresult\[36\] mantisaresult\[35\] net229 VGND VGND VPWR VPWR _0320_
+ sky130_fd_sc_hd__nor3_1
XFILLER_68_141 VGND VGND VPWR VPWR sky130_fd_sc_hd__fill_1
XFILLER_56_347 VPWR VGND VPWR VGND sky130_ef_sc_hd__decap_12
X_4047_ clknet_leaf_14_clk _0158_ VGND VGND VPWR VPWR mantisaresult\[48\] sky130_fd_sc_hd__dfxtp_1
XFILLER_71_317 VPWR VGND VPWR VGND sky130_ef_sc_hd__decap_12
XFILLER_24_222 VGND VGND VPWR VPWR sky130_fd_sc_hd__decap_4
XFILLER_3_137 VPWR VGND VPWR VGND sky130_ef_sc_hd__decap_12
XFILLER_79_417 VGND VGND VPWR VPWR sky130_fd_sc_hd__decap_3
XFILLER_47_314 VPWR VGND VPWR VGND sky130_ef_sc_hd__decap_12
XFILLER_62_328 VGND VGND VPWR VPWR sky130_fd_sc_hd__fill_2
XFILLER_15_222 VGND VGND VPWR VPWR sky130_fd_sc_hd__fill_2
XPHY_EDGE_ROW_4_Left_84 VGND VGND VPWR VPWR sky130_fd_sc_hd__decap_3
XTAP_TAPCELL_ROW_53_592 VGND VPWR sky130_fd_sc_hd__tapvpwrvgnd_1
XFILLER_30_269 VGND VGND VPWR VPWR sky130_fd_sc_hd__decap_8
XFILLER_11_461 VPWR VGND VPWR VGND sky130_ef_sc_hd__decap_12
XFILLER_7_410 VGND VGND VPWR VPWR sky130_fd_sc_hd__decap_6
X_2300_ _1877_ net32 net102 VGND VGND VPWR VPWR _1921_ sky130_fd_sc_hd__mux2_1
X_3280_ _1156_ _1159_ VGND VGND VPWR VPWR _1160_ sky130_fd_sc_hd__xor2_1
X_2231_ net28 _1875_ net102 VGND VGND VPWR VPWR _1876_ sky130_fd_sc_hd__mux2_1
X_2162_ _1649_ net48 VGND VGND VPWR VPWR _1823_ sky130_fd_sc_hd__or2_1
X_2093_ net9 net1 VGND VGND VPWR VPWR _1755_ sky130_fd_sc_hd__nand2b_1
XFILLER_38_358 VGND VGND VPWR VPWR sky130_fd_sc_hd__decap_6
XFILLER_53_328 VGND VGND VPWR VPWR sky130_fd_sc_hd__decap_8
XFILLER_65_166 VGND VGND VPWR VPWR sky130_fd_sc_hd__fill_2
XFILLER_65_177 VGND VGND VPWR VPWR sky130_fd_sc_hd__fill_2
XFILLER_46_380 VGND VGND VPWR VPWR sky130_fd_sc_hd__fill_2
XFILLER_21_203 VGND VGND VPWR VPWR sky130_fd_sc_hd__fill_1
XFILLER_21_225 VGND VGND VPWR VPWR sky130_fd_sc_hd__decap_6
X_2995_ mantisaBshift\[10\] mantisaBshift\[11\] mantisaBshift\[12\] _0909_ VGND VGND
+ VPWR VPWR _0917_ sky130_fd_sc_hd__or4_2
XFILLER_9_60 VGND VGND VPWR VPWR sky130_fd_sc_hd__fill_1
X_1946_ mantisaresult\[54\] VGND VGND VPWR VPWR _1641_ sky130_fd_sc_hd__inv_2
X_3616_ mantisaB0\[14\] _1420_ _1446_ VGND VGND VPWR VPWR _1447_ sky130_fd_sc_hd__a21oi_1
X_3547_ _1381_ _1336_ net147 VGND VGND VPWR VPWR _1382_ sky130_fd_sc_hd__mux2_1
X_3478_ _1323_ _1078_ net145 VGND VGND VPWR VPWR _1324_ sky130_fd_sc_hd__mux2_1
XFILLER_29_303 VPWR VGND VPWR VGND sky130_ef_sc_hd__decap_12
X_2429_ mantisaresult\[38\] _0306_ _0340_ _0345_ VGND VGND VPWR VPWR _0372_ sky130_fd_sc_hd__or4_4
XFILLER_69_461 VGND VGND VPWR VPWR sky130_fd_sc_hd__decap_4
XFILLER_37_391 VGND VGND VPWR VPWR sky130_fd_sc_hd__fill_1
XTAP_TAPCELL_ROW_42_507 VGND VPWR sky130_fd_sc_hd__tapvpwrvgnd_1
XTAP_TAPCELL_ROW_50_573 VGND VPWR sky130_fd_sc_hd__tapvpwrvgnd_1
XFILLER_20_291 VGND VGND VPWR VPWR sky130_fd_sc_hd__decap_6
XFILLER_5_18 VPWR VGND VPWR VGND sky130_ef_sc_hd__decap_12
XFILLER_4_457 VPWR VGND VPWR VGND sky130_ef_sc_hd__decap_12
XFILLER_79_225 VPWR VGND VPWR VGND sky130_ef_sc_hd__decap_12
XFILLER_47_144 VGND VGND VPWR VPWR sky130_fd_sc_hd__decap_8
XFILLER_35_328 VGND VGND VPWR VPWR sky130_fd_sc_hd__decap_8
XTAP_TAPCELL_ROW_13_275 VGND VPWR sky130_fd_sc_hd__tapvpwrvgnd_1
X_2780_ _0711_ _0721_ net122 VGND VGND VPWR VPWR _0722_ sky130_fd_sc_hd__mux2_1
X_3401_ net247 _1269_ VGND VGND VPWR VPWR _1270_ sky130_fd_sc_hd__nor2_1
X_3332_ mantisaresult\[54\] _1207_ net203 VGND VGND VPWR VPWR _0165_ sky130_fd_sc_hd__mux2_1
X_3263_ mantisaAshift\[50\] mantisaBshift\[50\] VGND VGND VPWR VPWR _1144_ sky130_fd_sc_hd__nor2_1
X_2214_ net302 net178 _1865_ VGND VGND VPWR VPWR _0043_ sky130_fd_sc_hd__o21a_1
X_3194_ _0778_ _0937_ VGND VGND VPWR VPWR _1082_ sky130_fd_sc_hd__nor2_1
X_2145_ net39 _1664_ _1667_ net18 _1805_ VGND VGND VPWR VPWR _1806_ sky130_fd_sc_hd__a221o_1
XFILLER_19_391 VGND VGND VPWR VPWR sky130_fd_sc_hd__fill_1
X_2076_ net209 net339 VGND VGND VPWR VPWR _0016_ sky130_fd_sc_hd__and2b_1
XFILLER_53_169 VGND VGND VPWR VPWR sky130_fd_sc_hd__decap_4
XTAP_TAPCELL_ROW_64_687 VGND VPWR sky130_fd_sc_hd__tapvpwrvgnd_1
X_2978_ mantisaBshift\[8\] _0904_ VGND VGND VPWR VPWR _0905_ sky130_fd_sc_hd__xnor2_1
X_1929_ expmiddlec\[5\] VGND VGND VPWR VPWR _1624_ sky130_fd_sc_hd__inv_2
XFILLER_1_405 VPWR VGND VPWR VGND sky130_ef_sc_hd__decap_12
XFILLER_1_449 VPWR VGND VPWR VGND sky130_ef_sc_hd__decap_12
XFILLER_39_57 VGND VGND VPWR VPWR sky130_fd_sc_hd__fill_1
XFILLER_29_111 VGND VGND VPWR VPWR sky130_fd_sc_hd__fill_1
XFILLER_17_328 VGND VGND VPWR VPWR sky130_fd_sc_hd__decap_8
XTAP_TAPCELL_ROW_55_610 VGND VPWR sky130_fd_sc_hd__tapvpwrvgnd_1
XFILLER_72_401 VPWR VGND VPWR VGND sky130_ef_sc_hd__decap_12
XFILLER_72_445 VPWR VGND VPWR VGND sky130_ef_sc_hd__decap_12
XFILLER_25_361 VGND VGND VPWR VPWR sky130_fd_sc_hd__fill_2
XFILLER_32_309 VGND VGND VPWR VPWR sky130_fd_sc_hd__fill_2
XTAP_TAPCELL_ROW_27_389 VGND VPWR sky130_fd_sc_hd__tapvpwrvgnd_1
XFILLER_40_331 VPWR VGND VPWR VGND sky130_ef_sc_hd__decap_12
XFILLER_40_386 VPWR VGND VPWR VGND sky130_ef_sc_hd__decap_12
XFILLER_4_221 VPWR VGND VPWR VGND sky130_ef_sc_hd__decap_12
XFILLER_4_265 VGND VGND VPWR VPWR sky130_fd_sc_hd__decap_4
XFILLER_20_81 VGND VGND VPWR VPWR sky130_fd_sc_hd__decap_3
XFILLER_67_217 VGND VGND VPWR VPWR sky130_fd_sc_hd__decap_3
XFILLER_75_272 VGND VGND VPWR VPWR sky130_fd_sc_hd__decap_8
Xhold90 expmiddled\[7\] VGND VGND VPWR VPWR net364 sky130_fd_sc_hd__dlygate4sd3_1
XTAP_TAPCELL_ROW_18_312 VGND VPWR sky130_fd_sc_hd__tapvpwrvgnd_1
XFILLER_35_147 VGND VGND VPWR VPWR sky130_fd_sc_hd__decap_4
XFILLER_63_445 VGND VGND VPWR VPWR sky130_fd_sc_hd__decap_3
XFILLER_35_169 VPWR VGND VPWR VGND sky130_ef_sc_hd__decap_12
X_3950_ clknet_leaf_5_clk _0073_ VGND VGND VPWR VPWR mantisaB0\[1\] sky130_fd_sc_hd__dfxtp_1
XFILLER_50_106 VGND VGND VPWR VPWR sky130_fd_sc_hd__decap_6
X_2901_ _0834_ _0839_ net123 VGND VGND VPWR VPWR _0840_ sky130_fd_sc_hd__mux2_1
XFILLER_50_139 VGND VGND VPWR VPWR sky130_fd_sc_hd__fill_1
X_3881_ clknet_leaf_20_clk _0004_ VGND VGND VPWR VPWR net68 sky130_fd_sc_hd__dfxtp_1
XTAP_TAPCELL_ROW_61_657 VGND VPWR sky130_fd_sc_hd__tapvpwrvgnd_1
XFILLER_31_364 VGND VGND VPWR VPWR sky130_fd_sc_hd__decap_3
X_2832_ net150 _0772_ net128 VGND VGND VPWR VPWR _0773_ sky130_fd_sc_hd__o21ai_1
X_2763_ mantisaresult\[11\] net111 _0673_ net131 VGND VGND VPWR VPWR _0705_ sky130_fd_sc_hd__o2bb2a_1
XFILLER_31_397 VGND VGND VPWR VPWR sky130_fd_sc_hd__fill_1
X_2694_ mantisaresult\[26\] net154 VGND VGND VPWR VPWR _0637_ sky130_fd_sc_hd__nand2_1
XFILLER_6_83 VGND VGND VPWR VPWR sky130_fd_sc_hd__fill_1
X_3315_ _0743_ _0799_ _1190_ _1191_ VGND VGND VPWR VPWR _1192_ sky130_fd_sc_hd__a211o_1
X_3246_ _1114_ _1117_ _1115_ VGND VGND VPWR VPWR _1129_ sky130_fd_sc_hd__o21a_1
XTAP_TAPCELL_ROW_69_724 VGND VPWR sky130_fd_sc_hd__tapvpwrvgnd_1
X_3177_ mantisaAshift\[43\] mantisaBshift\[43\] VGND VGND VPWR VPWR _1066_ sky130_fd_sc_hd__nand2_1
XTAP_TAPCELL_ROW_77_790 VGND VPWR sky130_fd_sc_hd__tapvpwrvgnd_1
X_2128_ _1756_ _1777_ _1785_ _1776_ VGND VGND VPWR VPWR _1789_ sky130_fd_sc_hd__a211o_1
XFILLER_54_445 VGND VGND VPWR VPWR sky130_fd_sc_hd__decap_3
XFILLER_14_309 VGND VGND VPWR VPWR sky130_fd_sc_hd__decap_8
X_2059_ net212 _1746_ VGND VGND VPWR VPWR _0007_ sky130_fd_sc_hd__or2_1
XFILLER_25_37 VGND VGND VPWR VPWR sky130_fd_sc_hd__fill_1
XFILLER_41_25 VGND VGND VPWR VPWR sky130_fd_sc_hd__fill_1
XFILLER_1_279 VGND VGND VPWR VPWR sky130_fd_sc_hd__fill_1
XFILLER_45_412 VGND VGND VPWR VPWR sky130_fd_sc_hd__fill_1
XFILLER_64_209 VGND VGND VPWR VPWR sky130_fd_sc_hd__decap_6
XFILLER_17_125 VGND VGND VPWR VPWR sky130_fd_sc_hd__decap_4
XFILLER_72_231 VPWR VGND VPWR VGND sky130_ef_sc_hd__decap_12
XFILLER_72_253 VGND VGND VPWR VPWR sky130_fd_sc_hd__decap_6
XFILLER_60_459 VGND VGND VPWR VPWR sky130_fd_sc_hd__decap_6
XFILLER_15_92 VGND VGND VPWR VPWR sky130_fd_sc_hd__decap_4
XFILLER_40_172 VGND VGND VPWR VPWR sky130_fd_sc_hd__fill_1
X_3100_ mantisaBshift\[29\] mantisaBshift\[30\] _0997_ VGND VGND VPWR VPWR _1002_
+ sky130_fd_sc_hd__or3_1
Xoutput91 net91 VGND VGND VPWR VPWR mantisa[4] sky130_fd_sc_hd__buf_2
Xoutput80 net80 VGND VGND VPWR VPWR mantisa[15] sky130_fd_sc_hd__buf_2
X_4080_ clknet_leaf_21_clk _0189_ VGND VGND VPWR VPWR expadd\[4\] sky130_fd_sc_hd__dfxtp_1
X_3031_ _0948_ _0949_ mantisaresult\[15\] net234 VGND VGND VPWR VPWR _0122_ sky130_fd_sc_hd__a2bb2o_1
XFILLER_36_445 VPWR VGND VPWR VGND sky130_ef_sc_hd__decap_12
XFILLER_51_404 VGND VGND VPWR VPWR sky130_fd_sc_hd__decap_8
XTAP_TAPCELL_ROW_74_760 VGND VPWR sky130_fd_sc_hd__tapvpwrvgnd_1
XFILLER_16_191 VGND VGND VPWR VPWR sky130_fd_sc_hd__fill_1
XFILLER_16_180 VGND VGND VPWR VPWR sky130_fd_sc_hd__decap_4
X_3933_ clknet_leaf_6_clk _0056_ VGND VGND VPWR VPWR mantisaA0\[7\] sky130_fd_sc_hd__dfxtp_1
X_3864_ clknet_leaf_9_clk net289 VGND VGND VPWR VPWR mantisaAshift\[49\] sky130_fd_sc_hd__dfxtp_1
X_2815_ net150 net149 VGND VGND VPWR VPWR _0757_ sky130_fd_sc_hd__nand2_1
X_3795_ net256 _1589_ VGND VGND VPWR VPWR _1604_ sky130_fd_sc_hd__nor2_1
X_2746_ _0685_ _0688_ net116 VGND VGND VPWR VPWR _0689_ sky130_fd_sc_hd__mux2_1
X_2677_ mantisaresult\[4\] net152 net130 VGND VGND VPWR VPWR _0620_ sky130_fd_sc_hd__and3_1
XTAP_TAPCELL_ROW_29_407 VGND VPWR sky130_fd_sc_hd__tapvpwrvgnd_1
XFILLER_46_209 VGND VGND VPWR VPWR sky130_fd_sc_hd__decap_8
X_3229_ net221 _1113_ net204 VGND VGND VPWR VPWR _0156_ sky130_fd_sc_hd__mux2_1
XFILLER_54_275 VGND VGND VPWR VPWR sky130_fd_sc_hd__fill_1
XFILLER_42_459 VGND VGND VPWR VPWR sky130_fd_sc_hd__fill_1
XFILLER_33_459 VPWR VGND VPWR VGND sky130_ef_sc_hd__decap_12
XTAP_TAPCELL_ROW_71_741 VGND VPWR sky130_fd_sc_hd__tapvpwrvgnd_1
XFILLER_60_289 VGND VGND VPWR VPWR sky130_fd_sc_hd__fill_2
X_2600_ _0524_ _0539_ _0541_ _0542_ VGND VGND VPWR VPWR _0543_ sky130_fd_sc_hd__or4b_2
X_3580_ _1390_ _1411_ net119 VGND VGND VPWR VPWR _1412_ sky130_fd_sc_hd__mux2_1
X_2531_ _0309_ _0310_ _0325_ _0473_ VGND VGND VPWR VPWR _0474_ sky130_fd_sc_hd__nor4_1
XFILLER_5_393 VGND VGND VPWR VPWR sky130_fd_sc_hd__decap_3
X_2462_ _0400_ _0401_ _0404_ VGND VGND VPWR VPWR _0405_ sky130_fd_sc_hd__nor3b_1
X_2393_ mantisaresult\[50\] net221 _0333_ _0334_ VGND VGND VPWR VPWR _0336_ sky130_fd_sc_hd__or4_1
XFILLER_3_51 VGND VGND VPWR VPWR sky130_fd_sc_hd__decap_4
X_4132_ clknet_leaf_6_clk _0239_ VGND VGND VPWR VPWR mantisaBshift\[45\] sky130_fd_sc_hd__dfxtp_1
X_4063_ clknet_leaf_11_clk _0174_ VGND VGND VPWR VPWR mantisaresult\[63\] sky130_fd_sc_hd__dfxtp_2
X_3014_ _0806_ _0822_ net143 VGND VGND VPWR VPWR _0935_ sky130_fd_sc_hd__mux2_1
XFILLER_36_253 VPWR VGND VPWR VGND sky130_ef_sc_hd__decap_12
XTAP_TAPCELL_ROW_34_443 VGND VPWR sky130_fd_sc_hd__tapvpwrvgnd_1
XFILLER_51_234 VPWR VGND VPWR VGND sky130_ef_sc_hd__decap_12
X_3916_ clknet_leaf_29_clk _0039_ VGND VGND VPWR VPWR expmiddle\[6\] sky130_fd_sc_hd__dfxtp_1
XFILLER_32_470 VGND VGND VPWR VPWR sky130_fd_sc_hd__decap_3
X_3847_ net192 _1602_ VGND VGND VPWR VPWR _0266_ sky130_fd_sc_hd__and2_1
X_3778_ _1560_ _1554_ net261 VGND VGND VPWR VPWR _1593_ sky130_fd_sc_hd__mux2_1
X_2729_ _0668_ _0671_ net115 VGND VGND VPWR VPWR _0672_ sky130_fd_sc_hd__mux2_1
Xfanout111 net112 VGND VGND VPWR VPWR net111 sky130_fd_sc_hd__clkbuf_2
Xfanout122 _0605_ VGND VGND VPWR VPWR net122 sky130_fd_sc_hd__clkbuf_4
Xfanout100 net101 VGND VGND VPWR VPWR net100 sky130_fd_sc_hd__clkbuf_4
Xfanout144 net147 VGND VGND VPWR VPWR net144 sky130_fd_sc_hd__buf_2
Xfanout155 net156 VGND VGND VPWR VPWR net155 sky130_fd_sc_hd__buf_2
Xfanout133 net134 VGND VGND VPWR VPWR net133 sky130_fd_sc_hd__clkbuf_2
XFILLER_59_345 VGND VGND VPWR VPWR sky130_fd_sc_hd__decap_6
Xfanout166 _0568_ VGND VGND VPWR VPWR net166 sky130_fd_sc_hd__clkbuf_4
Xfanout177 _1758_ VGND VGND VPWR VPWR net177 sky130_fd_sc_hd__clkbuf_4
Xfanout188 _0309_ VGND VGND VPWR VPWR net188 sky130_fd_sc_hd__buf_2
Xfanout199 net200 VGND VGND VPWR VPWR net199 sky130_fd_sc_hd__dlymetal6s2s_1
XPHY_EDGE_ROW_29_Right_29 VGND VGND VPWR VPWR sky130_fd_sc_hd__decap_3
XFILLER_63_34 VGND VGND VPWR VPWR sky130_fd_sc_hd__fill_2
XFILLER_23_470 VGND VGND VPWR VPWR sky130_fd_sc_hd__decap_3
XPHY_EDGE_ROW_38_Right_38 VGND VGND VPWR VPWR sky130_fd_sc_hd__decap_3
XFILLER_10_175 VGND VGND VPWR VPWR sky130_fd_sc_hd__decap_4
XFILLER_10_197 VPWR VGND VPWR VGND sky130_ef_sc_hd__decap_12
XFILLER_12_82 VGND VGND VPWR VPWR sky130_fd_sc_hd__fill_2
XPHY_EDGE_ROW_47_Right_47 VGND VGND VPWR VPWR sky130_fd_sc_hd__decap_3
XFILLER_77_197 VGND VGND VPWR VPWR sky130_fd_sc_hd__fill_1
XFILLER_77_175 VGND VGND VPWR VPWR sky130_fd_sc_hd__fill_1
XFILLER_65_326 VGND VGND VPWR VPWR sky130_fd_sc_hd__fill_1
XTAP_TAPCELL_ROW_48_557 VGND VPWR sky130_fd_sc_hd__tapvpwrvgnd_1
XFILLER_18_286 VPWR VGND VPWR VGND sky130_ef_sc_hd__decap_12
XFILLER_18_253 VPWR VGND VPWR VGND sky130_ef_sc_hd__decap_12
XFILLER_33_223 VGND VGND VPWR VPWR sky130_fd_sc_hd__fill_1
XFILLER_33_234 VPWR VGND VPWR VGND sky130_ef_sc_hd__decap_12
X_1962_ net40 VGND VGND VPWR VPWR _1657_ sky130_fd_sc_hd__inv_2
XPHY_EDGE_ROW_56_Right_56 VGND VGND VPWR VPWR sky130_fd_sc_hd__decap_3
X_3701_ _1525_ _1522_ net263 VGND VGND VPWR VPWR _1527_ sky130_fd_sc_hd__mux2_1
X_3632_ net186 _1462_ VGND VGND VPWR VPWR _0210_ sky130_fd_sc_hd__nor2_1
X_3563_ mantisaresult\[59\] net199 net160 net215 VGND VGND VPWR VPWR _1397_ sky130_fd_sc_hd__a31o_1
X_2514_ mantisaresult\[7\] _0430_ _0436_ VGND VGND VPWR VPWR _0457_ sky130_fd_sc_hd__and3_1
X_3494_ _0921_ _0931_ VGND VGND VPWR VPWR _1333_ sky130_fd_sc_hd__nand2_1
X_2445_ mantisaresult\[36\] _0313_ _0318_ _0384_ _0387_ VGND VGND VPWR VPWR _0388_
+ sky130_fd_sc_hd__a311o_1
XPHY_EDGE_ROW_65_Right_65 VGND VGND VPWR VPWR sky130_fd_sc_hd__decap_3
X_4115_ clknet_leaf_24_clk _0222_ VGND VGND VPWR VPWR mantisaBshift\[7\] sky130_fd_sc_hd__dfxtp_1
X_2376_ mantisaresult\[36\] mantisaresult\[35\] VGND VGND VPWR VPWR _0319_ sky130_fd_sc_hd__or2_1
XFILLER_56_359 VGND VGND VPWR VPWR sky130_fd_sc_hd__decap_4
X_4046_ clknet_leaf_14_clk _0157_ VGND VGND VPWR VPWR mantisaresult\[47\] sky130_fd_sc_hd__dfxtp_2
XFILLER_17_49 VGND VGND VPWR VPWR sky130_fd_sc_hd__decap_6
XFILLER_71_329 VGND VGND VPWR VPWR sky130_fd_sc_hd__decap_6
XFILLER_12_418 VGND VGND VPWR VPWR sky130_fd_sc_hd__fill_2
XFILLER_24_267 VPWR VGND VPWR VGND sky130_ef_sc_hd__decap_12
XPHY_EDGE_ROW_74_Right_74 VGND VGND VPWR VPWR sky130_fd_sc_hd__decap_3
XFILLER_3_105 VGND VGND VPWR VPWR sky130_fd_sc_hd__decap_6
XFILLER_3_149 VPWR VGND VPWR VGND sky130_ef_sc_hd__decap_12
XFILLER_58_12 VGND VGND VPWR VPWR sky130_fd_sc_hd__decap_3
XFILLER_59_186 VGND VGND VPWR VPWR sky130_fd_sc_hd__decap_4
XFILLER_74_123 VGND VGND VPWR VPWR sky130_fd_sc_hd__fill_1
XFILLER_47_359 VGND VGND VPWR VPWR sky130_fd_sc_hd__fill_1
XTAP_TAPCELL_ROW_53_593 VGND VPWR sky130_fd_sc_hd__tapvpwrvgnd_1
X_2230_ net51 net168 VGND VGND VPWR VPWR _1875_ sky130_fd_sc_hd__and2_1
X_2161_ _1649_ net48 net47 _1650_ VGND VGND VPWR VPWR _1822_ sky130_fd_sc_hd__a22o_1
XFILLER_38_326 VGND VGND VPWR VPWR sky130_fd_sc_hd__fill_1
X_2092_ net211 net323 VGND VGND VPWR VPWR _0032_ sky130_fd_sc_hd__and2b_1
XFILLER_0_41 VPWR VGND VPWR VGND sky130_ef_sc_hd__decap_12
XFILLER_0_85 VGND VGND VPWR VPWR sky130_fd_sc_hd__fill_2
X_2994_ _0915_ _0916_ mantisaresult\[12\] net232 VGND VGND VPWR VPWR _0118_ sky130_fd_sc_hd__a2bb2o_1
X_1945_ mantisaresult\[57\] VGND VGND VPWR VPWR _1640_ sky130_fd_sc_hd__inv_2
XFILLER_9_94 VGND VGND VPWR VPWR sky130_fd_sc_hd__fill_2
X_3615_ net250 mantisaB0\[15\] net273 VGND VGND VPWR VPWR _1446_ sky130_fd_sc_hd__and3b_1
X_3546_ _1357_ _1380_ net118 VGND VGND VPWR VPWR _1381_ sky130_fd_sc_hd__mux2_1
X_3477_ net137 _1321_ _1322_ VGND VGND VPWR VPWR _1323_ sky130_fd_sc_hd__o21a_1
X_2428_ mantisaresult\[37\] net229 _0319_ VGND VGND VPWR VPWR _0371_ sky130_fd_sc_hd__or3_2
X_2359_ mantisaresult\[57\] mantisaresult\[56\] VGND VGND VPWR VPWR _0302_ sky130_fd_sc_hd__or2_1
X_4029_ clknet_leaf_12_clk _0140_ VGND VGND VPWR VPWR mantisaresult\[32\] sky130_fd_sc_hd__dfxtp_2
XFILLER_56_167 VGND VGND VPWR VPWR sky130_fd_sc_hd__fill_2
XFILLER_71_137 VGND VGND VPWR VPWR sky130_fd_sc_hd__decap_8
XTAP_TAPCELL_ROW_42_508 VGND VPWR sky130_fd_sc_hd__tapvpwrvgnd_1
XTAP_TAPCELL_ROW_50_574 VGND VPWR sky130_fd_sc_hd__tapvpwrvgnd_1
XFILLER_60_35 VGND VGND VPWR VPWR sky130_fd_sc_hd__fill_1
XFILLER_60_79 VGND VGND VPWR VPWR sky130_fd_sc_hd__decap_4
XFILLER_4_469 VGND VGND VPWR VPWR sky130_fd_sc_hd__decap_4
XFILLER_69_55 VGND VGND VPWR VPWR sky130_fd_sc_hd__fill_1
XFILLER_79_237 VPWR VGND VPWR VGND sky130_ef_sc_hd__decap_12
XTAP_TAPCELL_ROW_7_230 VGND VPWR sky130_fd_sc_hd__tapvpwrvgnd_1
XFILLER_35_318 VGND VGND VPWR VPWR sky130_fd_sc_hd__fill_1
XFILLER_28_392 VGND VGND VPWR VPWR sky130_fd_sc_hd__fill_1
XFILLER_62_148 VGND VGND VPWR VPWR sky130_fd_sc_hd__decap_8
XFILLER_43_384 VGND VGND VPWR VPWR sky130_fd_sc_hd__decap_3
XFILLER_70_181 VGND VGND VPWR VPWR sky130_fd_sc_hd__decap_3
XTAP_TAPCELL_ROW_13_276 VGND VPWR sky130_fd_sc_hd__tapvpwrvgnd_1
Xwire183 _0323_ VGND VGND VPWR VPWR net183 sky130_fd_sc_hd__clkbuf_1
X_3400_ _1255_ _1259_ _1256_ VGND VGND VPWR VPWR _1269_ sky130_fd_sc_hd__a21oi_1
X_3331_ _1198_ _1206_ VGND VGND VPWR VPWR _1207_ sky130_fd_sc_hd__xnor2_1
X_3262_ _1142_ VGND VGND VPWR VPWR _1143_ sky130_fd_sc_hd__inv_2
X_2213_ net3 net11 net98 VGND VGND VPWR VPWR _1865_ sky130_fd_sc_hd__mux2_1
X_3193_ _1074_ _1080_ net129 VGND VGND VPWR VPWR _1081_ sky130_fd_sc_hd__a21oi_1
XFILLER_66_421 VPWR VGND VPWR VGND sky130_ef_sc_hd__decap_12
XFILLER_38_134 VGND VGND VPWR VPWR sky130_fd_sc_hd__decap_6
X_2144_ net39 _1664_ _1665_ net38 _1804_ VGND VGND VPWR VPWR _1805_ sky130_fd_sc_hd__o221a_1
XFILLER_19_381 VGND VGND VPWR VPWR sky130_fd_sc_hd__decap_3
X_2075_ inf3 net329 VGND VGND VPWR VPWR _0015_ sky130_fd_sc_hd__and2b_1
XFILLER_34_395 VGND VGND VPWR VPWR sky130_fd_sc_hd__fill_2
X_2977_ mantisaBshift\[7\] _0901_ net240 VGND VGND VPWR VPWR _0904_ sky130_fd_sc_hd__o21ai_1
X_1928_ expmiddlec\[6\] VGND VGND VPWR VPWR _1623_ sky130_fd_sc_hd__inv_2
XFILLER_1_417 VPWR VGND VPWR VGND sky130_ef_sc_hd__decap_12
X_3529_ net336 net207 _1363_ _1365_ VGND VGND VPWR VPWR _0204_ sky130_fd_sc_hd__o22a_1
XTAP_TAPCELL_ROW_4_200 VGND VPWR sky130_fd_sc_hd__tapvpwrvgnd_1
XPHY_EDGE_ROW_24_Left_104 VGND VGND VPWR VPWR sky130_fd_sc_hd__decap_3
XFILLER_29_145 VPWR VGND VPWR VGND sky130_ef_sc_hd__decap_12
XFILLER_55_35 VGND VGND VPWR VPWR sky130_fd_sc_hd__decap_4
XFILLER_72_413 VGND VGND VPWR VPWR sky130_fd_sc_hd__decap_6
XFILLER_29_189 VGND VGND VPWR VPWR sky130_fd_sc_hd__decap_6
XTAP_TAPCELL_ROW_55_611 VGND VPWR sky130_fd_sc_hd__tapvpwrvgnd_1
XFILLER_72_457 VPWR VGND VPWR VGND sky130_ef_sc_hd__decap_12
XFILLER_40_343 VGND VGND VPWR VPWR sky130_fd_sc_hd__decap_8
XPHY_EDGE_ROW_33_Left_113 VGND VGND VPWR VPWR sky130_fd_sc_hd__decap_3
XFILLER_40_365 VGND VGND VPWR VPWR sky130_fd_sc_hd__fill_1
XFILLER_40_398 VPWR VGND VPWR VGND sky130_ef_sc_hd__decap_12
XFILLER_4_233 VPWR VGND VPWR VGND sky130_ef_sc_hd__decap_12
XFILLER_20_60 VGND VGND VPWR VPWR sky130_fd_sc_hd__fill_1
XPHY_EDGE_ROW_42_Left_122 VGND VGND VPWR VPWR sky130_fd_sc_hd__decap_3
XFILLER_0_461 VPWR VGND VPWR VGND sky130_ef_sc_hd__decap_12
XFILLER_48_421 VGND VGND VPWR VPWR sky130_fd_sc_hd__decap_8
XFILLER_48_443 VGND VGND VPWR VPWR sky130_fd_sc_hd__fill_1
Xhold91 op0 VGND VGND VPWR VPWR net365 sky130_fd_sc_hd__dlygate4sd3_1
Xhold80 four_man\[55\] VGND VGND VPWR VPWR net354 sky130_fd_sc_hd__dlygate4sd3_1
XTAP_TAPCELL_ROW_18_313 VGND VPWR sky130_fd_sc_hd__tapvpwrvgnd_1
XFILLER_35_126 VGND VGND VPWR VPWR sky130_fd_sc_hd__fill_1
XFILLER_16_373 VGND VGND VPWR VPWR sky130_fd_sc_hd__fill_1
X_2900_ net144 _0663_ _0838_ VGND VGND VPWR VPWR _0839_ sky130_fd_sc_hd__a21oi_1
X_3880_ clknet_leaf_20_clk _0003_ VGND VGND VPWR VPWR net67 sky130_fd_sc_hd__dfxtp_1
XPHY_EDGE_ROW_51_Left_131 VGND VGND VPWR VPWR sky130_fd_sc_hd__decap_3
XTAP_TAPCELL_ROW_61_658 VGND VPWR sky130_fd_sc_hd__tapvpwrvgnd_1
X_2831_ _0767_ _0771_ net122 VGND VGND VPWR VPWR _0772_ sky130_fd_sc_hd__mux2_1
X_2762_ _0703_ VGND VGND VPWR VPWR _0704_ sky130_fd_sc_hd__inv_2
X_2693_ mantisaresult\[25\] net108 _0635_ net132 VGND VGND VPWR VPWR _0636_ sky130_fd_sc_hd__a22o_1
XPHY_EDGE_ROW_60_Left_140 VGND VGND VPWR VPWR sky130_fd_sc_hd__decap_3
X_3314_ _0808_ _0925_ net127 VGND VGND VPWR VPWR _1191_ sky130_fd_sc_hd__a21o_1
X_3245_ net245 _1127_ VGND VGND VPWR VPWR _1128_ sky130_fd_sc_hd__nand2_1
XTAP_TAPCELL_ROW_69_725 VGND VPWR sky130_fd_sc_hd__tapvpwrvgnd_1
X_3176_ mantisaAshift\[43\] mantisaBshift\[43\] VGND VGND VPWR VPWR _1065_ sky130_fd_sc_hd__nor2_1
XTAP_TAPCELL_ROW_77_791 VGND VPWR sky130_fd_sc_hd__tapvpwrvgnd_1
X_2127_ _1780_ _1781_ _1783_ _1787_ VGND VGND VPWR VPWR _1788_ sky130_fd_sc_hd__or4_1
X_2058_ _1744_ _1745_ VGND VGND VPWR VPWR _1746_ sky130_fd_sc_hd__xnor2_1
XFILLER_22_321 VPWR VGND VPWR VGND sky130_ef_sc_hd__decap_12
XFILLER_22_365 VGND VGND VPWR VPWR sky130_fd_sc_hd__decap_3
XFILLER_1_225 VPWR VGND VPWR VGND sky130_ef_sc_hd__decap_12
XFILLER_49_229 VGND VGND VPWR VPWR sky130_fd_sc_hd__decap_4
XFILLER_66_23 VGND VGND VPWR VPWR sky130_fd_sc_hd__decap_4
XFILLER_45_435 VGND VGND VPWR VPWR sky130_fd_sc_hd__decap_4
XFILLER_72_243 VGND VGND VPWR VPWR sky130_fd_sc_hd__decap_8
XFILLER_72_276 VPWR VGND VPWR VGND sky130_ef_sc_hd__decap_12
XFILLER_13_310 VPWR VGND VPWR VGND sky130_ef_sc_hd__decap_12
XFILLER_25_181 VGND VGND VPWR VPWR sky130_fd_sc_hd__decap_3
XFILLER_40_195 VGND VGND VPWR VPWR sky130_fd_sc_hd__fill_1
XFILLER_31_70 VGND VGND VPWR VPWR sky130_fd_sc_hd__decap_6
Xoutput70 net70 VGND VGND VPWR VPWR exp[4] sky130_fd_sc_hd__buf_2
Xoutput92 net92 VGND VGND VPWR VPWR mantisa[5] sky130_fd_sc_hd__buf_2
Xoutput81 net81 VGND VGND VPWR VPWR mantisa[16] sky130_fd_sc_hd__buf_2
X_3030_ net237 mantisaBshift\[15\] _0947_ net234 VGND VGND VPWR VPWR _0949_ sky130_fd_sc_hd__a31o_1
XFILLER_48_273 VGND VGND VPWR VPWR sky130_fd_sc_hd__decap_8
XFILLER_36_457 VPWR VGND VPWR VGND sky130_ef_sc_hd__decap_12
XTAP_TAPCELL_ROW_74_761 VGND VPWR sky130_fd_sc_hd__tapvpwrvgnd_1
X_3932_ clknet_leaf_6_clk _0055_ VGND VGND VPWR VPWR mantisaA0\[6\] sky130_fd_sc_hd__dfxtp_1
X_3863_ clknet_leaf_9_clk net282 VGND VGND VPWR VPWR mantisaAshift\[48\] sky130_fd_sc_hd__dfxtp_1
X_2814_ net151 net122 VGND VGND VPWR VPWR _0756_ sky130_fd_sc_hd__nor2_2
X_3794_ net184 _1586_ _1603_ _1418_ VGND VGND VPWR VPWR _0231_ sky130_fd_sc_hd__a22o_1
X_2745_ net131 _0686_ net111 mantisaresult\[18\] VGND VGND VPWR VPWR _0688_ sky130_fd_sc_hd__a2bb2o_1
X_2676_ mantisaresult\[4\] net153 VGND VGND VPWR VPWR _0619_ sky130_fd_sc_hd__nand2_1
XFILLER_27_402 VGND VGND VPWR VPWR sky130_fd_sc_hd__decap_8
X_3228_ _1107_ _1112_ VGND VGND VPWR VPWR _1113_ sky130_fd_sc_hd__xnor2_1
XFILLER_39_295 VGND VGND VPWR VPWR sky130_fd_sc_hd__decap_3
X_3159_ _1048_ _1049_ VGND VGND VPWR VPWR _1050_ sky130_fd_sc_hd__nand2b_1
XFILLER_22_162 VGND VGND VPWR VPWR sky130_fd_sc_hd__decap_3
XFILLER_52_58 VPWR VGND VPWR VGND sky130_ef_sc_hd__decap_12
XTAP_TAPCELL_ROW_20_330 VGND VPWR sky130_fd_sc_hd__tapvpwrvgnd_1
XFILLER_6_306 VGND VGND VPWR VPWR sky130_fd_sc_hd__fill_2
XFILLER_22_195 VGND VGND VPWR VPWR sky130_fd_sc_hd__fill_1
XFILLER_77_44 VPWR VGND VPWR VGND sky130_ef_sc_hd__decap_12
XFILLER_77_335 VGND VGND VPWR VPWR sky130_fd_sc_hd__fill_1
Xclkbuf_leaf_25_clk clknet_2_0__leaf_clk VGND VGND VPWR VPWR clknet_leaf_25_clk sky130_fd_sc_hd__clkbuf_8
XFILLER_60_246 VGND VGND VPWR VPWR sky130_fd_sc_hd__decap_6
XTAP_TAPCELL_ROW_71_742 VGND VPWR sky130_fd_sc_hd__tapvpwrvgnd_1
XFILLER_13_173 VGND VGND VPWR VPWR sky130_fd_sc_hd__fill_1
X_2530_ net223 net224 mantisaresult\[42\] net226 VGND VGND VPWR VPWR _0473_ sky130_fd_sc_hd__or4b_1
X_2461_ mantisaresult\[51\] net188 _0336_ _0403_ VGND VGND VPWR VPWR _0404_ sky130_fd_sc_hd__or4_1
X_2392_ _0334_ VGND VGND VPWR VPWR _0335_ sky130_fd_sc_hd__inv_2
X_4131_ clknet_leaf_6_clk _0238_ VGND VGND VPWR VPWR mantisaBshift\[46\] sky130_fd_sc_hd__dfxtp_1
XFILLER_68_346 VGND VGND VPWR VPWR sky130_fd_sc_hd__fill_1
X_4062_ clknet_leaf_11_clk _0173_ VGND VGND VPWR VPWR mantisaresult\[62\] sky130_fd_sc_hd__dfxtp_1
X_3013_ _0924_ _0933_ net125 VGND VGND VPWR VPWR _0934_ sky130_fd_sc_hd__o21a_1
XFILLER_36_265 VPWR VGND VPWR VGND sky130_ef_sc_hd__decap_12
XFILLER_36_287 VPWR VGND VPWR VGND sky130_ef_sc_hd__decap_12
XFILLER_51_202 VGND VGND VPWR VPWR sky130_fd_sc_hd__decap_4
XFILLER_51_213 VGND VGND VPWR VPWR sky130_fd_sc_hd__decap_8
XFILLER_51_246 VGND VGND VPWR VPWR sky130_fd_sc_hd__decap_6
Xclkbuf_leaf_16_clk clknet_2_3__leaf_clk VGND VGND VPWR VPWR clknet_leaf_16_clk sky130_fd_sc_hd__clkbuf_8
X_3915_ clknet_leaf_29_clk _0038_ VGND VGND VPWR VPWR expmiddle\[5\] sky130_fd_sc_hd__dfxtp_1
XTAP_TAPCELL_ROW_34_444 VGND VPWR sky130_fd_sc_hd__tapvpwrvgnd_1
X_3846_ _1499_ _1601_ VGND VGND VPWR VPWR _0265_ sky130_fd_sc_hd__and2_1
X_3777_ _1418_ _1592_ VGND VGND VPWR VPWR _0225_ sky130_fd_sc_hd__and2_1
X_2728_ mantisaresult\[11\] net108 _0670_ VGND VGND VPWR VPWR _0671_ sky130_fd_sc_hd__a21o_1
X_2659_ _1624_ _0582_ _0601_ VGND VGND VPWR VPWR _0602_ sky130_fd_sc_hd__mux2_2
Xfanout112 _0612_ VGND VGND VPWR VPWR net112 sky130_fd_sc_hd__clkbuf_2
Xfanout101 _1835_ VGND VGND VPWR VPWR net101 sky130_fd_sc_hd__buf_2
Xfanout123 _0605_ VGND VGND VPWR VPWR net123 sky130_fd_sc_hd__clkbuf_4
Xfanout156 _0609_ VGND VGND VPWR VPWR net156 sky130_fd_sc_hd__clkbuf_2
Xfanout134 net135 VGND VGND VPWR VPWR net134 sky130_fd_sc_hd__buf_1
Xfanout145 net147 VGND VGND VPWR VPWR net145 sky130_fd_sc_hd__clkbuf_2
Xfanout178 _1758_ VGND VGND VPWR VPWR net178 sky130_fd_sc_hd__buf_2
Xfanout189 net190 VGND VGND VPWR VPWR net189 sky130_fd_sc_hd__buf_2
XFILLER_27_221 VGND VGND VPWR VPWR sky130_fd_sc_hd__decap_3
XFILLER_15_405 VPWR VGND VPWR VGND sky130_ef_sc_hd__decap_12
XFILLER_15_449 VPWR VGND VPWR VGND sky130_ef_sc_hd__decap_12
XFILLER_27_298 VPWR VGND VPWR VGND sky130_ef_sc_hd__decap_12
XFILLER_6_158 VPWR VGND VPWR VGND sky130_ef_sc_hd__decap_12
XTAP_TAPCELL_ROW_48_558 VGND VPWR sky130_fd_sc_hd__tapvpwrvgnd_1
XFILLER_18_265 VGND VGND VPWR VPWR sky130_fd_sc_hd__fill_1
XFILLER_18_298 VGND VGND VPWR VPWR sky130_fd_sc_hd__decap_8
XFILLER_73_393 VPWR VGND VPWR VGND sky130_ef_sc_hd__decap_12
XFILLER_33_246 VGND VGND VPWR VPWR sky130_fd_sc_hd__decap_4
XFILLER_33_257 VPWR VGND VPWR VGND sky130_ef_sc_hd__decap_12
X_1961_ net51 VGND VGND VPWR VPWR _1656_ sky130_fd_sc_hd__inv_2
X_3700_ _1525_ VGND VGND VPWR VPWR _1526_ sky130_fd_sc_hd__inv_2
X_3631_ net254 _1461_ _1439_ VGND VGND VPWR VPWR _1462_ sky130_fd_sc_hd__a21o_1
X_3562_ net158 _1395_ VGND VGND VPWR VPWR _1396_ sky130_fd_sc_hd__and2_1
X_2513_ _0445_ _0446_ _0452_ _0455_ VGND VGND VPWR VPWR _0456_ sky130_fd_sc_hd__and4bb_1
X_3493_ net319 expmiddlec\[7\] net230 VGND VGND VPWR VPWR _0201_ sky130_fd_sc_hd__mux2_1
Xclkbuf_leaf_5_clk clknet_2_1__leaf_clk VGND VGND VPWR VPWR clknet_leaf_5_clk sky130_fd_sc_hd__clkbuf_8
X_2444_ net218 _0305_ _0326_ _0386_ VGND VGND VPWR VPWR _0387_ sky130_fd_sc_hd__and4b_1
X_2375_ _0315_ _0316_ _0317_ VGND VGND VPWR VPWR _0318_ sky130_fd_sc_hd__nor3_1
X_4114_ clknet_leaf_24_clk _0221_ VGND VGND VPWR VPWR mantisaBshift\[8\] sky130_fd_sc_hd__dfxtp_1
XFILLER_68_154 VPWR VGND VPWR VGND sky130_ef_sc_hd__decap_12
X_4045_ clknet_leaf_11_clk _0156_ VGND VGND VPWR VPWR mantisaresult\[46\] sky130_fd_sc_hd__dfxtp_1
XFILLER_24_279 VGND VGND VPWR VPWR sky130_fd_sc_hd__fill_1
X_3829_ net257 _1546_ _1614_ net190 VGND VGND VPWR VPWR _1615_ sky130_fd_sc_hd__a211o_1
XFILLER_74_23 VGND VGND VPWR VPWR sky130_fd_sc_hd__decap_4
XFILLER_15_202 VPWR VGND VPWR VGND sky130_ef_sc_hd__decap_12
XFILLER_74_45 VGND VGND VPWR VPWR sky130_fd_sc_hd__fill_2
XTAP_TAPCELL_ROW_45_528 VGND VPWR sky130_fd_sc_hd__tapvpwrvgnd_1
XFILLER_55_393 VGND VGND VPWR VPWR sky130_fd_sc_hd__fill_2
XFILLER_15_279 VGND VGND VPWR VPWR sky130_fd_sc_hd__fill_1
XTAP_TAPCELL_ROW_53_594 VGND VPWR sky130_fd_sc_hd__tapvpwrvgnd_1
X_2160_ _1818_ _1819_ _1820_ VGND VGND VPWR VPWR _1821_ sky130_fd_sc_hd__and3b_1
XFILLER_65_113 VPWR VGND VPWR VGND sky130_ef_sc_hd__decap_12
X_2091_ net211 net332 VGND VGND VPWR VPWR _0031_ sky130_fd_sc_hd__and2b_1
XFILLER_0_53 VGND VGND VPWR VPWR sky130_fd_sc_hd__decap_3
X_2993_ net238 mantisaBshift\[12\] _0914_ net230 VGND VGND VPWR VPWR _0916_ sky130_fd_sc_hd__a31o_1
XFILLER_61_385 VGND VGND VPWR VPWR sky130_fd_sc_hd__decap_6
XTAP_TAPCELL_ROW_16_296 VGND VPWR sky130_fd_sc_hd__tapvpwrvgnd_1
XFILLER_21_238 VPWR VGND VPWR VGND sky130_ef_sc_hd__decap_12
X_1944_ mantisaresult\[61\] VGND VGND VPWR VPWR _1639_ sky130_fd_sc_hd__inv_2
XFILLER_9_84 VGND VGND VPWR VPWR sky130_fd_sc_hd__decap_4
X_3614_ _1444_ VGND VGND VPWR VPWR _1445_ sky130_fd_sc_hd__inv_2
X_3545_ mantisaresult\[58\] net109 _1379_ VGND VGND VPWR VPWR _1380_ sky130_fd_sc_hd__a21o_1
X_3476_ net137 _1292_ VGND VGND VPWR VPWR _1322_ sky130_fd_sc_hd__nand2_1
X_2427_ _0368_ _0369_ VGND VGND VPWR VPWR _0370_ sky130_fd_sc_hd__nand2_1
X_2358_ mantisaresult\[57\] mantisaresult\[56\] VGND VGND VPWR VPWR _0301_ sky130_fd_sc_hd__nor2_1
XFILLER_56_135 VGND VGND VPWR VPWR sky130_fd_sc_hd__decap_4
X_2289_ _1914_ net288 net174 VGND VGND VPWR VPWR _0069_ sky130_fd_sc_hd__mux2_1
X_4028_ clknet_leaf_2_clk _0139_ VGND VGND VPWR VPWR mantisaresult\[31\] sky130_fd_sc_hd__dfxtp_1
XFILLER_37_371 VPWR VGND VPWR VGND sky130_ef_sc_hd__decap_12
XFILLER_71_127 VGND VGND VPWR VPWR sky130_fd_sc_hd__decap_3
XTAP_TAPCELL_ROW_42_509 VGND VPWR sky130_fd_sc_hd__tapvpwrvgnd_1
XTAP_TAPCELL_ROW_50_575 VGND VPWR sky130_fd_sc_hd__tapvpwrvgnd_1
XFILLER_60_25 VGND VGND VPWR VPWR sky130_fd_sc_hd__decap_3
XFILLER_79_249 VGND VGND VPWR VPWR sky130_fd_sc_hd__decap_3
XTAP_TAPCELL_ROW_7_231 VGND VPWR sky130_fd_sc_hd__tapvpwrvgnd_1
XFILLER_18_82 VGND VGND VPWR VPWR sky130_fd_sc_hd__fill_2
XFILLER_55_190 VPWR VGND VPWR VGND sky130_ef_sc_hd__decap_12
XFILLER_43_363 VGND VGND VPWR VPWR sky130_fd_sc_hd__decap_4
XTAP_TAPCELL_ROW_13_277 VGND VPWR sky130_fd_sc_hd__tapvpwrvgnd_1
X_3330_ net246 _1205_ _1204_ VGND VGND VPWR VPWR _1206_ sky130_fd_sc_hd__o21a_1
X_3261_ mantisaAshift\[50\] mantisaBshift\[50\] VGND VGND VPWR VPWR _1142_ sky130_fd_sc_hd__nand2_1
X_2212_ net305 net178 _1864_ VGND VGND VPWR VPWR _0042_ sky130_fd_sc_hd__o21a_1
X_3192_ _0785_ _0922_ _0926_ _1079_ VGND VGND VPWR VPWR _1080_ sky130_fd_sc_hd__o22a_1
X_2143_ net37 _1662_ _1665_ net38 _1803_ VGND VGND VPWR VPWR _1804_ sky130_fd_sc_hd__a221o_1
XFILLER_66_433 VGND VGND VPWR VPWR sky130_fd_sc_hd__fill_1
X_2074_ net209 net345 VGND VGND VPWR VPWR _0014_ sky130_fd_sc_hd__and2b_1
XFILLER_34_363 VGND VGND VPWR VPWR sky130_fd_sc_hd__fill_1
XFILLER_14_29 VPWR VGND VPWR VGND sky130_ef_sc_hd__decap_12
X_2976_ _0902_ _0903_ mantisaresult\[7\] net231 VGND VGND VPWR VPWR _0113_ sky130_fd_sc_hd__a2bb2o_1
X_1927_ expmiddlec\[7\] VGND VGND VPWR VPWR _1622_ sky130_fd_sc_hd__inv_2
XFILLER_1_429 VPWR VGND VPWR VGND sky130_ef_sc_hd__decap_12
X_3528_ mantisaresult\[57\] net198 net164 _1364_ VGND VGND VPWR VPWR _1365_ sky130_fd_sc_hd__a31o_1
X_3459_ net338 net206 _1313_ _1315_ VGND VGND VPWR VPWR _0184_ sky130_fd_sc_hd__o22a_1
XTAP_TAPCELL_ROW_4_201 VGND VPWR sky130_fd_sc_hd__tapvpwrvgnd_1
XFILLER_29_113 VGND VGND VPWR VPWR sky130_fd_sc_hd__fill_2
XFILLER_57_455 VGND VGND VPWR VPWR sky130_fd_sc_hd__fill_1
XTAP_TAPCELL_ROW_55_612 VGND VPWR sky130_fd_sc_hd__tapvpwrvgnd_1
XFILLER_72_469 VGND VGND VPWR VPWR sky130_fd_sc_hd__decap_4
XFILLER_4_245 VGND VGND VPWR VPWR sky130_fd_sc_hd__decap_6
Xhold81 expmiddled\[2\] VGND VGND VPWR VPWR net355 sky130_fd_sc_hd__dlygate4sd3_1
XFILLER_29_81 VGND VGND VPWR VPWR sky130_fd_sc_hd__decap_8
Xhold70 mantisaB0\[3\] VGND VGND VPWR VPWR net344 sky130_fd_sc_hd__dlygate4sd3_1
Xhold92 mantisaB0\[9\] VGND VGND VPWR VPWR net366 sky130_fd_sc_hd__dlygate4sd3_1
XFILLER_75_285 VPWR VGND VPWR VGND sky130_ef_sc_hd__decap_12
XTAP_TAPCELL_ROW_18_314 VGND VPWR sky130_fd_sc_hd__tapvpwrvgnd_1
XFILLER_50_119 VPWR VGND VPWR VGND sky130_ef_sc_hd__decap_12
XTAP_TAPCELL_ROW_26_380 VGND VPWR sky130_fd_sc_hd__tapvpwrvgnd_1
X_2830_ _0770_ VGND VGND VPWR VPWR _0771_ sky130_fd_sc_hd__inv_2
XFILLER_31_333 VGND VGND VPWR VPWR sky130_fd_sc_hd__decap_3
XFILLER_31_344 VPWR VGND VPWR VGND sky130_ef_sc_hd__decap_12
XTAP_TAPCELL_ROW_61_659 VGND VPWR sky130_fd_sc_hd__tapvpwrvgnd_1
X_2761_ net130 _0669_ net112 mantisaresult\[9\] VGND VGND VPWR VPWR _0703_ sky130_fd_sc_hd__a2bb2o_1
X_2692_ _0634_ VGND VGND VPWR VPWR _0635_ sky130_fd_sc_hd__inv_2
XFILLER_6_41 VPWR VGND VPWR VGND sky130_ef_sc_hd__decap_12
XFILLER_6_85 VPWR VGND VPWR VGND sky130_ef_sc_hd__decap_12
X_3313_ _0823_ _0922_ VGND VGND VPWR VPWR _1190_ sky130_fd_sc_hd__nor2_1
XFILLER_39_400 VPWR VGND VPWR VGND sky130_ef_sc_hd__decap_12
X_3244_ _1116_ _1119_ _1126_ VGND VGND VPWR VPWR _1127_ sky130_fd_sc_hd__a21o_1
XTAP_TAPCELL_ROW_69_726 VGND VPWR sky130_fd_sc_hd__tapvpwrvgnd_1
XFILLER_39_466 VGND VGND VPWR VPWR sky130_fd_sc_hd__decap_6
X_3175_ net225 net236 _1063_ _1064_ VGND VGND VPWR VPWR _0151_ sky130_fd_sc_hd__a22o_1
XFILLER_66_263 VGND VGND VPWR VPWR sky130_fd_sc_hd__decap_4
X_2126_ _1785_ _1786_ VGND VGND VPWR VPWR _1787_ sky130_fd_sc_hd__or2_1
X_2057_ _1738_ _1740_ _1737_ VGND VGND VPWR VPWR _1745_ sky130_fd_sc_hd__a21bo_1
XFILLER_26_149 VGND VGND VPWR VPWR sky130_fd_sc_hd__fill_2
XFILLER_22_333 VGND VGND VPWR VPWR sky130_fd_sc_hd__fill_1
X_2959_ net222 net194 net162 net216 VGND VGND VPWR VPWR _0891_ sky130_fd_sc_hd__a31o_1
XFILLER_1_237 VPWR VGND VPWR VGND sky130_ef_sc_hd__decap_12
XFILLER_72_288 VPWR VGND VPWR VGND sky130_ef_sc_hd__decap_12
XFILLER_13_322 VPWR VGND VPWR VGND sky130_ef_sc_hd__decap_12
XFILLER_40_141 VPWR VGND VPWR VGND sky130_ef_sc_hd__decap_12
XFILLER_9_337 VPWR VGND VPWR VGND sky130_ef_sc_hd__decap_12
Xoutput71 net71 VGND VGND VPWR VPWR exp[5] sky130_fd_sc_hd__buf_2
Xoutput93 net93 VGND VGND VPWR VPWR mantisa[6] sky130_fd_sc_hd__buf_2
Xoutput82 net82 VGND VGND VPWR VPWR mantisa[17] sky130_fd_sc_hd__buf_2
XFILLER_0_281 VGND VGND VPWR VPWR sky130_fd_sc_hd__decap_8
XFILLER_48_230 VGND VGND VPWR VPWR sky130_fd_sc_hd__fill_1
XFILLER_48_285 VPWR VGND VPWR VGND sky130_ef_sc_hd__decap_12
XFILLER_36_469 VGND VGND VPWR VPWR sky130_fd_sc_hd__decap_4
XFILLER_63_222 VGND VGND VPWR VPWR sky130_fd_sc_hd__fill_2
XFILLER_51_428 VGND VGND VPWR VPWR sky130_fd_sc_hd__fill_1
XTAP_TAPCELL_ROW_74_762 VGND VPWR sky130_fd_sc_hd__tapvpwrvgnd_1
X_3931_ clknet_leaf_6_clk _0054_ VGND VGND VPWR VPWR mantisaA0\[5\] sky130_fd_sc_hd__dfxtp_1
XFILLER_31_130 VGND VGND VPWR VPWR sky130_fd_sc_hd__fill_2
X_3862_ clknet_leaf_9_clk net295 VGND VGND VPWR VPWR mantisaAshift\[47\] sky130_fd_sc_hd__dfxtp_1
X_2813_ net141 net136 _0754_ VGND VGND VPWR VPWR _0755_ sky130_fd_sc_hd__nor3_1
X_3793_ net253 _1585_ VGND VGND VPWR VPWR _1603_ sky130_fd_sc_hd__nor2_1
X_2744_ _0686_ VGND VGND VPWR VPWR _0687_ sky130_fd_sc_hd__inv_2
X_2675_ _0614_ _0617_ net115 VGND VGND VPWR VPWR _0618_ sky130_fd_sc_hd__mux2_1
X_3227_ net245 _1110_ _1111_ VGND VGND VPWR VPWR _1112_ sky130_fd_sc_hd__a21oi_1
XFILLER_36_27 VGND VGND VPWR VPWR sky130_fd_sc_hd__fill_1
X_3158_ mantisaAshift\[41\] mantisaBshift\[41\] VGND VGND VPWR VPWR _1049_ sky130_fd_sc_hd__nand2_1
X_2109_ _1765_ _1769_ VGND VGND VPWR VPWR _1770_ sky130_fd_sc_hd__or2_1
X_3089_ mantisaBshift\[26\] mantisaBshift\[27\] _0989_ VGND VGND VPWR VPWR _0994_
+ sky130_fd_sc_hd__or3_1
XTAP_TAPCELL_ROW_37_464 VGND VPWR sky130_fd_sc_hd__tapvpwrvgnd_1
XFILLER_22_141 VGND VGND VPWR VPWR sky130_fd_sc_hd__decap_4
XTAP_TAPCELL_ROW_20_331 VGND VPWR sky130_fd_sc_hd__tapvpwrvgnd_1
XFILLER_45_233 VGND VGND VPWR VPWR sky130_fd_sc_hd__fill_2
XFILLER_45_244 VGND VGND VPWR VPWR sky130_fd_sc_hd__fill_2
XFILLER_45_288 VGND VGND VPWR VPWR sky130_fd_sc_hd__decap_4
XFILLER_45_299 VPWR VGND VPWR VGND sky130_ef_sc_hd__decap_12
XFILLER_60_236 VGND VGND VPWR VPWR sky130_fd_sc_hd__fill_1
XTAP_TAPCELL_ROW_71_743 VGND VPWR sky130_fd_sc_hd__tapvpwrvgnd_1
XFILLER_41_461 VPWR VGND VPWR VGND sky130_ef_sc_hd__decap_12
XFILLER_9_156 VPWR VGND VPWR VGND sky130_ef_sc_hd__decap_12
X_2460_ net228 _0316_ _0402_ VGND VGND VPWR VPWR _0403_ sky130_fd_sc_hd__or3_1
XFILLER_54_6 VGND VGND VPWR VPWR sky130_fd_sc_hd__fill_2
XTAP_TAPCELL_ROW_79_810 VGND VPWR sky130_fd_sc_hd__tapvpwrvgnd_1
X_2391_ net222 net223 net224 VGND VGND VPWR VPWR _0334_ sky130_fd_sc_hd__or3_2
X_4130_ clknet_leaf_9_clk _0237_ VGND VGND VPWR VPWR mantisaBshift\[47\] sky130_fd_sc_hd__dfxtp_1
X_4061_ clknet_leaf_14_clk _0172_ VGND VGND VPWR VPWR mantisaresult\[61\] sky130_fd_sc_hd__dfxtp_1
XFILLER_68_369 VGND VGND VPWR VPWR sky130_fd_sc_hd__fill_1
X_3012_ _0926_ _0931_ _0932_ _0756_ VGND VGND VPWR VPWR _0933_ sky130_fd_sc_hd__a2bb2o_1
XFILLER_36_277 VGND VGND VPWR VPWR sky130_fd_sc_hd__decap_4
XFILLER_24_428 VGND VGND VPWR VPWR sky130_fd_sc_hd__fill_2
XFILLER_36_299 VGND VGND VPWR VPWR sky130_fd_sc_hd__decap_8
X_3914_ clknet_leaf_29_clk _0037_ VGND VGND VPWR VPWR expmiddle\[4\] sky130_fd_sc_hd__dfxtp_1
XTAP_TAPCELL_ROW_34_445 VGND VPWR sky130_fd_sc_hd__tapvpwrvgnd_1
XFILLER_22_29 VGND VGND VPWR VPWR sky130_fd_sc_hd__decap_6
X_3845_ net258 net189 _1575_ VGND VGND VPWR VPWR _0264_ sky130_fd_sc_hd__nor3_1
X_3776_ _1591_ _1590_ net256 VGND VGND VPWR VPWR _1592_ sky130_fd_sc_hd__mux2_1
X_2727_ mantisaresult\[10\] net152 net130 VGND VGND VPWR VPWR _0670_ sky130_fd_sc_hd__and3_1
X_2658_ _0578_ _0600_ VGND VGND VPWR VPWR _0601_ sky130_fd_sc_hd__nor2_2
X_2589_ mantisaresult\[15\] _1630_ _0375_ _0428_ VGND VGND VPWR VPWR _0532_ sky130_fd_sc_hd__or4_1
Xfanout102 net105 VGND VGND VPWR VPWR net102 sky130_fd_sc_hd__clkbuf_4
Xfanout113 net114 VGND VGND VPWR VPWR net113 sky130_fd_sc_hd__clkbuf_2
Xfanout135 _0611_ VGND VGND VPWR VPWR net135 sky130_fd_sc_hd__clkbuf_2
Xfanout146 net147 VGND VGND VPWR VPWR net146 sky130_fd_sc_hd__buf_2
Xfanout124 _0605_ VGND VGND VPWR VPWR net124 sky130_fd_sc_hd__buf_2
Xfanout168 net170 VGND VGND VPWR VPWR net168 sky130_fd_sc_hd__clkbuf_2
Xfanout157 net158 VGND VGND VPWR VPWR net157 sky130_fd_sc_hd__buf_2
XFILLER_15_417 VPWR VGND VPWR VGND sky130_ef_sc_hd__decap_12
XFILLER_63_14 VPWR VGND VPWR VGND sky130_ef_sc_hd__decap_12
XFILLER_42_269 VGND VGND VPWR VPWR sky130_fd_sc_hd__decap_8
XFILLER_10_133 VGND VGND VPWR VPWR sky130_fd_sc_hd__decap_6
XFILLER_6_137 VGND VGND VPWR VPWR sky130_fd_sc_hd__decap_3
XFILLER_2_354 VGND VGND VPWR VPWR sky130_fd_sc_hd__fill_1
XFILLER_2_365 VGND VGND VPWR VPWR sky130_fd_sc_hd__fill_1
XFILLER_77_111 VGND VGND VPWR VPWR sky130_fd_sc_hd__fill_1
XFILLER_19_9 VGND VGND VPWR VPWR sky130_fd_sc_hd__decap_4
XTAP_TAPCELL_ROW_48_559 VGND VPWR sky130_fd_sc_hd__tapvpwrvgnd_1
XFILLER_33_203 VPWR VGND VPWR VGND sky130_ef_sc_hd__decap_12
XFILLER_73_361 VPWR VGND VPWR VGND sky130_ef_sc_hd__decap_12
XFILLER_33_269 VGND VGND VPWR VPWR sky130_fd_sc_hd__decap_8
X_1960_ net31 VGND VGND VPWR VPWR _1655_ sky130_fd_sc_hd__inv_2
X_3630_ _1451_ _1460_ net260 VGND VGND VPWR VPWR _1461_ sky130_fd_sc_hd__mux2_1
X_3561_ _0603_ _1388_ _1389_ _1394_ VGND VGND VPWR VPWR _1395_ sky130_fd_sc_hd__a211o_1
X_2512_ _0435_ _0442_ _0453_ _0454_ VGND VGND VPWR VPWR _0455_ sky130_fd_sc_hd__or4_1
X_3492_ net316 expmiddlec\[6\] net230 VGND VGND VPWR VPWR _0200_ sky130_fd_sc_hd__mux2_1
XFILLER_5_181 VPWR VGND VPWR VGND sky130_ef_sc_hd__decap_12
X_2443_ mantisaresult\[39\] mantisaresult\[38\] _0310_ _0385_ VGND VGND VPWR VPWR
+ _0386_ sky130_fd_sc_hd__nor4_1
X_2374_ mantisaresult\[47\] net221 net222 net223 VGND VGND VPWR VPWR _0317_ sky130_fd_sc_hd__or4_1
X_4113_ clknet_leaf_24_clk _0220_ VGND VGND VPWR VPWR mantisaBshift\[9\] sky130_fd_sc_hd__dfxtp_1
XFILLER_68_166 VPWR VGND VPWR VGND sky130_ef_sc_hd__decap_12
XFILLER_49_391 VGND VGND VPWR VPWR sky130_fd_sc_hd__fill_1
X_4044_ clknet_leaf_12_clk _0155_ VGND VGND VPWR VPWR mantisaresult\[45\] sky130_fd_sc_hd__dfxtp_1
XFILLER_24_247 VGND VGND VPWR VPWR sky130_fd_sc_hd__decap_4
X_3828_ net257 _1551_ VGND VGND VPWR VPWR _1614_ sky130_fd_sc_hd__nor2_1
X_3759_ net261 _1511_ VGND VGND VPWR VPWR _1578_ sky130_fd_sc_hd__or2_1
XFILLER_59_111 VGND VGND VPWR VPWR sky130_fd_sc_hd__fill_1
XFILLER_55_361 VGND VGND VPWR VPWR sky130_fd_sc_hd__decap_8
XFILLER_15_214 VGND VGND VPWR VPWR sky130_fd_sc_hd__decap_8
XTAP_TAPCELL_ROW_2_184 VGND VPWR sky130_fd_sc_hd__tapvpwrvgnd_1
XTAP_TAPCELL_ROW_45_529 VGND VPWR sky130_fd_sc_hd__tapvpwrvgnd_1
XTAP_TAPCELL_ROW_53_595 VGND VPWR sky130_fd_sc_hd__tapvpwrvgnd_1
XFILLER_23_50 VGND VGND VPWR VPWR sky130_fd_sc_hd__decap_6
XFILLER_2_195 VGND VGND VPWR VPWR sky130_fd_sc_hd__fill_1
XFILLER_38_306 VGND VGND VPWR VPWR sky130_fd_sc_hd__fill_2
X_2090_ net211 net337 VGND VGND VPWR VPWR _0030_ sky130_fd_sc_hd__and2b_1
XFILLER_65_169 VGND VGND VPWR VPWR sky130_fd_sc_hd__decap_8
XFILLER_0_76 VGND VGND VPWR VPWR sky130_fd_sc_hd__decap_4
XFILLER_0_65 VGND VGND VPWR VPWR sky130_fd_sc_hd__fill_1
XFILLER_46_372 VGND VGND VPWR VPWR sky130_fd_sc_hd__decap_8
XFILLER_61_331 VGND VGND VPWR VPWR sky130_fd_sc_hd__decap_4
XFILLER_61_353 VGND VGND VPWR VPWR sky130_fd_sc_hd__fill_1
XFILLER_73_191 VGND VGND VPWR VPWR sky130_fd_sc_hd__decap_8
X_2992_ net238 _0914_ mantisaBshift\[12\] VGND VGND VPWR VPWR _0915_ sky130_fd_sc_hd__a21oi_1
XTAP_TAPCELL_ROW_16_297 VGND VPWR sky130_fd_sc_hd__tapvpwrvgnd_1
XFILLER_14_291 VPWR VGND VPWR VGND sky130_ef_sc_hd__decap_12
X_1943_ mantisaresult\[17\] VGND VGND VPWR VPWR _1638_ sky130_fd_sc_hd__inv_2
X_3613_ _1441_ _1443_ net270 VGND VGND VPWR VPWR _1444_ sky130_fd_sc_hd__mux2_1
X_3544_ mantisaresult\[57\] net155 net133 VGND VGND VPWR VPWR _1379_ sky130_fd_sc_hd__and3_1
X_3475_ net219 net113 net109 net218 VGND VGND VPWR VPWR _1321_ sky130_fd_sc_hd__a22o_1
X_2426_ _1638_ _0331_ _0360_ _0364_ VGND VGND VPWR VPWR _0369_ sky130_fd_sc_hd__or4_1
XFILLER_69_442 VGND VGND VPWR VPWR sky130_fd_sc_hd__decap_6
XFILLER_29_328 VGND VGND VPWR VPWR sky130_fd_sc_hd__decap_4
X_2357_ _0298_ _0299_ VGND VGND VPWR VPWR _0300_ sky130_fd_sc_hd__nor2_1
X_2288_ net29 _1913_ net100 VGND VGND VPWR VPWR _1914_ sky130_fd_sc_hd__mux2_1
X_4027_ clknet_leaf_2_clk _0138_ VGND VGND VPWR VPWR mantisaresult\[30\] sky130_fd_sc_hd__dfxtp_1
XFILLER_44_309 VGND VGND VPWR VPWR sky130_fd_sc_hd__decap_8
XFILLER_37_383 VGND VGND VPWR VPWR sky130_fd_sc_hd__decap_8
XFILLER_44_38 VGND VGND VPWR VPWR sky130_fd_sc_hd__decap_3
XFILLER_52_331 VPWR VGND VPWR VGND sky130_ef_sc_hd__decap_12
XFILLER_20_250 VGND VGND VPWR VPWR sky130_fd_sc_hd__fill_2
XFILLER_69_13 VGND VGND VPWR VPWR sky130_fd_sc_hd__fill_2
XFILLER_69_57 VGND VGND VPWR VPWR sky130_fd_sc_hd__decap_3
XPHY_EDGE_ROW_8_Left_88 VGND VGND VPWR VPWR sky130_fd_sc_hd__decap_3
XTAP_TAPCELL_ROW_58_632 VGND VPWR sky130_fd_sc_hd__tapvpwrvgnd_1
XFILLER_18_94 VPWR VGND VPWR VGND sky130_ef_sc_hd__decap_12
XFILLER_62_139 VGND VGND VPWR VPWR sky130_fd_sc_hd__fill_1
XFILLER_70_161 VGND VGND VPWR VPWR sky130_fd_sc_hd__decap_4
XTAP_TAPCELL_ROW_13_278 VGND VPWR sky130_fd_sc_hd__tapvpwrvgnd_1
X_3260_ mantisaresult\[49\] net236 _1140_ _1141_ VGND VGND VPWR VPWR _0159_ sky130_fd_sc_hd__a22o_1
X_2211_ net2 net10 net98 VGND VGND VPWR VPWR _1864_ sky130_fd_sc_hd__mux2_1
X_3191_ _1077_ _0881_ net145 VGND VGND VPWR VPWR _1079_ sky130_fd_sc_hd__mux2_1
X_2142_ net37 _1662_ _1663_ net36 _1802_ VGND VGND VPWR VPWR _1803_ sky130_fd_sc_hd__o221a_1
XFILLER_26_309 VGND VGND VPWR VPWR sky130_fd_sc_hd__fill_2
X_2073_ inf3 net327 VGND VGND VPWR VPWR _0013_ sky130_fd_sc_hd__and2b_1
XFILLER_53_106 VGND VGND VPWR VPWR sky130_fd_sc_hd__fill_1
XFILLER_53_117 VGND VGND VPWR VPWR sky130_fd_sc_hd__fill_1
X_2975_ net239 mantisaBshift\[7\] _0901_ net231 VGND VGND VPWR VPWR _0903_ sky130_fd_sc_hd__a31o_1
XFILLER_30_29 VGND VGND VPWR VPWR sky130_fd_sc_hd__decap_3
X_3527_ mantisaresult\[56\] net196 net160 net216 VGND VGND VPWR VPWR _1364_ sky130_fd_sc_hd__a31o_1
X_3458_ net218 net196 net164 _1314_ VGND VGND VPWR VPWR _1315_ sky130_fd_sc_hd__a31o_1
XTAP_TAPCELL_ROW_4_202 VGND VPWR sky130_fd_sc_hd__tapvpwrvgnd_1
XFILLER_29_103 VGND VGND VPWR VPWR sky130_fd_sc_hd__fill_2
X_2409_ _0295_ net182 VGND VGND VPWR VPWR _0352_ sky130_fd_sc_hd__and2_1
X_3389_ mantisaAshift\[59\] mantisaBshift\[59\] _1258_ VGND VGND VPWR VPWR _1259_
+ sky130_fd_sc_hd__a21o_1
XFILLER_29_169 VPWR VGND VPWR VGND sky130_ef_sc_hd__decap_12
XTAP_TAPCELL_ROW_55_613 VGND VPWR sky130_fd_sc_hd__tapvpwrvgnd_1
XFILLER_44_139 VGND VGND VPWR VPWR sky130_fd_sc_hd__fill_1
XTAP_TAPCELL_ROW_10_248 VGND VPWR sky130_fd_sc_hd__tapvpwrvgnd_1
XFILLER_20_73 VGND VGND VPWR VPWR sky130_fd_sc_hd__decap_8
Xhold82 expmiddled\[5\] VGND VGND VPWR VPWR net356 sky130_fd_sc_hd__dlygate4sd3_1
Xhold71 four_man\[43\] VGND VGND VPWR VPWR net345 sky130_fd_sc_hd__dlygate4sd3_1
Xhold60 four_man\[47\] VGND VGND VPWR VPWR net334 sky130_fd_sc_hd__dlygate4sd3_1
XFILLER_75_297 VPWR VGND VPWR VGND sky130_ef_sc_hd__decap_12
XTAP_TAPCELL_ROW_18_315 VGND VPWR sky130_fd_sc_hd__tapvpwrvgnd_1
XFILLER_35_106 VGND VGND VPWR VPWR sky130_fd_sc_hd__decap_6
Xhold93 mantisaB0\[18\] VGND VGND VPWR VPWR net367 sky130_fd_sc_hd__dlygate4sd3_1
XFILLER_63_437 VGND VGND VPWR VPWR sky130_fd_sc_hd__decap_8
XFILLER_16_331 VGND VGND VPWR VPWR sky130_fd_sc_hd__fill_1
XTAP_TAPCELL_ROW_26_381 VGND VPWR sky130_fd_sc_hd__tapvpwrvgnd_1
XFILLER_31_356 VGND VGND VPWR VPWR sky130_fd_sc_hd__decap_8
X_2760_ net340 net206 _0700_ _0702_ VGND VGND VPWR VPWR _0098_ sky130_fd_sc_hd__o22a_1
X_2691_ mantisaresult\[24\] net154 VGND VGND VPWR VPWR _0634_ sky130_fd_sc_hd__nand2_1
XFILLER_6_53 VPWR VGND VPWR VGND sky130_ef_sc_hd__decap_12
XFILLER_6_97 VGND VGND VPWR VPWR sky130_fd_sc_hd__fill_2
X_3312_ _1187_ _1188_ VGND VGND VPWR VPWR _1189_ sky130_fd_sc_hd__or2_1
XFILLER_58_209 VGND VGND VPWR VPWR sky130_fd_sc_hd__decap_6
X_3243_ mantisaBshift\[47\] mantisaAshift\[47\] VGND VGND VPWR VPWR _1126_ sky130_fd_sc_hd__and2b_1
XTAP_TAPCELL_ROW_69_727 VGND VPWR sky130_fd_sc_hd__tapvpwrvgnd_1
XFILLER_39_412 VGND VGND VPWR VPWR sky130_fd_sc_hd__decap_4
X_3174_ _1058_ _1062_ net235 VGND VGND VPWR VPWR _1064_ sky130_fd_sc_hd__a21oi_1
XFILLER_66_253 VGND VGND VPWR VPWR sky130_fd_sc_hd__fill_1
X_2125_ net3 _1672_ VGND VGND VPWR VPWR _1786_ sky130_fd_sc_hd__nor2_1
X_2056_ _1742_ _1743_ VGND VGND VPWR VPWR _1744_ sky130_fd_sc_hd__nand2_1
XFILLER_26_139 VGND VGND VPWR VPWR sky130_fd_sc_hd__fill_1
XFILLER_25_29 VGND VGND VPWR VPWR sky130_fd_sc_hd__decap_8
XFILLER_34_183 VGND VGND VPWR VPWR sky130_fd_sc_hd__fill_2
XFILLER_22_345 VGND VGND VPWR VPWR sky130_fd_sc_hd__decap_3
XFILLER_22_389 VPWR VGND VPWR VGND sky130_ef_sc_hd__decap_12
X_2958_ net157 _0876_ _0889_ VGND VGND VPWR VPWR _0890_ sky130_fd_sc_hd__and3_1
X_2889_ net327 _1687_ _0826_ _0828_ VGND VGND VPWR VPWR _0101_ sky130_fd_sc_hd__o22a_1
XFILLER_1_205 VPWR VGND VPWR VGND sky130_ef_sc_hd__decap_12
XFILLER_1_249 VPWR VGND VPWR VGND sky130_ef_sc_hd__decap_12
XFILLER_45_426 VGND VGND VPWR VPWR sky130_fd_sc_hd__decap_4
XFILLER_15_40 VGND VGND VPWR VPWR sky130_fd_sc_hd__decap_3
XFILLER_13_334 VGND VGND VPWR VPWR sky130_fd_sc_hd__fill_2
XFILLER_40_153 VPWR VGND VPWR VGND sky130_ef_sc_hd__decap_12
XFILLER_9_349 VGND VGND VPWR VPWR sky130_fd_sc_hd__fill_1
XFILLER_40_197 VGND VGND VPWR VPWR sky130_fd_sc_hd__decap_8
Xoutput72 net72 VGND VGND VPWR VPWR exp[6] sky130_fd_sc_hd__buf_2
Xoutput94 net94 VGND VGND VPWR VPWR mantisa[7] sky130_fd_sc_hd__buf_2
Xoutput83 net83 VGND VGND VPWR VPWR mantisa[18] sky130_fd_sc_hd__buf_2
XFILLER_48_297 VGND VGND VPWR VPWR sky130_fd_sc_hd__fill_1
X_3930_ clknet_leaf_6_clk _0053_ VGND VGND VPWR VPWR mantisaA0\[4\] sky130_fd_sc_hd__dfxtp_1
XTAP_TAPCELL_ROW_74_763 VGND VPWR sky130_fd_sc_hd__tapvpwrvgnd_1
X_3861_ clknet_leaf_6_clk net285 VGND VGND VPWR VPWR mantisaAshift\[46\] sky130_fd_sc_hd__dfxtp_1
X_2812_ mantisaresult\[0\] net107 VGND VGND VPWR VPWR _0754_ sky130_fd_sc_hd__nand2_1
X_3792_ net184 _1583_ _1602_ _1418_ VGND VGND VPWR VPWR _0230_ sky130_fd_sc_hd__a22o_1
X_2743_ mantisaresult\[19\] net153 VGND VGND VPWR VPWR _0686_ sky130_fd_sc_hd__nand2_1
XFILLER_8_393 VGND VGND VPWR VPWR sky130_fd_sc_hd__decap_4
X_2674_ _0616_ VGND VGND VPWR VPWR _0617_ sky130_fd_sc_hd__inv_2
X_3226_ net245 _1108_ VGND VGND VPWR VPWR _1111_ sky130_fd_sc_hd__nor2_1
X_3157_ mantisaAshift\[41\] mantisaBshift\[41\] VGND VGND VPWR VPWR _1048_ sky130_fd_sc_hd__nor2_1
X_2108_ _1766_ _1768_ VGND VGND VPWR VPWR _1769_ sky130_fd_sc_hd__or2_1
X_3088_ mantisaresult\[27\] _0993_ net202 VGND VGND VPWR VPWR _0135_ sky130_fd_sc_hd__mux2_1
XTAP_TAPCELL_ROW_37_465 VGND VPWR sky130_fd_sc_hd__tapvpwrvgnd_1
X_2039_ expmiddled\[0\] expadd\[0\] _1725_ _1723_ VGND VGND VPWR VPWR _1730_ sky130_fd_sc_hd__a31o_1
XFILLER_35_470 VGND VGND VPWR VPWR sky130_fd_sc_hd__decap_3
XFILLER_52_38 VGND VGND VPWR VPWR sky130_fd_sc_hd__decap_3
XFILLER_50_462 VGND VGND VPWR VPWR sky130_fd_sc_hd__decap_3
XTAP_TAPCELL_ROW_20_332 VGND VPWR sky130_fd_sc_hd__tapvpwrvgnd_1
XFILLER_22_197 VGND VGND VPWR VPWR sky130_fd_sc_hd__decap_3
XFILLER_77_337 VPWR VGND VPWR VGND sky130_ef_sc_hd__decap_12
XFILLER_77_57 VGND VGND VPWR VPWR sky130_fd_sc_hd__decap_4
XFILLER_45_201 VGND VGND VPWR VPWR sky130_fd_sc_hd__fill_2
XFILLER_45_223 VGND VGND VPWR VPWR sky130_fd_sc_hd__fill_1
XFILLER_26_83 VGND VGND VPWR VPWR sky130_fd_sc_hd__fill_1
XFILLER_13_153 VPWR VGND VPWR VGND sky130_ef_sc_hd__decap_12
XTAP_TAPCELL_ROW_79_800 VGND VPWR sky130_fd_sc_hd__tapvpwrvgnd_1
X_2390_ mantisaresult\[49\] net220 mantisaresult\[47\] VGND VGND VPWR VPWR _0333_
+ sky130_fd_sc_hd__or3_1
XTAP_TAPCELL_ROW_79_811 VGND VPWR sky130_fd_sc_hd__tapvpwrvgnd_1
XFILLER_68_337 VGND VGND VPWR VPWR sky130_fd_sc_hd__fill_1
X_4060_ clknet_leaf_14_clk _0171_ VGND VGND VPWR VPWR mantisaresult\[60\] sky130_fd_sc_hd__dfxtp_2
X_3011_ _0800_ _0798_ net142 VGND VGND VPWR VPWR _0932_ sky130_fd_sc_hd__mux2_1
XFILLER_24_418 VGND VGND VPWR VPWR sky130_fd_sc_hd__fill_2
X_3913_ clknet_leaf_26_clk _0036_ VGND VGND VPWR VPWR expmiddle\[3\] sky130_fd_sc_hd__dfxtp_1
XTAP_TAPCELL_ROW_34_446 VGND VPWR sky130_fd_sc_hd__tapvpwrvgnd_1
XFILLER_32_462 VGND VGND VPWR VPWR sky130_fd_sc_hd__decap_8
X_3844_ net258 net189 _1558_ VGND VGND VPWR VPWR _0263_ sky130_fd_sc_hd__nor3_1
X_3775_ _1463_ _1467_ _1471_ _1479_ net266 net262 VGND VGND VPWR VPWR _1591_ sky130_fd_sc_hd__mux4_1
X_2726_ mantisaresult\[10\] net152 VGND VGND VPWR VPWR _0669_ sky130_fd_sc_hd__nand2_1
X_2657_ _1623_ mantisaresult\[63\] _0598_ _0599_ _1622_ VGND VGND VPWR VPWR _0600_
+ sky130_fd_sc_hd__o221a_1
X_2588_ mantisaresult\[15\] _0430_ VGND VGND VPWR VPWR _0531_ sky130_fd_sc_hd__nand2_1
Xfanout103 net104 VGND VGND VPWR VPWR net103 sky130_fd_sc_hd__clkbuf_4
Xfanout136 net137 VGND VGND VPWR VPWR net136 sky130_fd_sc_hd__buf_2
Xfanout125 _0630_ VGND VGND VPWR VPWR net125 sky130_fd_sc_hd__buf_2
Xfanout114 _0612_ VGND VGND VPWR VPWR net114 sky130_fd_sc_hd__clkbuf_2
Xfanout147 net148 VGND VGND VPWR VPWR net147 sky130_fd_sc_hd__buf_2
XFILLER_59_315 VGND VGND VPWR VPWR sky130_fd_sc_hd__fill_1
Xfanout158 net159 VGND VGND VPWR VPWR net158 sky130_fd_sc_hd__buf_2
Xfanout169 net170 VGND VGND VPWR VPWR net169 sky130_fd_sc_hd__clkbuf_2
XFILLER_47_38 VGND VGND VPWR VPWR sky130_fd_sc_hd__decap_8
X_3209_ net223 _1095_ net205 VGND VGND VPWR VPWR _0154_ sky130_fd_sc_hd__mux2_1
XFILLER_74_307 VGND VGND VPWR VPWR sky130_fd_sc_hd__fill_1
XFILLER_15_429 VPWR VGND VPWR VGND sky130_ef_sc_hd__decap_12
XFILLER_63_26 VGND VGND VPWR VPWR sky130_fd_sc_hd__decap_8
XFILLER_23_462 VGND VGND VPWR VPWR sky130_fd_sc_hd__decap_8
XFILLER_6_105 VGND VGND VPWR VPWR sky130_fd_sc_hd__decap_6
XFILLER_12_85 VGND VGND VPWR VPWR sky130_fd_sc_hd__decap_8
XPHY_EDGE_ROW_16_Right_16 VGND VGND VPWR VPWR sky130_fd_sc_hd__decap_3
XFILLER_33_215 VGND VGND VPWR VPWR sky130_fd_sc_hd__decap_8
XFILLER_73_373 VPWR VGND VPWR VGND sky130_ef_sc_hd__decap_12
XTAP_TAPCELL_ROW_31_416 VGND VPWR sky130_fd_sc_hd__tapvpwrvgnd_1
XFILLER_41_281 VGND VGND VPWR VPWR sky130_fd_sc_hd__fill_2
XFILLER_41_292 VPWR VGND VPWR VGND sky130_ef_sc_hd__decap_12
XPHY_EDGE_ROW_25_Right_25 VGND VGND VPWR VPWR sky130_fd_sc_hd__decap_3
X_3560_ net149 _1392_ _1393_ _0632_ VGND VGND VPWR VPWR _1394_ sky130_fd_sc_hd__o211a_1
X_2511_ mantisaresult\[16\] mantisaresult\[18\] mantisaresult\[17\] mantisaresult\[3\]
+ VGND VGND VPWR VPWR _0454_ sky130_fd_sc_hd__or4b_1
X_3491_ net320 expmiddlec\[5\] net230 VGND VGND VPWR VPWR _0199_ sky130_fd_sc_hd__mux2_1
XFILLER_5_193 VPWR VGND VPWR VGND sky130_ef_sc_hd__decap_12
XFILLER_45_3 VPWR VGND VPWR VGND sky130_ef_sc_hd__decap_12
X_2442_ net219 net227 mantisaresult\[37\] VGND VGND VPWR VPWR _0385_ sky130_fd_sc_hd__or3b_1
X_2373_ mantisaresult\[39\] mantisaresult\[38\] mantisaresult\[37\] VGND VGND VPWR
+ VPWR _0316_ sky130_fd_sc_hd__or3_2
X_4112_ clknet_leaf_24_clk _0219_ VGND VGND VPWR VPWR mantisaBshift\[10\] sky130_fd_sc_hd__dfxtp_1
X_4043_ clknet_leaf_12_clk _0154_ VGND VGND VPWR VPWR mantisaresult\[44\] sky130_fd_sc_hd__dfxtp_1
XFILLER_56_318 VGND VGND VPWR VPWR sky130_fd_sc_hd__fill_2
XFILLER_68_178 VPWR VGND VPWR VGND sky130_ef_sc_hd__decap_12
XPHY_EDGE_ROW_34_Right_34 VGND VGND VPWR VPWR sky130_fd_sc_hd__decap_3
XFILLER_33_18 VGND VGND VPWR VPWR sky130_fd_sc_hd__decap_6
X_3827_ _1418_ _1613_ _1612_ VGND VGND VPWR VPWR _0254_ sky130_fd_sc_hd__a21o_1
XPHY_EDGE_ROW_43_Right_43 VGND VGND VPWR VPWR sky130_fd_sc_hd__decap_3
X_3758_ net187 _1576_ _1577_ net184 VGND VGND VPWR VPWR _0221_ sky130_fd_sc_hd__a2bb2o_1
X_2709_ net135 _0650_ net114 mantisaresult\[32\] VGND VGND VPWR VPWR _0652_ sky130_fd_sc_hd__a2bb2o_1
X_3689_ _1514_ _1515_ net268 VGND VGND VPWR VPWR _1516_ sky130_fd_sc_hd__mux2_1
XFILLER_47_329 VGND VGND VPWR VPWR sky130_fd_sc_hd__decap_6
XPHY_EDGE_ROW_52_Right_52 VGND VGND VPWR VPWR sky130_fd_sc_hd__decap_3
XFILLER_59_167 VGND VGND VPWR VPWR sky130_fd_sc_hd__fill_1
XFILLER_74_115 VGND VGND VPWR VPWR sky130_fd_sc_hd__decap_8
XTAP_TAPCELL_ROW_2_185 VGND VPWR sky130_fd_sc_hd__tapvpwrvgnd_1
XFILLER_70_321 VGND VGND VPWR VPWR sky130_fd_sc_hd__decap_4
XFILLER_70_365 VPWR VGND VPWR VGND sky130_ef_sc_hd__decap_12
XTAP_TAPCELL_ROW_53_596 VGND VPWR sky130_fd_sc_hd__tapvpwrvgnd_1
XPHY_EDGE_ROW_61_Right_61 VGND VGND VPWR VPWR sky130_fd_sc_hd__decap_3
XFILLER_7_447 VGND VGND VPWR VPWR sky130_fd_sc_hd__fill_1
XFILLER_78_421 VPWR VGND VPWR VGND sky130_ef_sc_hd__decap_12
XFILLER_2_141 VPWR VGND VPWR VGND sky130_ef_sc_hd__decap_12
XFILLER_31_9 VGND VGND VPWR VPWR sky130_fd_sc_hd__decap_6
XPHY_EDGE_ROW_70_Right_70 VGND VGND VPWR VPWR sky130_fd_sc_hd__decap_3
X_2991_ mantisaBshift\[10\] mantisaBshift\[11\] _0909_ VGND VGND VPWR VPWR _0914_
+ sky130_fd_sc_hd__or3_1
XTAP_TAPCELL_ROW_16_298 VGND VPWR sky130_fd_sc_hd__tapvpwrvgnd_1
X_1942_ mantisaresult\[18\] VGND VGND VPWR VPWR _1637_ sky130_fd_sc_hd__inv_2
X_3612_ mantisaB0\[12\] _1420_ _1442_ VGND VGND VPWR VPWR _1443_ sky130_fd_sc_hd__a21oi_1
X_3543_ net127 _0803_ _1377_ _0603_ VGND VGND VPWR VPWR _1378_ sky130_fd_sc_hd__o211a_1
X_3474_ net312 expmiddlec\[1\] net230 VGND VGND VPWR VPWR _0194_ sky130_fd_sc_hd__mux2_1
X_2425_ _1629_ _0331_ _0332_ _0365_ VGND VGND VPWR VPWR _0368_ sky130_fd_sc_hd__or4_1
XFILLER_69_421 VGND VGND VPWR VPWR sky130_fd_sc_hd__decap_4
XFILLER_28_29 VGND VGND VPWR VPWR sky130_fd_sc_hd__fill_2
X_2356_ mantisaresult\[59\] mantisaresult\[58\] VGND VGND VPWR VPWR _0299_ sky130_fd_sc_hd__or2_2
X_2287_ net52 net168 VGND VGND VPWR VPWR _1913_ sky130_fd_sc_hd__and2_1
X_4026_ clknet_leaf_2_clk _0137_ VGND VGND VPWR VPWR mantisaresult\[29\] sky130_fd_sc_hd__dfxtp_2
XFILLER_52_343 VGND VGND VPWR VPWR sky130_fd_sc_hd__decap_3
XFILLER_64_181 VGND VGND VPWR VPWR sky130_fd_sc_hd__fill_1
XFILLER_52_365 VGND VGND VPWR VPWR sky130_fd_sc_hd__fill_1
XFILLER_52_387 VGND VGND VPWR VPWR sky130_fd_sc_hd__fill_2
XTAP_TAPCELL_ROW_58_633 VGND VPWR sky130_fd_sc_hd__tapvpwrvgnd_1
XFILLER_18_51 VGND VGND VPWR VPWR sky130_fd_sc_hd__decap_8
XFILLER_55_181 VGND VGND VPWR VPWR sky130_fd_sc_hd__fill_2
XTAP_TAPCELL_ROW_41_500 VGND VPWR sky130_fd_sc_hd__tapvpwrvgnd_1
XFILLER_34_94 VGND VGND VPWR VPWR sky130_fd_sc_hd__fill_2
XTAP_TAPCELL_ROW_13_279 VGND VPWR sky130_fd_sc_hd__tapvpwrvgnd_1
XFILLER_11_262 VGND VGND VPWR VPWR sky130_fd_sc_hd__fill_2
XFILLER_7_211 VPWR VGND VPWR VGND sky130_ef_sc_hd__decap_12
XFILLER_7_299 VGND VGND VPWR VPWR sky130_fd_sc_hd__decap_8
XFILLER_3_461 VPWR VGND VPWR VGND sky130_ef_sc_hd__decap_12
X_2210_ net311 net178 _1863_ VGND VGND VPWR VPWR _0041_ sky130_fd_sc_hd__o21a_1
X_3190_ _1077_ VGND VGND VPWR VPWR _1078_ sky130_fd_sc_hd__inv_2
X_2141_ net35 _1660_ _1663_ net36 _1801_ VGND VGND VPWR VPWR _1802_ sky130_fd_sc_hd__a221o_1
XFILLER_19_340 VGND VGND VPWR VPWR sky130_fd_sc_hd__decap_3
X_2072_ inf3 net275 VGND VGND VPWR VPWR _0012_ sky130_fd_sc_hd__and2b_1
XFILLER_19_373 VGND VGND VPWR VPWR sky130_fd_sc_hd__decap_8
XFILLER_34_365 VPWR VGND VPWR VGND sky130_ef_sc_hd__decap_12
X_2974_ net239 _0901_ mantisaBshift\[7\] VGND VGND VPWR VPWR _0902_ sky130_fd_sc_hd__a21oi_1
X_3526_ _0741_ _0936_ _1361_ _1362_ VGND VGND VPWR VPWR _1363_ sky130_fd_sc_hd__a211oi_1
X_3457_ mantisaresult\[52\] net196 net160 net215 VGND VGND VPWR VPWR _1314_ sky130_fd_sc_hd__a31o_1
XTAP_TAPCELL_ROW_4_203 VGND VPWR sky130_fd_sc_hd__tapvpwrvgnd_1
X_2408_ mantisaresult\[32\] _0293_ VGND VGND VPWR VPWR _0351_ sky130_fd_sc_hd__nor2_1
X_3388_ mantisaAshift\[59\] mantisaBshift\[59\] _1237_ _1244_ _1238_ VGND VGND VPWR
+ VPWR _1258_ sky130_fd_sc_hd__o221a_1
XFILLER_69_240 VGND VGND VPWR VPWR sky130_fd_sc_hd__decap_8
X_2339_ _0286_ net358 net171 VGND VGND VPWR VPWR _0093_ sky130_fd_sc_hd__mux2_1
XFILLER_57_435 VGND VGND VPWR VPWR sky130_fd_sc_hd__decap_4
XPHY_EDGE_ROW_2_Right_2 VGND VGND VPWR VPWR sky130_fd_sc_hd__decap_3
XTAP_TAPCELL_ROW_55_614 VGND VPWR sky130_fd_sc_hd__tapvpwrvgnd_1
X_4009_ clknet_leaf_17_clk _0120_ VGND VGND VPWR VPWR four_man\[46\] sky130_fd_sc_hd__dfxtp_1
XTAP_TAPCELL_ROW_10_249 VGND VPWR sky130_fd_sc_hd__tapvpwrvgnd_1
XFILLER_20_85 VGND VGND VPWR VPWR sky130_fd_sc_hd__fill_1
XFILLER_4_269 VGND VGND VPWR VPWR sky130_fd_sc_hd__fill_1
Xhold50 four_man\[50\] VGND VGND VPWR VPWR net324 sky130_fd_sc_hd__dlygate4sd3_1
XFILLER_75_232 VGND VGND VPWR VPWR sky130_fd_sc_hd__decap_6
Xhold83 expmiddled\[1\] VGND VGND VPWR VPWR net357 sky130_fd_sc_hd__dlygate4sd3_1
Xhold72 mantisaB0\[1\] VGND VGND VPWR VPWR net346 sky130_fd_sc_hd__dlygate4sd3_1
Xhold61 four_man\[48\] VGND VGND VPWR VPWR net335 sky130_fd_sc_hd__dlygate4sd3_1
XTAP_TAPCELL_ROW_18_316 VGND VPWR sky130_fd_sc_hd__tapvpwrvgnd_1
Xhold94 mantisaB0\[20\] VGND VGND VPWR VPWR net368 sky130_fd_sc_hd__dlygate4sd3_1
XFILLER_16_365 VGND VGND VPWR VPWR sky130_fd_sc_hd__decap_8
XFILLER_45_82 VGND VGND VPWR VPWR sky130_fd_sc_hd__decap_6
XFILLER_16_398 VGND VGND VPWR VPWR sky130_fd_sc_hd__decap_4
XTAP_TAPCELL_ROW_26_382 VGND VPWR sky130_fd_sc_hd__tapvpwrvgnd_1
XFILLER_43_173 VGND VGND VPWR VPWR sky130_fd_sc_hd__fill_1
XFILLER_77_6 VPWR VGND VPWR VGND sky130_ef_sc_hd__decap_12
XPHY_EDGE_ROW_20_Left_100 VGND VGND VPWR VPWR sky130_fd_sc_hd__decap_3
X_2690_ net151 net127 VGND VGND VPWR VPWR _0633_ sky130_fd_sc_hd__nand2_2
XFILLER_6_65 VPWR VGND VPWR VGND sky130_ef_sc_hd__decap_12
X_3311_ _0756_ _0802_ _0925_ _1186_ net128 VGND VGND VPWR VPWR _1188_ sky130_fd_sc_hd__a221o_1
X_3242_ _1123_ _1124_ VGND VGND VPWR VPWR _1125_ sky130_fd_sc_hd__nor2_1
XFILLER_39_424 VPWR VGND VPWR VGND sky130_ef_sc_hd__decap_12
X_3173_ _1058_ _1062_ VGND VGND VPWR VPWR _1063_ sky130_fd_sc_hd__or2_1
X_2124_ net3 _1672_ VGND VGND VPWR VPWR _1785_ sky130_fd_sc_hd__and2_1
XFILLER_66_276 VPWR VGND VPWR VGND sky130_ef_sc_hd__decap_12
X_2055_ expmiddled\[5\] expadd\[5\] VGND VGND VPWR VPWR _1743_ sky130_fd_sc_hd__or2_1
XTAP_TAPCELL_ROW_60_650 VGND VPWR sky130_fd_sc_hd__tapvpwrvgnd_1
X_2957_ _0633_ _0884_ _0888_ net126 VGND VGND VPWR VPWR _0889_ sky130_fd_sc_hd__o22a_1
X_2888_ net224 net194 net166 _0827_ VGND VGND VPWR VPWR _0828_ sky130_fd_sc_hd__a31o_1
XFILLER_1_217 VGND VGND VPWR VPWR sky130_fd_sc_hd__decap_6
X_3509_ _0602_ _1346_ VGND VGND VPWR VPWR _1347_ sky130_fd_sc_hd__nor2_1
XFILLER_17_129 VGND VGND VPWR VPWR sky130_fd_sc_hd__fill_1
XPHY_EDGE_ROW_11_Left_91 VGND VGND VPWR VPWR sky130_fd_sc_hd__decap_3
XFILLER_60_419 VGND VGND VPWR VPWR sky130_fd_sc_hd__fill_1
XFILLER_40_121 VGND VGND VPWR VPWR sky130_fd_sc_hd__decap_8
XTAP_TAPCELL_ROW_23_352 VGND VPWR sky130_fd_sc_hd__tapvpwrvgnd_1
Xoutput73 net73 VGND VGND VPWR VPWR exp[7] sky130_fd_sc_hd__buf_2
Xoutput84 net84 VGND VGND VPWR VPWR mantisa[19] sky130_fd_sc_hd__buf_2
Xoutput95 net95 VGND VGND VPWR VPWR mantisa[8] sky130_fd_sc_hd__buf_2
XFILLER_0_294 VGND VGND VPWR VPWR sky130_fd_sc_hd__decap_4
Xclkbuf_leaf_28_clk clknet_2_0__leaf_clk VGND VGND VPWR VPWR clknet_leaf_28_clk sky130_fd_sc_hd__clkbuf_8
XFILLER_56_70 VGND VGND VPWR VPWR sky130_fd_sc_hd__decap_4
XFILLER_63_246 VGND VGND VPWR VPWR sky130_fd_sc_hd__decap_4
XTAP_TAPCELL_ROW_74_764 VGND VPWR sky130_fd_sc_hd__tapvpwrvgnd_1
X_3860_ clknet_leaf_6_clk net299 VGND VGND VPWR VPWR mantisaAshift\[45\] sky130_fd_sc_hd__dfxtp_1
X_2811_ _0751_ _0748_ net141 VGND VGND VPWR VPWR _0753_ sky130_fd_sc_hd__mux2_1
X_3791_ net258 _1581_ VGND VGND VPWR VPWR _1602_ sky130_fd_sc_hd__nor2_1
XFILLER_72_91 VGND VGND VPWR VPWR sky130_fd_sc_hd__fill_1
X_2742_ net131 _0683_ net111 mantisaresult\[16\] VGND VGND VPWR VPWR _0685_ sky130_fd_sc_hd__a2bb2o_1
X_2673_ mantisaresult\[2\] net111 net108 mantisaresult\[3\] VGND VGND VPWR VPWR _0616_
+ sky130_fd_sc_hd__a22o_1
X_3225_ _1098_ _1102_ _1109_ VGND VGND VPWR VPWR _1110_ sky130_fd_sc_hd__a21o_1
X_3156_ net228 _1047_ net205 VGND VGND VPWR VPWR _0149_ sky130_fd_sc_hd__mux2_1
X_2107_ net15 net7 VGND VGND VPWR VPWR _1768_ sky130_fd_sc_hd__and2b_1
Xclkbuf_leaf_19_clk clknet_2_2__leaf_clk VGND VGND VPWR VPWR clknet_leaf_19_clk sky130_fd_sc_hd__clkbuf_8
XFILLER_27_438 VGND VGND VPWR VPWR sky130_fd_sc_hd__decap_3
X_3087_ mantisaBshift\[27\] _0992_ VGND VGND VPWR VPWR _0993_ sky130_fd_sc_hd__xnor2_1
XFILLER_36_29 VGND VGND VPWR VPWR sky130_fd_sc_hd__fill_2
X_2038_ _1727_ _1728_ VGND VGND VPWR VPWR _1729_ sky130_fd_sc_hd__nand2_1
XTAP_TAPCELL_ROW_37_466 VGND VPWR sky130_fd_sc_hd__tapvpwrvgnd_1
XFILLER_50_441 VGND VGND VPWR VPWR sky130_fd_sc_hd__decap_6
XFILLER_62_290 VGND VGND VPWR VPWR sky130_fd_sc_hd__decap_6
X_3989_ clknet_leaf_26_clk net303 VGND VGND VPWR VPWR expmiddleb\[7\] sky130_fd_sc_hd__dfxtp_1
XFILLER_10_349 VPWR VGND VPWR VGND sky130_ef_sc_hd__decap_12
XTAP_TAPCELL_ROW_20_333 VGND VPWR sky130_fd_sc_hd__tapvpwrvgnd_1
XFILLER_7_6 VGND VGND VPWR VPWR sky130_fd_sc_hd__fill_1
XFILLER_77_305 VPWR VGND VPWR VGND sky130_ef_sc_hd__decap_12
XFILLER_77_349 VPWR VGND VPWR VGND sky130_ef_sc_hd__decap_12
XFILLER_45_268 VGND VGND VPWR VPWR sky130_fd_sc_hd__fill_2
XFILLER_13_132 VGND VGND VPWR VPWR sky130_fd_sc_hd__decap_4
XFILLER_13_165 VGND VGND VPWR VPWR sky130_fd_sc_hd__decap_3
XFILLER_9_169 VPWR VGND VPWR VGND sky130_ef_sc_hd__decap_12
XFILLER_5_386 VGND VGND VPWR VPWR sky130_fd_sc_hd__decap_6
XTAP_TAPCELL_ROW_79_801 VGND VPWR sky130_fd_sc_hd__tapvpwrvgnd_1
XTAP_TAPCELL_ROW_79_812 VGND VPWR sky130_fd_sc_hd__tapvpwrvgnd_1
XFILLER_3_55 VGND VGND VPWR VPWR sky130_fd_sc_hd__fill_1
XFILLER_68_305 VGND VGND VPWR VPWR sky130_fd_sc_hd__decap_3
X_3010_ net146 _0929_ _0930_ VGND VGND VPWR VPWR _0931_ sky130_fd_sc_hd__o21ai_1
XFILLER_67_80 VGND VGND VPWR VPWR sky130_fd_sc_hd__decap_6
X_3912_ clknet_leaf_29_clk _0035_ VGND VGND VPWR VPWR expmiddle\[2\] sky130_fd_sc_hd__dfxtp_1
XFILLER_32_441 VPWR VGND VPWR VGND sky130_ef_sc_hd__decap_12
XTAP_TAPCELL_ROW_34_447 VGND VPWR sky130_fd_sc_hd__tapvpwrvgnd_1
X_3843_ net258 net189 _1548_ VGND VGND VPWR VPWR _0262_ sky130_fd_sc_hd__nor3_1
X_3774_ _1589_ VGND VGND VPWR VPWR _1590_ sky130_fd_sc_hd__inv_2
X_2725_ mantisaresult\[9\] net107 _0667_ VGND VGND VPWR VPWR _0668_ sky130_fd_sc_hd__a21o_1
Xclkbuf_leaf_8_clk clknet_2_1__leaf_clk VGND VGND VPWR VPWR clknet_leaf_8_clk sky130_fd_sc_hd__clkbuf_8
X_2656_ _1623_ mantisaresult\[63\] _0583_ _1624_ VGND VGND VPWR VPWR _0599_ sky130_fd_sc_hd__a22o_1
X_2587_ _0470_ _0506_ _0528_ _0529_ VGND VGND VPWR VPWR _0530_ sky130_fd_sc_hd__or4_1
Xfanout104 net105 VGND VGND VPWR VPWR net104 sky130_fd_sc_hd__clkbuf_4
Xfanout137 _0607_ VGND VGND VPWR VPWR net137 sky130_fd_sc_hd__clkbuf_2
Xfanout115 net121 VGND VGND VPWR VPWR net115 sky130_fd_sc_hd__buf_2
Xfanout126 _0630_ VGND VGND VPWR VPWR net126 sky130_fd_sc_hd__buf_2
Xfanout159 _0555_ VGND VGND VPWR VPWR net159 sky130_fd_sc_hd__buf_2
Xfanout148 _0606_ VGND VGND VPWR VPWR net148 sky130_fd_sc_hd__clkbuf_2
X_3208_ _1089_ _1094_ VGND VGND VPWR VPWR _1095_ sky130_fd_sc_hd__xnor2_1
XFILLER_27_202 VGND VGND VPWR VPWR sky130_fd_sc_hd__decap_4
X_3139_ mantisaBshift\[37\] _1033_ VGND VGND VPWR VPWR _1034_ sky130_fd_sc_hd__xnor2_1
XFILLER_10_157 VGND VGND VPWR VPWR sky130_fd_sc_hd__fill_2
XFILLER_12_53 VGND VGND VPWR VPWR sky130_fd_sc_hd__fill_1
XFILLER_10_179 VGND VGND VPWR VPWR sky130_fd_sc_hd__fill_1
XFILLER_77_113 VPWR VGND VPWR VGND sky130_ef_sc_hd__decap_12
XFILLER_65_308 VPWR VGND VPWR VGND sky130_ef_sc_hd__decap_12
XFILLER_37_83 VGND VGND VPWR VPWR sky130_fd_sc_hd__fill_1
XFILLER_73_385 VGND VGND VPWR VPWR sky130_fd_sc_hd__decap_6
XTAP_TAPCELL_ROW_31_417 VGND VPWR sky130_fd_sc_hd__tapvpwrvgnd_1
XFILLER_53_82 VGND VGND VPWR VPWR sky130_fd_sc_hd__decap_4
X_3490_ net314 expmiddlec\[4\] net230 VGND VGND VPWR VPWR _0198_ sky130_fd_sc_hd__mux2_1
X_2510_ _0338_ _0348_ _0363_ _0377_ VGND VGND VPWR VPWR _0453_ sky130_fd_sc_hd__or4_2
XFILLER_5_161 VGND VGND VPWR VPWR sky130_fd_sc_hd__decap_6
X_2441_ _1642_ _0306_ _0341_ VGND VGND VPWR VPWR _0384_ sky130_fd_sc_hd__nor3_1
X_2372_ net224 net225 net226 net228 VGND VGND VPWR VPWR _0315_ sky130_fd_sc_hd__or4_2
X_4111_ clknet_leaf_26_clk _0218_ VGND VGND VPWR VPWR mantisaBshift\[11\] sky130_fd_sc_hd__dfxtp_1
X_4042_ clknet_leaf_15_clk _0153_ VGND VGND VPWR VPWR four_man\[49\] sky130_fd_sc_hd__dfxtp_1
XTAP_TAPCELL_ROW_47_550 VGND VPWR sky130_fd_sc_hd__tapvpwrvgnd_1
XFILLER_64_363 VGND VGND VPWR VPWR sky130_fd_sc_hd__fill_1
XPHY_EDGE_ROW_49_Left_129 VGND VGND VPWR VPWR sky130_fd_sc_hd__decap_3
X_3826_ net252 _1541_ VGND VGND VPWR VPWR _1613_ sky130_fd_sc_hd__nor2_1
X_3757_ net262 net267 _1463_ VGND VGND VPWR VPWR _1577_ sky130_fd_sc_hd__and3_1
X_2708_ _0650_ VGND VGND VPWR VPWR _0651_ sky130_fd_sc_hd__inv_2
X_3688_ _1428_ _1431_ net270 VGND VGND VPWR VPWR _1515_ sky130_fd_sc_hd__mux2_1
X_2639_ _0581_ _0554_ _0577_ VGND VGND VPWR VPWR _0582_ sky130_fd_sc_hd__mux2_1
XPHY_EDGE_ROW_58_Left_138 VGND VGND VPWR VPWR sky130_fd_sc_hd__decap_3
XFILLER_59_113 VGND VGND VPWR VPWR sky130_fd_sc_hd__fill_1
XTAP_TAPCELL_ROW_2_186 VGND VPWR sky130_fd_sc_hd__tapvpwrvgnd_1
XPHY_EDGE_ROW_67_Left_147 VGND VGND VPWR VPWR sky130_fd_sc_hd__decap_3
XFILLER_70_377 VPWR VGND VPWR VGND sky130_ef_sc_hd__decap_12
XTAP_TAPCELL_ROW_53_597 VGND VPWR sky130_fd_sc_hd__tapvpwrvgnd_1
XPHY_EDGE_ROW_76_Left_156 VGND VGND VPWR VPWR sky130_fd_sc_hd__decap_3
XFILLER_2_153 VPWR VGND VPWR VGND sky130_ef_sc_hd__decap_12
XFILLER_78_433 VPWR VGND VPWR VGND sky130_ef_sc_hd__decap_12
XFILLER_2_197 VPWR VGND VPWR VGND sky130_ef_sc_hd__decap_12
XFILLER_46_341 VPWR VGND VPWR VGND sky130_ef_sc_hd__decap_12
XTAP_TAPCELL_ROW_44_520 VGND VPWR sky130_fd_sc_hd__tapvpwrvgnd_1
XFILLER_64_70 VGND VGND VPWR VPWR sky130_fd_sc_hd__decap_4
X_2990_ mantisaresult\[11\] _0913_ net201 VGND VGND VPWR VPWR _0117_ sky130_fd_sc_hd__mux2_1
XTAP_TAPCELL_ROW_16_299 VGND VPWR sky130_fd_sc_hd__tapvpwrvgnd_1
X_1941_ mantisaresult\[19\] VGND VGND VPWR VPWR _1636_ sky130_fd_sc_hd__inv_2
X_3611_ net251 mantisaB0\[13\] net273 VGND VGND VPWR VPWR _1442_ sky130_fd_sc_hd__and3b_1
XFILLER_6_470 VGND VGND VPWR VPWR sky130_fd_sc_hd__decap_3
X_3542_ net127 _0824_ VGND VGND VPWR VPWR _1377_ sky130_fd_sc_hd__nand2_1
X_3473_ net315 expmiddlec\[0\] net231 VGND VGND VPWR VPWR _0193_ sky130_fd_sc_hd__mux2_1
X_2424_ _0331_ _0332_ _0365_ VGND VGND VPWR VPWR _0367_ sky130_fd_sc_hd__or3_1
X_2355_ mantisaresult\[63\] mantisaresult\[62\] mantisaresult\[61\] mantisaresult\[60\]
+ VGND VGND VPWR VPWR _0298_ sky130_fd_sc_hd__or4_2
X_2286_ _1912_ net293 net174 VGND VGND VPWR VPWR _0068_ sky130_fd_sc_hd__mux2_1
X_4025_ clknet_leaf_23_clk _0136_ VGND VGND VPWR VPWR mantisaresult\[28\] sky130_fd_sc_hd__dfxtp_1
X_3809_ net189 _1572_ VGND VGND VPWR VPWR _0243_ sky130_fd_sc_hd__nor2_1
XFILLER_4_418 VGND VGND VPWR VPWR sky130_fd_sc_hd__fill_2
XFILLER_75_447 VGND VGND VPWR VPWR sky130_fd_sc_hd__fill_1
XTAP_TAPCELL_ROW_58_634 VGND VPWR sky130_fd_sc_hd__tapvpwrvgnd_1
XFILLER_28_385 VGND VGND VPWR VPWR sky130_fd_sc_hd__decap_3
XFILLER_43_322 VGND VGND VPWR VPWR sky130_fd_sc_hd__fill_2
XFILLER_43_333 VGND VGND VPWR VPWR sky130_fd_sc_hd__decap_3
XTAP_TAPCELL_ROW_41_501 VGND VPWR sky130_fd_sc_hd__tapvpwrvgnd_1
XFILLER_7_223 VGND VGND VPWR VPWR sky130_fd_sc_hd__fill_1
XFILLER_7_289 VGND VGND VPWR VPWR sky130_fd_sc_hd__fill_2
XFILLER_50_83 VGND VGND VPWR VPWR sky130_fd_sc_hd__fill_1
XFILLER_22_6 VGND VGND VPWR VPWR sky130_fd_sc_hd__decap_8
X_2140_ net35 _1660_ _1661_ net34 _1800_ VGND VGND VPWR VPWR _1801_ sky130_fd_sc_hd__o221a_1
X_2071_ net212 net326 VGND VGND VPWR VPWR _0011_ sky130_fd_sc_hd__and2b_1
XFILLER_19_363 VGND VGND VPWR VPWR sky130_fd_sc_hd__fill_2
XFILLER_46_160 VGND VGND VPWR VPWR sky130_fd_sc_hd__decap_4
XFILLER_19_396 VGND VGND VPWR VPWR sky130_fd_sc_hd__decap_6
XFILLER_34_355 VGND VGND VPWR VPWR sky130_fd_sc_hd__decap_8
XFILLER_34_377 VPWR VGND VPWR VGND sky130_ef_sc_hd__decap_12
X_2973_ mantisaBshift\[4\] mantisaBshift\[5\] mantisaBshift\[6\] _0893_ VGND VGND
+ VPWR VPWR _0901_ sky130_fd_sc_hd__or4_2
XFILLER_61_163 VGND VGND VPWR VPWR sky130_fd_sc_hd__fill_1
X_3525_ _0630_ _0758_ net159 VGND VGND VPWR VPWR _1362_ sky130_fd_sc_hd__o21ai_1
X_3456_ _1310_ _1311_ _1312_ net159 VGND VGND VPWR VPWR _1313_ sky130_fd_sc_hd__o31a_1
XFILLER_39_29 VGND VGND VPWR VPWR sky130_fd_sc_hd__decap_6
XTAP_TAPCELL_ROW_4_204 VGND VPWR sky130_fd_sc_hd__tapvpwrvgnd_1
X_2407_ mantisaresult\[32\] mantisaresult\[31\] VGND VGND VPWR VPWR _0350_ sky130_fd_sc_hd__or2_1
X_3387_ _1254_ _1256_ VGND VGND VPWR VPWR _1257_ sky130_fd_sc_hd__nor2_1
X_2338_ _1915_ net30 net100 VGND VGND VPWR VPWR _0286_ sky130_fd_sc_hd__mux2_1
X_2269_ net45 net170 VGND VGND VPWR VPWR _1901_ sky130_fd_sc_hd__and2_1
X_4008_ clknet_leaf_26_clk _0119_ VGND VGND VPWR VPWR mantisaresult\[13\] sky130_fd_sc_hd__dfxtp_2
XFILLER_37_160 VGND VGND VPWR VPWR sky130_fd_sc_hd__fill_2
XFILLER_44_119 VGND VGND VPWR VPWR sky130_fd_sc_hd__fill_2
XFILLER_55_39 VGND VGND VPWR VPWR sky130_fd_sc_hd__fill_1
XTAP_TAPCELL_ROW_55_615 VGND VPWR sky130_fd_sc_hd__tapvpwrvgnd_1
XFILLER_52_141 VGND VGND VPWR VPWR sky130_fd_sc_hd__decap_6
XFILLER_25_377 VPWR VGND VPWR VGND sky130_ef_sc_hd__decap_12
XFILLER_52_163 VPWR VGND VPWR VGND sky130_ef_sc_hd__decap_12
XFILLER_0_421 VGND VGND VPWR VPWR sky130_fd_sc_hd__fill_2
Xhold40 expmiddleb\[4\] VGND VGND VPWR VPWR net314 sky130_fd_sc_hd__dlygate4sd3_1
XFILLER_75_222 VGND VGND VPWR VPWR sky130_fd_sc_hd__fill_2
Xhold73 signB0 VGND VGND VPWR VPWR net347 sky130_fd_sc_hd__dlygate4sd3_1
Xhold62 four_man\[56\] VGND VGND VPWR VPWR net336 sky130_fd_sc_hd__dlygate4sd3_1
Xhold51 four_man\[54\] VGND VGND VPWR VPWR net325 sky130_fd_sc_hd__dlygate4sd3_1
Xhold95 expmiddled\[0\] VGND VGND VPWR VPWR net369 sky130_fd_sc_hd__dlygate4sd3_1
Xhold84 mantisaB0\[21\] VGND VGND VPWR VPWR net358 sky130_fd_sc_hd__dlygate4sd3_1
XTAP_TAPCELL_ROW_18_317 VGND VPWR sky130_fd_sc_hd__tapvpwrvgnd_1
XFILLER_71_461 VPWR VGND VPWR VGND sky130_ef_sc_hd__decap_12
XFILLER_16_377 VGND VGND VPWR VPWR sky130_fd_sc_hd__fill_1
XFILLER_31_325 VGND VGND VPWR VPWR sky130_fd_sc_hd__decap_8
XTAP_TAPCELL_ROW_26_383 VGND VPWR sky130_fd_sc_hd__tapvpwrvgnd_1
XFILLER_6_77 VGND VGND VPWR VPWR sky130_fd_sc_hd__decap_6
X_3310_ net106 _0818_ _0921_ _0813_ VGND VGND VPWR VPWR _1187_ sky130_fd_sc_hd__a22o_1
X_3241_ mantisaAshift\[48\] mantisaBshift\[48\] VGND VGND VPWR VPWR _1124_ sky130_fd_sc_hd__nor2_1
XFILLER_20_3 VGND VGND VPWR VPWR sky130_fd_sc_hd__fill_1
X_3172_ _1059_ _1061_ net244 VGND VGND VPWR VPWR _1062_ sky130_fd_sc_hd__mux2_1
X_2123_ _1781_ _1783_ VGND VGND VPWR VPWR _1784_ sky130_fd_sc_hd__nor2_1
XFILLER_39_436 VPWR VGND VPWR VGND sky130_ef_sc_hd__decap_12
XTAP_TAPCELL_ROW_77_784 VGND VPWR sky130_fd_sc_hd__tapvpwrvgnd_1
XFILLER_66_288 VGND VGND VPWR VPWR sky130_fd_sc_hd__decap_8
X_2054_ expmiddled\[5\] expadd\[5\] VGND VGND VPWR VPWR _1742_ sky130_fd_sc_hd__nand2_1
XFILLER_34_141 VGND VGND VPWR VPWR sky130_fd_sc_hd__decap_6
XFILLER_34_152 VPWR VGND VPWR VGND sky130_ef_sc_hd__decap_12
XFILLER_22_303 VGND VGND VPWR VPWR sky130_fd_sc_hd__decap_4
X_2956_ _0885_ _0887_ net123 VGND VGND VPWR VPWR _0888_ sky130_fd_sc_hd__mux2_1
XTAP_TAPCELL_ROW_60_651 VGND VPWR sky130_fd_sc_hd__tapvpwrvgnd_1
X_2887_ net225 net194 net163 net217 VGND VGND VPWR VPWR _0827_ sky130_fd_sc_hd__a31o_1
X_3508_ _0628_ _0698_ net126 VGND VGND VPWR VPWR _1346_ sky130_fd_sc_hd__mux2_1
X_3439_ _0431_ _0534_ net208 VGND VGND VPWR VPWR _1304_ sky130_fd_sc_hd__o21a_2
XFILLER_66_27 VGND VGND VPWR VPWR sky130_fd_sc_hd__fill_1
XFILLER_66_38 VPWR VGND VPWR VGND sky130_ef_sc_hd__decap_12
XFILLER_45_439 VGND VGND VPWR VPWR sky130_fd_sc_hd__fill_1
XFILLER_40_100 VGND VGND VPWR VPWR sky130_fd_sc_hd__fill_2
XFILLER_15_64 VGND VGND VPWR VPWR sky130_fd_sc_hd__decap_4
XFILLER_15_53 VGND VGND VPWR VPWR sky130_fd_sc_hd__decap_3
XFILLER_15_86 VGND VGND VPWR VPWR sky130_fd_sc_hd__fill_2
XTAP_TAPCELL_ROW_23_353 VGND VPWR sky130_fd_sc_hd__tapvpwrvgnd_1
Xoutput85 net85 VGND VGND VPWR VPWR mantisa[1] sky130_fd_sc_hd__buf_2
Xoutput74 net74 VGND VGND VPWR VPWR mantisa[0] sky130_fd_sc_hd__buf_2
Xoutput96 net96 VGND VGND VPWR VPWR mantisa[9] sky130_fd_sc_hd__buf_2
XFILLER_63_225 VGND VGND VPWR VPWR sky130_fd_sc_hd__decap_4
XFILLER_44_450 VPWR VGND VPWR VGND sky130_ef_sc_hd__decap_12
XTAP_TAPCELL_ROW_74_765 VGND VPWR sky130_fd_sc_hd__tapvpwrvgnd_1
XFILLER_16_163 VGND VGND VPWR VPWR sky130_fd_sc_hd__fill_1
X_2810_ _0751_ VGND VGND VPWR VPWR _0752_ sky130_fd_sc_hd__inv_2
XFILLER_31_166 VGND VGND VPWR VPWR sky130_fd_sc_hd__fill_2
X_3790_ _1502_ _1579_ _1601_ _1418_ VGND VGND VPWR VPWR _0229_ sky130_fd_sc_hd__a2bb2o_1
XFILLER_12_380 VGND VGND VPWR VPWR sky130_fd_sc_hd__fill_1
X_2741_ _0683_ VGND VGND VPWR VPWR _0684_ sky130_fd_sc_hd__inv_2
XFILLER_8_340 VGND VGND VPWR VPWR sky130_fd_sc_hd__decap_6
X_2672_ _0610_ net131 VGND VGND VPWR VPWR _0615_ sky130_fd_sc_hd__nor2_1
XFILLER_39_200 VGND VGND VPWR VPWR sky130_fd_sc_hd__fill_2
X_3224_ mantisaBshift\[45\] mantisaAshift\[45\] VGND VGND VPWR VPWR _1109_ sky130_fd_sc_hd__and2b_1
.ends
